* NGSPICE file created from rns_top_crt.ext - technology: sky130A

* Black-box entry subcircuit for sky130_fd_sc_hd__diode_2 abstract view
.subckt sky130_fd_sc_hd__diode_2 DIODE VGND VNB VPB VPWR
.ends

* Black-box entry subcircuit for sky130_fd_sc_hd__decap_6 abstract view
.subckt sky130_fd_sc_hd__decap_6 VGND VNB VPB VPWR
.ends

* Black-box entry subcircuit for sky130_fd_sc_hd__fill_2 abstract view
.subckt sky130_fd_sc_hd__fill_2 VGND VNB VPB VPWR
.ends

* Black-box entry subcircuit for sky130_fd_sc_hd__tapvpwrvgnd_1 abstract view
.subckt sky130_fd_sc_hd__tapvpwrvgnd_1 VGND VPWR
.ends

* Black-box entry subcircuit for sky130_fd_sc_hd__fill_1 abstract view
.subckt sky130_fd_sc_hd__fill_1 VGND VNB VPB VPWR
.ends

* Black-box entry subcircuit for sky130_ef_sc_hd__decap_12 abstract view
.subckt sky130_ef_sc_hd__decap_12 VPWR VGND VPB VNB
.ends

* Black-box entry subcircuit for sky130_fd_sc_hd__a31o_1 abstract view
.subckt sky130_fd_sc_hd__a31o_1 A1 A2 A3 B1 VGND VNB VPB VPWR X
.ends

* Black-box entry subcircuit for sky130_fd_sc_hd__a21oi_1 abstract view
.subckt sky130_fd_sc_hd__a21oi_1 A1 A2 B1 VGND VNB VPB VPWR Y
.ends

* Black-box entry subcircuit for sky130_fd_sc_hd__and2_1 abstract view
.subckt sky130_fd_sc_hd__and2_1 A B VGND VNB VPB VPWR X
.ends

* Black-box entry subcircuit for sky130_fd_sc_hd__nand2_1 abstract view
.subckt sky130_fd_sc_hd__nand2_1 A B VGND VNB VPB VPWR Y
.ends

* Black-box entry subcircuit for sky130_fd_sc_hd__decap_8 abstract view
.subckt sky130_fd_sc_hd__decap_8 VGND VNB VPB VPWR
.ends

* Black-box entry subcircuit for sky130_fd_sc_hd__decap_4 abstract view
.subckt sky130_fd_sc_hd__decap_4 VGND VNB VPB VPWR
.ends

* Black-box entry subcircuit for sky130_fd_sc_hd__xnor2_1 abstract view
.subckt sky130_fd_sc_hd__xnor2_1 A B VGND VNB VPB VPWR Y
.ends

* Black-box entry subcircuit for sky130_fd_sc_hd__xor2_1 abstract view
.subckt sky130_fd_sc_hd__xor2_1 A B VGND VNB VPB VPWR X
.ends

* Black-box entry subcircuit for sky130_fd_sc_hd__inv_2 abstract view
.subckt sky130_fd_sc_hd__inv_2 A VGND VNB VPB VPWR Y
.ends

* Black-box entry subcircuit for sky130_fd_sc_hd__a21oi_2 abstract view
.subckt sky130_fd_sc_hd__a21oi_2 A1 A2 B1 VGND VNB VPB VPWR Y
.ends

* Black-box entry subcircuit for sky130_fd_sc_hd__nor2_1 abstract view
.subckt sky130_fd_sc_hd__nor2_1 A B VGND VNB VPB VPWR Y
.ends

* Black-box entry subcircuit for sky130_fd_sc_hd__mux2_1 abstract view
.subckt sky130_fd_sc_hd__mux2_1 A0 A1 S VGND VNB VPB VPWR X
.ends

* Black-box entry subcircuit for sky130_fd_sc_hd__a21o_1 abstract view
.subckt sky130_fd_sc_hd__a21o_1 A1 A2 B1 VGND VNB VPB VPWR X
.ends

* Black-box entry subcircuit for sky130_fd_sc_hd__a32o_1 abstract view
.subckt sky130_fd_sc_hd__a32o_1 A1 A2 A3 B1 B2 VGND VNB VPB VPWR X
.ends

* Black-box entry subcircuit for sky130_fd_sc_hd__decap_3 abstract view
.subckt sky130_fd_sc_hd__decap_3 VGND VNB VPB VPWR
.ends

* Black-box entry subcircuit for sky130_fd_sc_hd__or3_1 abstract view
.subckt sky130_fd_sc_hd__or3_1 A B C VGND VNB VPB VPWR X
.ends

* Black-box entry subcircuit for sky130_fd_sc_hd__o22ai_2 abstract view
.subckt sky130_fd_sc_hd__o22ai_2 A1 A2 B1 B2 VGND VNB VPB VPWR Y
.ends

* Black-box entry subcircuit for sky130_fd_sc_hd__and3_1 abstract view
.subckt sky130_fd_sc_hd__and3_1 A B C VGND VNB VPB VPWR X
.ends

* Black-box entry subcircuit for sky130_fd_sc_hd__dfrtp_1 abstract view
.subckt sky130_fd_sc_hd__dfrtp_1 CLK D RESET_B VGND VNB VPB VPWR Q
.ends

* Black-box entry subcircuit for sky130_fd_sc_hd__o21ai_1 abstract view
.subckt sky130_fd_sc_hd__o21ai_1 A1 A2 B1 VGND VNB VPB VPWR Y
.ends

* Black-box entry subcircuit for sky130_fd_sc_hd__o21bai_4 abstract view
.subckt sky130_fd_sc_hd__o21bai_4 A1 A2 B1_N VGND VNB VPB VPWR Y
.ends

* Black-box entry subcircuit for sky130_fd_sc_hd__buf_1 abstract view
.subckt sky130_fd_sc_hd__buf_1 A VGND VNB VPB VPWR X
.ends

* Black-box entry subcircuit for sky130_fd_sc_hd__o21a_1 abstract view
.subckt sky130_fd_sc_hd__o21a_1 A1 A2 B1 VGND VNB VPB VPWR X
.ends

* Black-box entry subcircuit for sky130_fd_sc_hd__a22o_1 abstract view
.subckt sky130_fd_sc_hd__a22o_1 A1 A2 B1 B2 VGND VNB VPB VPWR X
.ends

* Black-box entry subcircuit for sky130_fd_sc_hd__nand2b_1 abstract view
.subckt sky130_fd_sc_hd__nand2b_1 A_N B VGND VNB VPB VPWR Y
.ends

* Black-box entry subcircuit for sky130_fd_sc_hd__or2_1 abstract view
.subckt sky130_fd_sc_hd__or2_1 A B VGND VNB VPB VPWR X
.ends

* Black-box entry subcircuit for sky130_fd_sc_hd__clkbuf_16 abstract view
.subckt sky130_fd_sc_hd__clkbuf_16 A VGND VNB VPB VPWR X
.ends

* Black-box entry subcircuit for sky130_fd_sc_hd__o2bb2a_1 abstract view
.subckt sky130_fd_sc_hd__o2bb2a_1 A1_N A2_N B1 B2 VGND VNB VPB VPWR X
.ends

* Black-box entry subcircuit for sky130_fd_sc_hd__nand3_1 abstract view
.subckt sky130_fd_sc_hd__nand3_1 A B C VGND VNB VPB VPWR Y
.ends

* Black-box entry subcircuit for sky130_fd_sc_hd__nor3b_1 abstract view
.subckt sky130_fd_sc_hd__nor3b_1 A B C_N VGND VNB VPB VPWR Y
.ends

* Black-box entry subcircuit for sky130_fd_sc_hd__a21bo_1 abstract view
.subckt sky130_fd_sc_hd__a21bo_1 A1 A2 B1_N VGND VNB VPB VPWR X
.ends

* Black-box entry subcircuit for sky130_fd_sc_hd__o211ai_1 abstract view
.subckt sky130_fd_sc_hd__o211ai_1 A1 A2 B1 C1 VGND VNB VPB VPWR Y
.ends

* Black-box entry subcircuit for sky130_fd_sc_hd__a311o_1 abstract view
.subckt sky130_fd_sc_hd__a311o_1 A1 A2 A3 B1 C1 VGND VNB VPB VPWR X
.ends

* Black-box entry subcircuit for sky130_fd_sc_hd__o211a_1 abstract view
.subckt sky130_fd_sc_hd__o211a_1 A1 A2 B1 C1 VGND VNB VPB VPWR X
.ends

* Black-box entry subcircuit for sky130_fd_sc_hd__and3b_1 abstract view
.subckt sky130_fd_sc_hd__and3b_1 A_N B C VGND VNB VPB VPWR X
.ends

* Black-box entry subcircuit for sky130_fd_sc_hd__dfrtp_4 abstract view
.subckt sky130_fd_sc_hd__dfrtp_4 CLK D RESET_B VGND VNB VPB VPWR Q
.ends

* Black-box entry subcircuit for sky130_fd_sc_hd__dfrtp_2 abstract view
.subckt sky130_fd_sc_hd__dfrtp_2 CLK D RESET_B VGND VNB VPB VPWR Q
.ends

* Black-box entry subcircuit for sky130_fd_sc_hd__and2b_1 abstract view
.subckt sky130_fd_sc_hd__and2b_1 A_N B VGND VNB VPB VPWR X
.ends

* Black-box entry subcircuit for sky130_fd_sc_hd__o21ba_1 abstract view
.subckt sky130_fd_sc_hd__o21ba_1 A1 A2 B1_N VGND VNB VPB VPWR X
.ends

* Black-box entry subcircuit for sky130_fd_sc_hd__o21a_2 abstract view
.subckt sky130_fd_sc_hd__o21a_2 A1 A2 B1 VGND VNB VPB VPWR X
.ends

* Black-box entry subcircuit for sky130_fd_sc_hd__a21boi_1 abstract view
.subckt sky130_fd_sc_hd__a21boi_1 A1 A2 B1_N VGND VNB VPB VPWR Y
.ends

* Black-box entry subcircuit for sky130_fd_sc_hd__nand2_2 abstract view
.subckt sky130_fd_sc_hd__nand2_2 A B VGND VNB VPB VPWR Y
.ends

* Black-box entry subcircuit for sky130_fd_sc_hd__and4_1 abstract view
.subckt sky130_fd_sc_hd__and4_1 A B C D VGND VNB VPB VPWR X
.ends

* Black-box entry subcircuit for sky130_fd_sc_hd__o22a_1 abstract view
.subckt sky130_fd_sc_hd__o22a_1 A1 A2 B1 B2 VGND VNB VPB VPWR X
.ends

* Black-box entry subcircuit for sky130_fd_sc_hd__xor2_2 abstract view
.subckt sky130_fd_sc_hd__xor2_2 A B VGND VNB VPB VPWR X
.ends

* Black-box entry subcircuit for sky130_fd_sc_hd__a2bb2o_1 abstract view
.subckt sky130_fd_sc_hd__a2bb2o_1 A1_N A2_N B1 B2 VGND VNB VPB VPWR X
.ends

* Black-box entry subcircuit for sky130_fd_sc_hd__xnor2_2 abstract view
.subckt sky130_fd_sc_hd__xnor2_2 A B VGND VNB VPB VPWR Y
.ends

* Black-box entry subcircuit for sky130_fd_sc_hd__nand2b_4 abstract view
.subckt sky130_fd_sc_hd__nand2b_4 A_N B VGND VNB VPB VPWR Y
.ends

* Black-box entry subcircuit for sky130_fd_sc_hd__o31a_1 abstract view
.subckt sky130_fd_sc_hd__o31a_1 A1 A2 A3 B1 VGND VNB VPB VPWR X
.ends

* Black-box entry subcircuit for sky130_fd_sc_hd__o21ai_2 abstract view
.subckt sky130_fd_sc_hd__o21ai_2 A1 A2 B1 VGND VNB VPB VPWR Y
.ends

* Black-box entry subcircuit for sky130_fd_sc_hd__inv_8 abstract view
.subckt sky130_fd_sc_hd__inv_8 A VGND VNB VPB VPWR Y
.ends

* Black-box entry subcircuit for sky130_fd_sc_hd__or3_4 abstract view
.subckt sky130_fd_sc_hd__or3_4 A B C VGND VNB VPB VPWR X
.ends

* Black-box entry subcircuit for sky130_fd_sc_hd__a211oi_1 abstract view
.subckt sky130_fd_sc_hd__a211oi_1 A1 A2 B1 C1 VGND VNB VPB VPWR Y
.ends

* Black-box entry subcircuit for sky130_fd_sc_hd__a211o_1 abstract view
.subckt sky130_fd_sc_hd__a211o_1 A1 A2 B1 C1 VGND VNB VPB VPWR X
.ends

* Black-box entry subcircuit for sky130_fd_sc_hd__or3b_1 abstract view
.subckt sky130_fd_sc_hd__or3b_1 A B C_N VGND VNB VPB VPWR X
.ends

* Black-box entry subcircuit for sky130_fd_sc_hd__inv_12 abstract view
.subckt sky130_fd_sc_hd__inv_12 A VGND VNB VPB VPWR Y
.ends

* Black-box entry subcircuit for sky130_fd_sc_hd__o2bb2ai_1 abstract view
.subckt sky130_fd_sc_hd__o2bb2ai_1 A1_N A2_N B1 B2 VGND VNB VPB VPWR Y
.ends

* Black-box entry subcircuit for sky130_fd_sc_hd__clkinvlp_4 abstract view
.subckt sky130_fd_sc_hd__clkinvlp_4 A VGND VNB VPB VPWR Y
.ends

* Black-box entry subcircuit for sky130_fd_sc_hd__or3_2 abstract view
.subckt sky130_fd_sc_hd__or3_2 A B C VGND VNB VPB VPWR X
.ends

* Black-box entry subcircuit for sky130_fd_sc_hd__a2bb2o_2 abstract view
.subckt sky130_fd_sc_hd__a2bb2o_2 A1_N A2_N B1 B2 VGND VNB VPB VPWR X
.ends

* Black-box entry subcircuit for sky130_fd_sc_hd__o311a_1 abstract view
.subckt sky130_fd_sc_hd__o311a_1 A1 A2 A3 B1 C1 VGND VNB VPB VPWR X
.ends

* Black-box entry subcircuit for sky130_fd_sc_hd__o32a_1 abstract view
.subckt sky130_fd_sc_hd__o32a_1 A1 A2 A3 B1 B2 VGND VNB VPB VPWR X
.ends

* Black-box entry subcircuit for sky130_fd_sc_hd__clkinv_4 abstract view
.subckt sky130_fd_sc_hd__clkinv_4 A VGND VNB VPB VPWR Y
.ends

* Black-box entry subcircuit for sky130_fd_sc_hd__or4b_1 abstract view
.subckt sky130_fd_sc_hd__or4b_1 A B C D_N VGND VNB VPB VPWR X
.ends

* Black-box entry subcircuit for sky130_fd_sc_hd__a41o_1 abstract view
.subckt sky130_fd_sc_hd__a41o_1 A1 A2 A3 A4 B1 VGND VNB VPB VPWR X
.ends

* Black-box entry subcircuit for sky130_fd_sc_hd__and2b_4 abstract view
.subckt sky130_fd_sc_hd__and2b_4 A_N B VGND VNB VPB VPWR X
.ends

* Black-box entry subcircuit for sky130_fd_sc_hd__a221o_1 abstract view
.subckt sky130_fd_sc_hd__a221o_1 A1 A2 B1 B2 C1 VGND VNB VPB VPWR X
.ends

* Black-box entry subcircuit for sky130_fd_sc_hd__o221a_1 abstract view
.subckt sky130_fd_sc_hd__o221a_1 A1 A2 B1 B2 C1 VGND VNB VPB VPWR X
.ends

* Black-box entry subcircuit for sky130_fd_sc_hd__clkbuf_1 abstract view
.subckt sky130_fd_sc_hd__clkbuf_1 A VGND VNB VPB VPWR X
.ends

* Black-box entry subcircuit for sky130_fd_sc_hd__a22oi_1 abstract view
.subckt sky130_fd_sc_hd__a22oi_1 A1 A2 B1 B2 VGND VNB VPB VPWR Y
.ends

* Black-box entry subcircuit for sky130_fd_sc_hd__or2_4 abstract view
.subckt sky130_fd_sc_hd__or2_4 A B VGND VNB VPB VPWR X
.ends

* Black-box entry subcircuit for sky130_fd_sc_hd__o31ai_2 abstract view
.subckt sky130_fd_sc_hd__o31ai_2 A1 A2 A3 B1 VGND VNB VPB VPWR Y
.ends

* Black-box entry subcircuit for sky130_fd_sc_hd__a31oi_1 abstract view
.subckt sky130_fd_sc_hd__a31oi_1 A1 A2 A3 B1 VGND VNB VPB VPWR Y
.ends

* Black-box entry subcircuit for sky130_fd_sc_hd__o2111a_1 abstract view
.subckt sky130_fd_sc_hd__o2111a_1 A1 A2 B1 C1 D1 VGND VNB VPB VPWR X
.ends

* Black-box entry subcircuit for sky130_fd_sc_hd__nor2_4 abstract view
.subckt sky130_fd_sc_hd__nor2_4 A B VGND VNB VPB VPWR Y
.ends

* Black-box entry subcircuit for sky130_fd_sc_hd__o21bai_2 abstract view
.subckt sky130_fd_sc_hd__o21bai_2 A1 A2 B1_N VGND VNB VPB VPWR Y
.ends

* Black-box entry subcircuit for sky130_fd_sc_hd__or3b_4 abstract view
.subckt sky130_fd_sc_hd__or3b_4 A B C_N VGND VNB VPB VPWR X
.ends

* Black-box entry subcircuit for sky130_fd_sc_hd__nor3_1 abstract view
.subckt sky130_fd_sc_hd__nor3_1 A B C VGND VNB VPB VPWR Y
.ends

* Black-box entry subcircuit for sky130_fd_sc_hd__a21oi_4 abstract view
.subckt sky130_fd_sc_hd__a21oi_4 A1 A2 B1 VGND VNB VPB VPWR Y
.ends

* Black-box entry subcircuit for sky130_fd_sc_hd__o211ai_2 abstract view
.subckt sky130_fd_sc_hd__o211ai_2 A1 A2 B1 C1 VGND VNB VPB VPWR Y
.ends

* Black-box entry subcircuit for sky130_fd_sc_hd__inv_6 abstract view
.subckt sky130_fd_sc_hd__inv_6 A VGND VNB VPB VPWR Y
.ends

* Black-box entry subcircuit for sky130_fd_sc_hd__and4b_1 abstract view
.subckt sky130_fd_sc_hd__and4b_1 A_N B C D VGND VNB VPB VPWR X
.ends

* Black-box entry subcircuit for sky130_fd_sc_hd__nor2_2 abstract view
.subckt sky130_fd_sc_hd__nor2_2 A B VGND VNB VPB VPWR Y
.ends

* Black-box entry subcircuit for sky130_fd_sc_hd__o22ai_1 abstract view
.subckt sky130_fd_sc_hd__o22ai_1 A1 A2 B1 B2 VGND VNB VPB VPWR Y
.ends

* Black-box entry subcircuit for sky130_fd_sc_hd__a31oi_4 abstract view
.subckt sky130_fd_sc_hd__a31oi_4 A1 A2 A3 B1 VGND VNB VPB VPWR Y
.ends

* Black-box entry subcircuit for sky130_fd_sc_hd__or4bb_1 abstract view
.subckt sky130_fd_sc_hd__or4bb_1 A B C_N D_N VGND VNB VPB VPWR X
.ends

* Black-box entry subcircuit for sky130_fd_sc_hd__dlymetal6s2s_1 abstract view
.subckt sky130_fd_sc_hd__dlymetal6s2s_1 A VGND VNB VPB VPWR X
.ends

* Black-box entry subcircuit for sky130_fd_sc_hd__xor2_4 abstract view
.subckt sky130_fd_sc_hd__xor2_4 A B VGND VNB VPB VPWR X
.ends

* Black-box entry subcircuit for sky130_fd_sc_hd__nand2_4 abstract view
.subckt sky130_fd_sc_hd__nand2_4 A B VGND VNB VPB VPWR Y
.ends

* Black-box entry subcircuit for sky130_fd_sc_hd__o31ai_1 abstract view
.subckt sky130_fd_sc_hd__o31ai_1 A1 A2 A3 B1 VGND VNB VPB VPWR Y
.ends

* Black-box entry subcircuit for sky130_fd_sc_hd__or2_2 abstract view
.subckt sky130_fd_sc_hd__or2_2 A B VGND VNB VPB VPWR X
.ends

* Black-box entry subcircuit for sky130_fd_sc_hd__nand3_2 abstract view
.subckt sky130_fd_sc_hd__nand3_2 A B C VGND VNB VPB VPWR Y
.ends

* Black-box entry subcircuit for sky130_fd_sc_hd__nand4_2 abstract view
.subckt sky130_fd_sc_hd__nand4_2 A B C D VGND VNB VPB VPWR Y
.ends

* Black-box entry subcircuit for sky130_fd_sc_hd__a22oi_2 abstract view
.subckt sky130_fd_sc_hd__a22oi_2 A1 A2 B1 B2 VGND VNB VPB VPWR Y
.ends

* Black-box entry subcircuit for sky130_fd_sc_hd__o21bai_1 abstract view
.subckt sky130_fd_sc_hd__o21bai_1 A1 A2 B1_N VGND VNB VPB VPWR Y
.ends

* Black-box entry subcircuit for sky130_fd_sc_hd__nand4_1 abstract view
.subckt sky130_fd_sc_hd__nand4_1 A B C D VGND VNB VPB VPWR Y
.ends

* Black-box entry subcircuit for sky130_fd_sc_hd__a311oi_1 abstract view
.subckt sky130_fd_sc_hd__a311oi_1 A1 A2 A3 B1 C1 VGND VNB VPB VPWR Y
.ends

* Black-box entry subcircuit for sky130_fd_sc_hd__and3b_4 abstract view
.subckt sky130_fd_sc_hd__and3b_4 A_N B C VGND VNB VPB VPWR X
.ends

* Black-box entry subcircuit for sky130_fd_sc_hd__or4_1 abstract view
.subckt sky130_fd_sc_hd__or4_1 A B C D VGND VNB VPB VPWR X
.ends

* Black-box entry subcircuit for sky130_fd_sc_hd__a31oi_2 abstract view
.subckt sky130_fd_sc_hd__a31oi_2 A1 A2 A3 B1 VGND VNB VPB VPWR Y
.ends

* Black-box entry subcircuit for sky130_fd_sc_hd__nor4_1 abstract view
.subckt sky130_fd_sc_hd__nor4_1 A B C D VGND VNB VPB VPWR Y
.ends

* Black-box entry subcircuit for sky130_fd_sc_hd__a221oi_4 abstract view
.subckt sky130_fd_sc_hd__a221oi_4 A1 A2 B1 B2 C1 VGND VNB VPB VPWR Y
.ends

.subckt rns_top_crt A_in[0] A_in[10] A_in[11] A_in[12] A_in[13] A_in[14] A_in[15]
+ A_in[1] A_in[2] A_in[3] A_in[4] A_in[5] A_in[6] A_in[7] A_in[8] A_in[9] B_in[0]
+ B_in[10] B_in[11] B_in[12] B_in[13] B_in[14] B_in[15] B_in[1] B_in[2] B_in[3] B_in[4]
+ B_in[5] B_in[6] B_in[7] B_in[8] B_in[9] Done Op_Sel[0] Op_Sel[1] Start VGND VPWR
+ X_out[0] X_out[10] X_out[11] X_out[12] X_out[13] X_out[14] X_out[15] X_out[1] X_out[2]
+ X_out[3] X_out[4] X_out[5] X_out[6] X_out[7] X_out[8] X_out[9] clk rst_n
XANTENNA__2439__B _0187_ VGND VGND VPWR VPWR sky130_fd_sc_hd__diode_2
XFILLER_67_553 VGND VGND VPWR VPWR sky130_fd_sc_hd__decap_6
XFILLER_39_233 VGND VGND VPWR VPWR sky130_fd_sc_hd__fill_2
XTAP_TAPCELL_ROW_124_2311 VGND VPWR sky130_fd_sc_hd__tapvpwrvgnd_1
XFILLER_95_895 VGND VGND VPWR VPWR sky130_fd_sc_hd__fill_1
XFILLER_82_501 VPWR VGND VPWR VGND sky130_ef_sc_hd__decap_12
X_3155_ _0801_ _0805_ _0827_ _0809_ VGND VGND VPWR VPWR _0843_ sky130_fd_sc_hd__a31o_1
XTAP_TAPCELL_ROW_124_2322 VGND VPWR sky130_fd_sc_hd__tapvpwrvgnd_1
X_2106_ _1357_ _1362_ B_reg\[11\] VGND VGND VPWR VPWR _1365_ sky130_fd_sc_hd__a21oi_1
XTAP_TAPCELL_ROW_38_935 VGND VPWR sky130_fd_sc_hd__tapvpwrvgnd_1
XTAP_TAPCELL_ROW_38_946 VGND VPWR sky130_fd_sc_hd__tapvpwrvgnd_1
X_3086_ _0754_ _0756_ VGND VGND VPWR VPWR _0774_ sky130_fd_sc_hd__and2_1
X_2037_ _1292_ _1298_ B_reg\[7\] VGND VGND VPWR VPWR _1299_ sky130_fd_sc_hd__a21oi_1
XFILLER_82_589 VPWR VGND VPWR VGND sky130_ef_sc_hd__decap_12
XFILLER_35_461 VPWR VGND VPWR VGND sky130_ef_sc_hd__decap_12
XFILLER_52_29 VPWR VGND VPWR VGND sky130_ef_sc_hd__decap_12
XFILLER_22_133 VGND VGND VPWR VPWR sky130_fd_sc_hd__decap_6
XTAP_TAPCELL_ROW_102_1963 VGND VPWR sky130_fd_sc_hd__tapvpwrvgnd_1
XFILLER_50_475 VGND VGND VPWR VPWR sky130_fd_sc_hd__fill_1
XFILLER_149_853 VPWR VGND VPWR VGND sky130_ef_sc_hd__decap_12
X_2939_ _0620_ _0626_ VGND VGND VPWR VPWR _0627_ sky130_fd_sc_hd__nand2_1
XFILLER_22_177 VPWR VGND VPWR VGND sky130_ef_sc_hd__decap_12
XFILLER_149_897 VPWR VGND VPWR VGND sky130_ef_sc_hd__decap_12
XFILLER_148_363 VGND VGND VPWR VPWR sky130_fd_sc_hd__fill_1
XFILLER_136_525 VGND VGND VPWR VPWR sky130_fd_sc_hd__decap_6
XTAP_TAPCELL_ROW_135_2484 VGND VPWR sky130_fd_sc_hd__tapvpwrvgnd_1
XFILLER_151_517 VPWR VGND VPWR VGND sky130_ef_sc_hd__decap_12
XFILLER_136_569 VPWR VGND VPWR VGND sky130_ef_sc_hd__decap_12
XTAP_TAPCELL_ROW_135_2495 VGND VPWR sky130_fd_sc_hd__tapvpwrvgnd_1
XFILLER_117_783 VGND VGND VPWR VPWR sky130_fd_sc_hd__fill_1
XFILLER_104_411 VGND VGND VPWR VPWR sky130_fd_sc_hd__decap_8
XFILLER_2_538 VPWR VGND VPWR VGND sky130_ef_sc_hd__decap_12
XFILLER_117_55 VGND VGND VPWR VPWR sky130_fd_sc_hd__fill_1
XFILLER_104_433 VPWR VGND VPWR VGND sky130_ef_sc_hd__decap_12
XFILLER_77_37 VGND VGND VPWR VPWR sky130_fd_sc_hd__fill_1
XFILLER_104_488 VPWR VGND VPWR VGND sky130_ef_sc_hd__decap_12
XFILLER_77_48 VGND VGND VPWR VPWR sky130_fd_sc_hd__decap_8
XFILLER_58_531 VGND VGND VPWR VPWR sky130_fd_sc_hd__fill_1
XFILLER_92_309 VPWR VGND VPWR VGND sky130_ef_sc_hd__decap_12
XFILLER_85_361 VPWR VGND VPWR VGND sky130_ef_sc_hd__decap_12
XFILLER_58_586 VGND VGND VPWR VPWR sky130_fd_sc_hd__fill_2
XFILLER_46_737 VPWR VGND VPWR VGND sky130_ef_sc_hd__decap_12
XFILLER_18_439 VPWR VGND VPWR VGND sky130_ef_sc_hd__decap_12
XFILLER_93_69 VPWR VGND VPWR VGND sky130_ef_sc_hd__decap_12
XANTENNA__3301__RESET_B net36 VGND VGND VPWR VPWR sky130_fd_sc_hd__diode_2
XANTENNA__3282__CLK clknet_3_1__leaf_clk VGND VGND VPWR VPWR sky130_fd_sc_hd__diode_2
XFILLER_26_41 VPWR VGND VPWR VGND sky130_ef_sc_hd__decap_12
XFILLER_61_729 VPWR VGND VPWR VGND sky130_ef_sc_hd__decap_12
XFILLER_54_792 VPWR VGND VPWR VGND sky130_ef_sc_hd__decap_12
XFILLER_14_601 VPWR VGND VPWR VGND sky130_ef_sc_hd__decap_12
XANTENNA__2642__A0 net33 VGND VGND VPWR VPWR sky130_fd_sc_hd__diode_2
XFILLER_13_111 VGND VGND VPWR VPWR sky130_fd_sc_hd__fill_1
XFILLER_14_645 VPWR VGND VPWR VGND sky130_ef_sc_hd__decap_12
XFILLER_26_85 VPWR VGND VPWR VGND sky130_ef_sc_hd__decap_12
XFILLER_9_137 VPWR VGND VPWR VGND sky130_ef_sc_hd__decap_12
XFILLER_41_497 VGND VGND VPWR VPWR sky130_fd_sc_hd__decap_6
XFILLER_139_385 VGND VGND VPWR VPWR sky130_fd_sc_hd__decap_6
XFILLER_127_503 VGND VGND VPWR VPWR sky130_fd_sc_hd__fill_1
XFILLER_6_811 VGND VGND VPWR VPWR sky130_fd_sc_hd__fill_1
XFILLER_115_709 VPWR VGND VPWR VGND sky130_ef_sc_hd__decap_12
XFILLER_5_365 VGND VGND VPWR VPWR sky130_fd_sc_hd__decap_6
XTAP_TAPCELL_ROW_75_1531 VGND VPWR sky130_fd_sc_hd__tapvpwrvgnd_1
XFILLER_123_753 VPWR VGND VPWR VGND sky130_ef_sc_hd__decap_12
XFILLER_107_293 VPWR VGND VPWR VGND sky130_ef_sc_hd__decap_12
XFILLER_123_797 VPWR VGND VPWR VGND sky130_ef_sc_hd__decap_12
XFILLER_96_637 VGND VGND VPWR VPWR sky130_fd_sc_hd__decap_6
XFILLER_95_125 VPWR VGND VPWR VGND sky130_ef_sc_hd__decap_12
XFILLER_95_169 VGND VGND VPWR VPWR sky130_fd_sc_hd__decap_4
XFILLER_49_553 VGND VGND VPWR VPWR sky130_fd_sc_hd__decap_6
XTAP_TAPCELL_ROW_106_2030 VGND VPWR sky130_fd_sc_hd__tapvpwrvgnd_1
XFILLER_77_895 VGND VGND VPWR VPWR sky130_fd_sc_hd__fill_1
XFILLER_49_586 VPWR VGND VPWR VGND sky130_ef_sc_hd__decap_12
XANTENNA__2275__A A_reg\[1\] VGND VGND VPWR VPWR sky130_fd_sc_hd__diode_2
XFILLER_24_409 VGND VGND VPWR VPWR sky130_fd_sc_hd__decap_8
XFILLER_91_375 VPWR VGND VPWR VGND sky130_ef_sc_hd__decap_12
XFILLER_64_589 VPWR VGND VPWR VGND sky130_ef_sc_hd__decap_12
XFILLER_17_461 VPWR VGND VPWR VGND sky130_ef_sc_hd__decap_12
XFILLER_149_105 VGND VGND VPWR VPWR sky130_fd_sc_hd__decap_6
XFILLER_32_475 VGND VGND VPWR VPWR sky130_fd_sc_hd__fill_1
XFILLER_149_149 VPWR VGND VPWR VGND sky130_ef_sc_hd__decap_12
XFILLER_20_637 VGND VGND VPWR VPWR sky130_fd_sc_hd__decap_6
XFILLER_9_671 VGND VGND VPWR VPWR sky130_fd_sc_hd__fill_1
XFILLER_146_867 VGND VGND VPWR VPWR sky130_fd_sc_hd__fill_1
XFILLER_118_525 VGND VGND VPWR VPWR sky130_fd_sc_hd__decap_6
X_2724_ _0422_ _0437_ VGND VGND VPWR VPWR _0464_ sky130_fd_sc_hd__xnor2_1
XFILLER_133_517 VPWR VGND VPWR VGND sky130_ef_sc_hd__decap_12
XFILLER_118_569 VPWR VGND VPWR VGND sky130_ef_sc_hd__decap_12
X_2655_ a_r3\[3\] _0393_ VGND VGND VPWR VPWR _0395_ sky130_fd_sc_hd__xor2_1
X_1606_ A_reg\[0\] VGND VGND VPWR VPWR _0886_ sky130_fd_sc_hd__inv_2
X_2586_ a_r2\[0\] a_r2\[1\] VGND VGND VPWR VPWR _0331_ sky130_fd_sc_hd__nand2_1
XFILLER_141_561 VPWR VGND VPWR VGND sky130_ef_sc_hd__decap_12
XFILLER_86_136 VGND VGND VPWR VPWR sky130_fd_sc_hd__decap_4
XFILLER_74_309 VPWR VGND VPWR VGND sky130_ef_sc_hd__decap_12
X_3207_ X_crt\[11\] _0912_ VGND VGND VPWR VPWR _0100_ sky130_fd_sc_hd__and2_1
XFILLER_83_821 VPWR VGND VPWR VGND sky130_ef_sc_hd__decap_12
X_3138_ _0773_ _0822_ _0823_ VGND VGND VPWR VPWR _0826_ sky130_fd_sc_hd__a21oi_2
XFILLER_27_225 VGND VGND VPWR VPWR sky130_fd_sc_hd__fill_2
XFILLER_28_737 VPWR VGND VPWR VGND sky130_ef_sc_hd__decap_12
XFILLER_103_57 VPWR VGND VPWR VGND sky130_ef_sc_hd__decap_12
XFILLER_83_865 VPWR VGND VPWR VGND sky130_ef_sc_hd__decap_12
XTAP_TAPCELL_ROW_2_368 VGND VPWR sky130_fd_sc_hd__tapvpwrvgnd_1
XTAP_TAPCELL_ROW_2_357 VGND VPWR sky130_fd_sc_hd__tapvpwrvgnd_1
XFILLER_27_258 VGND VGND VPWR VPWR sky130_fd_sc_hd__decap_8
XFILLER_70_515 VPWR VGND VPWR VGND sky130_ef_sc_hd__decap_12
XANTENNA__2185__A A_reg\[9\] VGND VGND VPWR VPWR sky130_fd_sc_hd__diode_2
XFILLER_36_781 VPWR VGND VPWR VGND sky130_ef_sc_hd__decap_12
X_3069_ _0754_ _0756_ VGND VGND VPWR VPWR _0757_ sky130_fd_sc_hd__nor2_1
XFILLER_43_729 VPWR VGND VPWR VGND sky130_ef_sc_hd__decap_12
XTAP_TAPCELL_ROW_42_1007 VGND VPWR sky130_fd_sc_hd__tapvpwrvgnd_1
XTAP_TAPCELL_ROW_137_2524 VGND VPWR sky130_fd_sc_hd__tapvpwrvgnd_1
XFILLER_23_497 VGND VGND VPWR VPWR sky130_fd_sc_hd__decap_6
XANTENNA__2124__S B_reg\[6\] VGND VGND VPWR VPWR sky130_fd_sc_hd__diode_2
XFILLER_136_333 VPWR VGND VPWR VGND sky130_ef_sc_hd__decap_12
XFILLER_109_536 VGND VGND VPWR VPWR sky130_fd_sc_hd__fill_1
XTAP_TAPCELL_ROW_21_665 VGND VPWR sky130_fd_sc_hd__tapvpwrvgnd_1
XTAP_TAPCELL_ROW_150_2735 VGND VPWR sky130_fd_sc_hd__tapvpwrvgnd_1
XTAP_TAPCELL_ROW_150_2724 VGND VPWR sky130_fd_sc_hd__tapvpwrvgnd_1
XFILLER_137_889 VGND VGND VPWR VPWR sky130_fd_sc_hd__decap_6
XFILLER_12_65 VPWR VGND VPWR VGND sky130_ef_sc_hd__decap_12
XFILLER_152_837 VPWR VGND VPWR VGND sky130_ef_sc_hd__decap_12
XFILLER_136_377 VPWR VGND VPWR VGND sky130_ef_sc_hd__decap_12
XFILLER_128_65 VPWR VGND VPWR VGND sky130_ef_sc_hd__decap_12
XFILLER_2_302 VGND VGND VPWR VPWR sky130_fd_sc_hd__decap_6
XFILLER_105_753 VPWR VGND VPWR VGND sky130_ef_sc_hd__decap_12
XTAP_TAPCELL_ROW_57_1250 VGND VPWR sky130_fd_sc_hd__tapvpwrvgnd_1
XFILLER_120_701 VPWR VGND VPWR VGND sky130_ef_sc_hd__decap_12
XFILLER_105_797 VPWR VGND VPWR VGND sky130_ef_sc_hd__decap_12
XFILLER_2_379 VPWR VGND VPWR VGND sky130_ef_sc_hd__decap_12
XFILLER_144_53 VPWR VGND VPWR VGND sky130_ef_sc_hd__decap_12
XFILLER_77_125 VGND VGND VPWR VPWR sky130_fd_sc_hd__decap_4
XTAP_TAPCELL_ROW_70_1450 VGND VPWR sky130_fd_sc_hd__tapvpwrvgnd_1
XTAP_TAPCELL_ROW_148_2697 VGND VPWR sky130_fd_sc_hd__tapvpwrvgnd_1
XFILLER_144_97 VPWR VGND VPWR VGND sky130_ef_sc_hd__decap_12
XANTENNA__3252__Q OpSel_reg\[0\] VGND VGND VPWR VPWR sky130_fd_sc_hd__diode_2
XFILLER_77_169 VPWR VGND VPWR VGND sky130_ef_sc_hd__decap_12
XFILLER_74_810 VGND VGND VPWR VPWR sky130_fd_sc_hd__fill_2
XFILLER_59_895 VGND VGND VPWR VPWR sky130_fd_sc_hd__fill_1
XFILLER_37_51 VGND VGND VPWR VPWR sky130_fd_sc_hd__decap_4
XFILLER_73_342 VPWR VGND VPWR VGND sky130_ef_sc_hd__decap_12
XFILLER_46_545 VPWR VGND VPWR VGND sky130_ef_sc_hd__decap_12
XFILLER_46_589 VPWR VGND VPWR VGND sky130_ef_sc_hd__decap_12
XTAP_TAPCELL_ROW_29_798 VGND VPWR sky130_fd_sc_hd__tapvpwrvgnd_1
XFILLER_61_559 VGND VGND VPWR VPWR sky130_fd_sc_hd__fill_1
XFILLER_147_609 VGND VGND VPWR VPWR sky130_fd_sc_hd__decap_6
XFILLER_139_193 VPWR VGND VPWR VGND sky130_ef_sc_hd__decap_12
XFILLER_10_681 VPWR VGND VPWR VGND sky130_ef_sc_hd__decap_12
XTAP_TAPCELL_ROW_40_974 VGND VPWR sky130_fd_sc_hd__tapvpwrvgnd_1
XFILLER_128_867 VGND VGND VPWR VPWR sky130_fd_sc_hd__fill_1
XFILLER_115_517 VPWR VGND VPWR VGND sky130_ef_sc_hd__decap_12
XFILLER_108_580 VGND VGND VPWR VPWR sky130_fd_sc_hd__decap_8
X_2440_ _0189_ b_r0\[0\] a_r0\[0\] VGND VGND VPWR VPWR _0190_ sky130_fd_sc_hd__mux2_1
XFILLER_123_561 VPWR VGND VPWR VGND sky130_ef_sc_hd__decap_12
XFILLER_96_401 VGND VGND VPWR VPWR sky130_fd_sc_hd__decap_8
X_2371_ _0123_ _0124_ VGND VGND VPWR VPWR _0125_ sky130_fd_sc_hd__nor2_1
XFILLER_69_615 VGND VGND VPWR VPWR sky130_fd_sc_hd__fill_1
XFILLER_110_233 VPWR VGND VPWR VGND sky130_ef_sc_hd__decap_12
XFILLER_96_445 VPWR VGND VPWR VGND sky130_ef_sc_hd__decap_12
XANTENNA__3294__RESET_B net36 VGND VGND VPWR VPWR sky130_fd_sc_hd__diode_2
XFILLER_56_309 VPWR VGND VPWR VGND sky130_ef_sc_hd__decap_12
XANTENNA__3223__RESET_B net36 VGND VGND VPWR VPWR sky130_fd_sc_hd__diode_2
XFILLER_110_277 VPWR VGND VPWR VGND sky130_ef_sc_hd__decap_12
XTAP_TAPCELL_ROW_88_1744 VGND VPWR sky130_fd_sc_hd__tapvpwrvgnd_1
XTAP_TAPCELL_ROW_88_1733 VGND VPWR sky130_fd_sc_hd__tapvpwrvgnd_1
XFILLER_65_821 VPWR VGND VPWR VGND sky130_ef_sc_hd__decap_12
XANTENNA__1657__A1 A_reg\[11\] VGND VGND VPWR VPWR sky130_fd_sc_hd__diode_2
XFILLER_65_865 VPWR VGND VPWR VGND sky130_ef_sc_hd__decap_12
XFILLER_64_353 VGND VGND VPWR VPWR sky130_fd_sc_hd__decap_8
XFILLER_64_342 VGND VGND VPWR VPWR sky130_fd_sc_hd__decap_8
XFILLER_80_813 VPWR VGND VPWR VGND sky130_ef_sc_hd__decap_12
XFILLER_18_781 VPWR VGND VPWR VGND sky130_ef_sc_hd__decap_12
XFILLER_25_729 VPWR VGND VPWR VGND sky130_ef_sc_hd__decap_12
XFILLER_20_401 VPWR VGND VPWR VGND sky130_ef_sc_hd__decap_12
XTAP_TAPCELL_ROW_119_2243 VGND VPWR sky130_fd_sc_hd__tapvpwrvgnd_1
XTAP_TAPCELL_ROW_119_2232 VGND VPWR sky130_fd_sc_hd__tapvpwrvgnd_1
XFILLER_20_456 VPWR VGND VPWR VGND sky130_ef_sc_hd__decap_12
XFILLER_118_333 VPWR VGND VPWR VGND sky130_ef_sc_hd__decap_12
XFILLER_20_489 VPWR VGND VPWR VGND sky130_ef_sc_hd__decap_12
XFILLER_119_889 VGND VGND VPWR VPWR sky130_fd_sc_hd__decap_6
X_2707_ a_r3\[2\] b_r3\[1\] _0445_ VGND VGND VPWR VPWR _0447_ sky130_fd_sc_hd__a21o_1
XFILLER_134_837 VPWR VGND VPWR VGND sky130_ef_sc_hd__decap_12
XTAP_TAPCELL_ROW_132_2443 VGND VPWR sky130_fd_sc_hd__tapvpwrvgnd_1
XFILLER_118_377 VPWR VGND VPWR VGND sky130_ef_sc_hd__decap_12
XANTENNA__1636__X net37 VGND VGND VPWR VPWR sky130_fd_sc_hd__diode_2
X_2638_ _0184_ _0380_ _0381_ _0910_ u_crt.r2\[1\] VGND VGND VPWR VPWR _0033_ sky130_fd_sc_hd__a32o_1
XFILLER_142_881 VPWR VGND VPWR VGND sky130_ef_sc_hd__decap_12
XFILLER_102_701 VPWR VGND VPWR VGND sky130_ef_sc_hd__decap_12
XFILLER_99_261 VGND VGND VPWR VPWR sky130_fd_sc_hd__decap_8
X_2569_ _0306_ _0313_ VGND VGND VPWR VPWR _0314_ sky130_fd_sc_hd__and2_1
XTAP_TAPCELL_ROW_7_438 VGND VPWR sky130_fd_sc_hd__tapvpwrvgnd_1
XFILLER_141_391 VGND VGND VPWR VPWR sky130_fd_sc_hd__fill_1
XTAP_TAPCELL_ROW_7_449 VGND VPWR sky130_fd_sc_hd__tapvpwrvgnd_1
XFILLER_75_629 VGND VGND VPWR VPWR sky130_fd_sc_hd__decap_4
XFILLER_59_169 VGND VGND VPWR VPWR sky130_fd_sc_hd__decap_6
XFILLER_74_139 VGND VGND VPWR VPWR sky130_fd_sc_hd__fill_1
XFILLER_28_501 VPWR VGND VPWR VGND sky130_ef_sc_hd__decap_12
XANTENNA__1812__A A_reg\[3\] VGND VGND VPWR VPWR sky130_fd_sc_hd__diode_2
XFILLER_28_545 VPWR VGND VPWR VGND sky130_ef_sc_hd__decap_12
XFILLER_83_673 VPWR VGND VPWR VGND sky130_ef_sc_hd__decap_12
XFILLER_55_386 VGND VGND VPWR VPWR sky130_fd_sc_hd__decap_6
XFILLER_55_353 VGND VGND VPWR VPWR sky130_fd_sc_hd__fill_1
XFILLER_15_217 VGND VGND VPWR VPWR sky130_fd_sc_hd__decap_6
XFILLER_28_589 VPWR VGND VPWR VGND sky130_ef_sc_hd__decap_12
XFILLER_82_183 VGND VGND VPWR VPWR sky130_fd_sc_hd__fill_2
XFILLER_70_345 VPWR VGND VPWR VGND sky130_ef_sc_hd__decap_12
XTAP_TAPCELL_ROW_26_746 VGND VPWR sky130_fd_sc_hd__tapvpwrvgnd_1
XFILLER_43_559 VGND VGND VPWR VPWR sky130_fd_sc_hd__fill_1
XFILLER_130_77 VGND VGND VPWR VPWR sky130_fd_sc_hd__decap_6
XFILLER_30_209 VGND VGND VPWR VPWR sky130_fd_sc_hd__decap_8
XFILLER_129_609 VGND VGND VPWR VPWR sky130_fd_sc_hd__decap_6
XFILLER_135_3 VPWR VGND VPWR VGND sky130_ef_sc_hd__decap_12
XANTENNA__3320__CLK clknet_3_5__leaf_clk VGND VGND VPWR VPWR sky130_fd_sc_hd__diode_2
XPHY_EDGE_ROW_137_Right_137 VGND VGND VPWR VPWR sky130_fd_sc_hd__decap_3
XFILLER_7_449 VGND VGND VPWR VPWR sky130_fd_sc_hd__decap_4
XFILLER_7_416 VPWR VGND VPWR VGND sky130_ef_sc_hd__decap_12
XFILLER_152_601 VPWR VGND VPWR VGND sky130_ef_sc_hd__decap_12
XFILLER_137_653 VPWR VGND VPWR VGND sky130_ef_sc_hd__decap_12
XFILLER_136_141 VPWR VGND VPWR VGND sky130_ef_sc_hd__decap_12
XFILLER_151_111 VGND VGND VPWR VPWR sky130_fd_sc_hd__fill_1
XFILLER_137_697 VPWR VGND VPWR VGND sky130_ef_sc_hd__decap_12
XFILLER_99_57 VPWR VGND VPWR VGND sky130_ef_sc_hd__decap_12
XFILLER_152_645 VPWR VGND VPWR VGND sky130_ef_sc_hd__decap_12
XTAP_TAPCELL_ROW_55_1209 VGND VPWR sky130_fd_sc_hd__tapvpwrvgnd_1
XFILLER_2_121 VPWR VGND VPWR VGND sky130_ef_sc_hd__decap_12
XFILLER_105_572 VPWR VGND VPWR VGND sky130_ef_sc_hd__decap_12
XFILLER_78_412 VGND VGND VPWR VPWR sky130_fd_sc_hd__decap_8
XFILLER_2_165 VPWR VGND VPWR VGND sky130_ef_sc_hd__decap_12
XFILLER_120_531 VGND VGND VPWR VPWR sky130_fd_sc_hd__fill_1
XFILLER_78_445 VPWR VGND VPWR VGND sky130_ef_sc_hd__decap_12
XFILLER_94_905 VGND VGND VPWR VPWR sky130_fd_sc_hd__decap_4
XFILLER_38_309 VPWR VGND VPWR VGND sky130_ef_sc_hd__decap_12
XFILLER_93_437 VGND VGND VPWR VPWR sky130_fd_sc_hd__fill_1
XFILLER_78_489 VPWR VGND VPWR VGND sky130_ef_sc_hd__decap_12
XFILLER_48_83 VGND VGND VPWR VPWR sky130_fd_sc_hd__fill_1
XFILLER_47_821 VPWR VGND VPWR VGND sky130_ef_sc_hd__decap_12
XANTENNA__2836__A0 net9 VGND VGND VPWR VPWR sky130_fd_sc_hd__diode_2
XANTENNA_input10_X net10 VGND VGND VPWR VPWR sky130_fd_sc_hd__diode_2
XPHY_EDGE_ROW_100_Left_254 VGND VGND VPWR VPWR sky130_fd_sc_hd__decap_3
XFILLER_62_813 VPWR VGND VPWR VGND sky130_ef_sc_hd__decap_12
XFILLER_0_57 VPWR VGND VPWR VGND sky130_ef_sc_hd__decap_12
XFILLER_34_515 VGND VGND VPWR VPWR sky130_fd_sc_hd__decap_8
XFILLER_74_695 VGND VGND VPWR VPWR sky130_fd_sc_hd__decap_4
XFILLER_64_82 VGND VGND VPWR VPWR sky130_fd_sc_hd__fill_2
XFILLER_61_334 VGND VGND VPWR VPWR sky130_fd_sc_hd__fill_2
XTAP_TAPCELL_ROW_83_1663 VGND VPWR sky130_fd_sc_hd__tapvpwrvgnd_1
XTAP_TAPCELL_ROW_83_1652 VGND VPWR sky130_fd_sc_hd__tapvpwrvgnd_1
XFILLER_62_879 VGND VGND VPWR VPWR sky130_fd_sc_hd__fill_1
XFILLER_61_367 VGND VGND VPWR VPWR sky130_fd_sc_hd__fill_1
X_1940_ B_reg\[7\] _1199_ _1204_ _1202_ VGND VGND VPWR VPWR _1205_ sky130_fd_sc_hd__a31o_1
XFILLER_42_581 VGND VGND VPWR VPWR sky130_fd_sc_hd__decap_6
XFILLER_147_417 VPWR VGND VPWR VGND sky130_ef_sc_hd__decap_12
XFILLER_9_55 VGND VGND VPWR VPWR sky130_fd_sc_hd__fill_1
X_1871_ A_reg\[5\] _1138_ VGND VGND VPWR VPWR _1141_ sky130_fd_sc_hd__nor2_1
XPHY_EDGE_ROW_104_Right_104 VGND VGND VPWR VPWR sky130_fd_sc_hd__decap_3
XFILLER_80_70 VGND VGND VPWR VPWR sky130_fd_sc_hd__decap_4
XFILLER_116_837 VPWR VGND VPWR VGND sky130_ef_sc_hd__decap_12
XTAP_TAPCELL_ROW_114_2151 VGND VPWR sky130_fd_sc_hd__tapvpwrvgnd_1
XFILLER_142_133 VGND VGND VPWR VPWR sky130_fd_sc_hd__decap_6
XTAP_TAPCELL_ROW_114_2162 VGND VPWR sky130_fd_sc_hd__tapvpwrvgnd_1
XFILLER_50_3 VPWR VGND VPWR VGND sky130_ef_sc_hd__decap_12
XFILLER_142_177 VPWR VGND VPWR VGND sky130_ef_sc_hd__decap_12
XFILLER_124_881 VPWR VGND VPWR VGND sky130_ef_sc_hd__decap_12
X_2423_ _0174_ _0175_ _0897_ VGND VGND VPWR VPWR _0177_ sky130_fd_sc_hd__a21o_1
XFILLER_88_209 VGND VGND VPWR VPWR sky130_fd_sc_hd__decap_6
XFILLER_123_391 VGND VGND VPWR VPWR sky130_fd_sc_hd__fill_1
XFILLER_97_721 VGND VGND VPWR VPWR sky130_fd_sc_hd__decap_6
X_2354_ _1599_ _0107_ VGND VGND VPWR VPWR _0108_ sky130_fd_sc_hd__xnor2_1
XFILLER_69_445 VGND VGND VPWR VPWR sky130_fd_sc_hd__decap_3
XANTENNA__1878__A1 A_reg\[3\] VGND VGND VPWR VPWR sky130_fd_sc_hd__diode_2
XFILLER_97_765 VPWR VGND VPWR VGND sky130_ef_sc_hd__decap_12
XFILLER_96_253 VPWR VGND VPWR VGND sky130_ef_sc_hd__decap_12
XFILLER_111_597 VPWR VGND VPWR VGND sky130_ef_sc_hd__decap_12
XANTENNA__2728__A a_r3\[3\] VGND VGND VPWR VPWR sky130_fd_sc_hd__diode_2
X_2285_ A_reg\[0\] _1540_ VGND VGND VPWR VPWR _1542_ sky130_fd_sc_hd__nand2_1
XFILLER_57_629 VPWR VGND VPWR VGND sky130_ef_sc_hd__decap_12
XFILLER_56_128 VPWR VGND VPWR VGND sky130_ef_sc_hd__decap_12
XFILLER_64_172 VPWR VGND VPWR VGND sky130_ef_sc_hd__decap_12
XFILLER_25_559 VGND VGND VPWR VPWR sky130_fd_sc_hd__fill_1
XFILLER_12_209 VPWR VGND VPWR VGND sky130_ef_sc_hd__decap_12
XTAP_TAPCELL_ROW_23_705 VGND VPWR sky130_fd_sc_hd__tapvpwrvgnd_1
XANTENNA__2055__A1 B_reg\[5\] VGND VGND VPWR VPWR sky130_fd_sc_hd__diode_2
XFILLER_52_389 VPWR VGND VPWR VGND sky130_ef_sc_hd__decap_12
XFILLER_21_721 VGND VGND VPWR VPWR sky130_fd_sc_hd__decap_6
XFILLER_21_765 VPWR VGND VPWR VGND sky130_ef_sc_hd__decap_12
XFILLER_60_29 VGND VGND VPWR VPWR sky130_fd_sc_hd__decap_3
XFILLER_20_253 VPWR VGND VPWR VGND sky130_ef_sc_hd__decap_12
XFILLER_119_653 VPWR VGND VPWR VGND sky130_ef_sc_hd__decap_12
XFILLER_118_141 VPWR VGND VPWR VGND sky130_ef_sc_hd__decap_12
XFILLER_5_909 VGND VGND VPWR VPWR sky130_fd_sc_hd__fill_1
XFILLER_134_601 VPWR VGND VPWR VGND sky130_ef_sc_hd__decap_12
XFILLER_119_697 VPWR VGND VPWR VGND sky130_ef_sc_hd__decap_12
XANTENNA__1807__A A_reg\[3\] VGND VGND VPWR VPWR sky130_fd_sc_hd__diode_2
XFILLER_134_645 VPWR VGND VPWR VGND sky130_ef_sc_hd__decap_12
XFILLER_133_111 VGND VGND VPWR VPWR sky130_fd_sc_hd__fill_1
XFILLER_121_317 VPWR VGND VPWR VGND sky130_ef_sc_hd__decap_12
XFILLER_79_209 VGND VGND VPWR VPWR sky130_fd_sc_hd__fill_2
XANTENNA__1642__A_N A_reg\[15\] VGND VGND VPWR VPWR sky130_fd_sc_hd__diode_2
XFILLER_0_636 VGND VGND VPWR VPWR sky130_fd_sc_hd__decap_4
XFILLER_125_55 VGND VGND VPWR VPWR sky130_fd_sc_hd__fill_1
XFILLER_76_905 VGND VGND VPWR VPWR sky130_fd_sc_hd__decap_4
XTAP_TAPCELL_ROW_50_1128 VGND VPWR sky130_fd_sc_hd__tapvpwrvgnd_1
XFILLER_0_669 VGND VGND VPWR VPWR sky130_fd_sc_hd__decap_3
XTAP_TAPCELL_ROW_145_2645 VGND VPWR sky130_fd_sc_hd__tapvpwrvgnd_1
XTAP_TAPCELL_ROW_50_1139 VGND VPWR sky130_fd_sc_hd__tapvpwrvgnd_1
XFILLER_29_821 VPWR VGND VPWR VGND sky130_ef_sc_hd__decap_12
XTAP_TAPCELL_ROW_145_2656 VGND VPWR sky130_fd_sc_hd__tapvpwrvgnd_1
XFILLER_18_53 VPWR VGND VPWR VGND sky130_ef_sc_hd__decap_12
XFILLER_29_865 VPWR VGND VPWR VGND sky130_ef_sc_hd__decap_12
XFILLER_90_418 VGND VGND VPWR VPWR sky130_fd_sc_hd__fill_2
XFILLER_55_161 VGND VGND VPWR VPWR sky130_fd_sc_hd__decap_6
XFILLER_44_813 VPWR VGND VPWR VGND sky130_ef_sc_hd__decap_12
XFILLER_83_481 VGND VGND VPWR VPWR sky130_fd_sc_hd__decap_3
XFILLER_18_97 VPWR VGND VPWR VGND sky130_ef_sc_hd__decap_12
XANTENNA__2046__A1 B_reg\[6\] VGND VGND VPWR VPWR sky130_fd_sc_hd__diode_2
XTAP_TAPCELL_ROW_65_1371 VGND VPWR sky130_fd_sc_hd__tapvpwrvgnd_1
XFILLER_24_581 VGND VGND VPWR VPWR sky130_fd_sc_hd__decap_6
XFILLER_34_41 VPWR VGND VPWR VGND sky130_ef_sc_hd__decap_12
XFILLER_129_417 VPWR VGND VPWR VGND sky130_ef_sc_hd__decap_12
XFILLER_34_85 VPWR VGND VPWR VGND sky130_ef_sc_hd__decap_12
XFILLER_8_725 VPWR VGND VPWR VGND sky130_ef_sc_hd__decap_12
XFILLER_8_769 VPWR VGND VPWR VGND sky130_ef_sc_hd__decap_12
XFILLER_137_461 VPWR VGND VPWR VGND sky130_ef_sc_hd__decap_12
XANTENNA__1717__A A_reg\[1\] VGND VGND VPWR VPWR sky130_fd_sc_hd__diode_2
XFILLER_50_62 VPWR VGND VPWR VGND sky130_ef_sc_hd__decap_12
XFILLER_7_279 VGND VGND VPWR VPWR sky130_fd_sc_hd__fill_1
XFILLER_124_133 VGND VGND VPWR VPWR sky130_fd_sc_hd__decap_6
XFILLER_152_475 VGND VGND VPWR VPWR sky130_fd_sc_hd__fill_1
XFILLER_140_637 VGND VGND VPWR VPWR sky130_fd_sc_hd__decap_6
XFILLER_124_177 VPWR VGND VPWR VGND sky130_ef_sc_hd__decap_12
XFILLER_106_881 VPWR VGND VPWR VGND sky130_ef_sc_hd__decap_12
XANTENNA__3216__CLK clknet_3_4__leaf_clk VGND VGND VPWR VPWR sky130_fd_sc_hd__diode_2
XFILLER_105_391 VGND VGND VPWR VPWR sky130_fd_sc_hd__fill_1
XFILLER_78_253 VGND VGND VPWR VPWR sky130_fd_sc_hd__decap_3
XFILLER_59_93 VPWR VGND VPWR VGND sky130_ef_sc_hd__decap_12
XFILLER_121_895 VGND VGND VPWR VPWR sky130_fd_sc_hd__fill_1
XFILLER_94_713 VPWR VGND VPWR VGND sky130_ef_sc_hd__decap_12
XFILLER_78_275 VPWR VGND VPWR VGND sky130_ef_sc_hd__decap_12
XFILLER_66_426 VPWR VGND VPWR VGND sky130_ef_sc_hd__decap_12
XFILLER_39_629 VPWR VGND VPWR VGND sky130_ef_sc_hd__decap_12
XFILLER_94_757 VPWR VGND VPWR VGND sky130_ef_sc_hd__decap_12
XFILLER_93_223 VGND VGND VPWR VPWR sky130_fd_sc_hd__fill_1
X_2070_ B_reg\[3\] _1330_ VGND VGND VPWR VPWR _1332_ sky130_fd_sc_hd__xnor2_1
XFILLER_38_139 VGND VGND VPWR VPWR sky130_fd_sc_hd__fill_1
XFILLER_75_81 VPWR VGND VPWR VGND sky130_ef_sc_hd__decap_12
XFILLER_62_643 VGND VGND VPWR VPWR sky130_fd_sc_hd__fill_1
XFILLER_61_142 VPWR VGND VPWR VGND sky130_ef_sc_hd__decap_12
XFILLER_61_120 VGND VGND VPWR VPWR sky130_fd_sc_hd__decap_3
XFILLER_34_345 VGND VGND VPWR VPWR sky130_fd_sc_hd__decap_8
XFILLER_98_3 VPWR VGND VPWR VGND sky130_ef_sc_hd__decap_12
X_2972_ _0642_ _0644_ _0658_ VGND VGND VPWR VPWR _0660_ sky130_fd_sc_hd__or3_1
XFILLER_50_849 VPWR VGND VPWR VGND sky130_ef_sc_hd__decap_12
XTAP_TAPCELL_ROW_17_598 VGND VPWR sky130_fd_sc_hd__tapvpwrvgnd_1
XFILLER_34_389 VPWR VGND VPWR VGND sky130_ef_sc_hd__decap_12
X_1923_ B_reg\[10\] _1186_ VGND VGND VPWR VPWR _1188_ sky130_fd_sc_hd__nand2_1
XFILLER_30_540 VPWR VGND VPWR VGND sky130_ef_sc_hd__decap_12
XFILLER_148_737 VPWR VGND VPWR VGND sky130_ef_sc_hd__decap_12
XFILLER_147_225 VPWR VGND VPWR VGND sky130_ef_sc_hd__decap_12
X_1854_ _1119_ _1121_ _0889_ VGND VGND VPWR VPWR _1124_ sky130_fd_sc_hd__mux2_1
XFILLER_116_601 VPWR VGND VPWR VGND sky130_ef_sc_hd__decap_12
XANTENNA__1627__A B_reg\[3\] VGND VGND VPWR VPWR sky130_fd_sc_hd__diode_2
X_1785_ _1047_ _1052_ _1054_ _1051_ VGND VGND VPWR VPWR _1058_ sky130_fd_sc_hd__o22ai_2
XFILLER_116_645 VPWR VGND VPWR VGND sky130_ef_sc_hd__decap_12
XFILLER_115_111 VGND VGND VPWR VPWR sky130_fd_sc_hd__fill_1
XTAP_TAPCELL_ROW_96_1865 VGND VPWR sky130_fd_sc_hd__tapvpwrvgnd_1
XFILLER_131_615 VGND VGND VPWR VPWR sky130_fd_sc_hd__fill_1
XFILLER_143_497 VGND VGND VPWR VPWR sky130_fd_sc_hd__decap_6
XFILLER_103_317 VPWR VGND VPWR VGND sky130_ef_sc_hd__decap_12
X_2406_ _0908_ _0151_ _0153_ VGND VGND VPWR VPWR _0160_ sky130_fd_sc_hd__and3_1
XANTENNA_clkbuf_3_0__f_clk_X clknet_3_0__leaf_clk VGND VGND VPWR VPWR sky130_fd_sc_hd__diode_2
XFILLER_58_905 VGND VGND VPWR VPWR sky130_fd_sc_hd__decap_4
XANTENNA__1633__Y Encode_EN VGND VGND VPWR VPWR sky130_fd_sc_hd__diode_2
XFILLER_111_361 VPWR VGND VPWR VGND sky130_ef_sc_hd__decap_12
XFILLER_97_573 VPWR VGND VPWR VGND sky130_ef_sc_hd__decap_12
XFILLER_85_713 VGND VGND VPWR VPWR sky130_fd_sc_hd__fill_2
X_2337_ _1587_ _1589_ _0902_ VGND VGND VPWR VPWR _1590_ sky130_fd_sc_hd__a21oi_1
XTAP_TAPCELL_ROW_127_2364 VGND VPWR sky130_fd_sc_hd__tapvpwrvgnd_1
XFILLER_84_245 VGND VGND VPWR VPWR sky130_fd_sc_hd__decap_4
X_2268_ A_reg\[2\] _1519_ _1508_ VGND VGND VPWR VPWR _1525_ sky130_fd_sc_hd__a21oi_1
XFILLER_72_429 VGND VGND VPWR VPWR sky130_fd_sc_hd__decap_3
XANTENNA__2276__A1 A_reg\[1\] VGND VGND VPWR VPWR sky130_fd_sc_hd__diode_2
XFILLER_26_813 VPWR VGND VPWR VGND sky130_ef_sc_hd__decap_12
XANTENNA__1894__A2_N _0910_ VGND VGND VPWR VPWR sky130_fd_sc_hd__diode_2
XFILLER_44_109 VPWR VGND VPWR VGND sky130_ef_sc_hd__decap_12
X_2199_ A_reg\[8\] _1442_ _1452_ VGND VGND VPWR VPWR _1456_ sky130_fd_sc_hd__and3_1
XFILLER_25_334 VGND VGND VPWR VPWR sky130_fd_sc_hd__fill_2
XFILLER_37_161 VGND VGND VPWR VPWR sky130_fd_sc_hd__decap_6
XTAP_TAPCELL_ROW_140_2575 VGND VPWR sky130_fd_sc_hd__tapvpwrvgnd_1
XTAP_TAPCELL_ROW_140_2564 VGND VPWR sky130_fd_sc_hd__tapvpwrvgnd_1
XFILLER_111_57 VPWR VGND VPWR VGND sky130_ef_sc_hd__decap_12
XFILLER_13_529 VPWR VGND VPWR VGND sky130_ef_sc_hd__decap_12
XFILLER_40_315 VPWR VGND VPWR VGND sky130_ef_sc_hd__decap_12
XANTENNA__2624__C _0187_ VGND VGND VPWR VPWR sky130_fd_sc_hd__diode_2
XFILLER_71_39 VPWR VGND VPWR VGND sky130_ef_sc_hd__decap_12
XFILLER_52_197 VPWR VGND VPWR VGND sky130_ef_sc_hd__decap_12
XTAP_TAPCELL_ROW_47_1090 VGND VPWR sky130_fd_sc_hd__tapvpwrvgnd_1
XFILLER_21_573 VPWR VGND VPWR VGND sky130_ef_sc_hd__decap_12
XFILLER_119_461 VPWR VGND VPWR VGND sky130_ef_sc_hd__decap_12
XANTENNA__3239__CLK clknet_3_3__leaf_clk VGND VGND VPWR VPWR sky130_fd_sc_hd__diode_2
XTAP_TAPCELL_ROW_60_1290 VGND VPWR sky130_fd_sc_hd__tapvpwrvgnd_1
XFILLER_106_133 VGND VGND VPWR VPWR sky130_fd_sc_hd__decap_6
XANTENNA__2200__A1 A_reg\[8\] VGND VGND VPWR VPWR sky130_fd_sc_hd__diode_2
XFILLER_134_475 VGND VGND VPWR VPWR sky130_fd_sc_hd__fill_1
XFILLER_20_65 VPWR VGND VPWR VGND sky130_ef_sc_hd__decap_12
XFILLER_136_65 VPWR VGND VPWR VGND sky130_ef_sc_hd__decap_12
XFILLER_122_637 VGND VGND VPWR VPWR sky130_fd_sc_hd__decap_6
XFILLER_121_125 VPWR VGND VPWR VGND sky130_ef_sc_hd__decap_12
XFILLER_106_177 VPWR VGND VPWR VGND sky130_ef_sc_hd__decap_12
XFILLER_49_905 VGND VGND VPWR VPWR sky130_fd_sc_hd__fill_2
XFILLER_0_433 VPWR VGND VPWR VGND sky130_ef_sc_hd__decap_12
XFILLER_130_681 VPWR VGND VPWR VGND sky130_ef_sc_hd__decap_12
XFILLER_121_169 VPWR VGND VPWR VGND sky130_ef_sc_hd__decap_12
XFILLER_103_895 VGND VGND VPWR VPWR sky130_fd_sc_hd__fill_1
XFILLER_0_477 VPWR VGND VPWR VGND sky130_ef_sc_hd__decap_12
XFILLER_152_53 VPWR VGND VPWR VGND sky130_ef_sc_hd__decap_12
XFILLER_75_223 VGND VGND VPWR VPWR sky130_fd_sc_hd__fill_1
XFILLER_152_97 VPWR VGND VPWR VGND sky130_ef_sc_hd__decap_12
XFILLER_91_727 VGND VGND VPWR VPWR sky130_fd_sc_hd__fill_1
XANTENNA_input18_A B_in[10] VGND VGND VPWR VPWR sky130_fd_sc_hd__diode_2
XTAP_TAPCELL_ROW_67_1400 VGND VPWR sky130_fd_sc_hd__tapvpwrvgnd_1
XFILLER_29_673 VPWR VGND VPWR VGND sky130_ef_sc_hd__decap_12
XFILLER_90_237 VGND VGND VPWR VPWR sky130_fd_sc_hd__decap_3
XTAP_TAPCELL_ROW_67_1411 VGND VPWR sky130_fd_sc_hd__tapvpwrvgnd_1
XFILLER_16_301 VGND VGND VPWR VPWR sky130_fd_sc_hd__fill_2
XFILLER_16_323 VPWR VGND VPWR VGND sky130_ef_sc_hd__decap_12
XFILLER_44_621 VGND VGND VPWR VPWR sky130_fd_sc_hd__fill_1
XFILLER_90_259 VPWR VGND VPWR VGND sky130_ef_sc_hd__decap_12
XFILLER_45_51 VGND VGND VPWR VPWR sky130_fd_sc_hd__decap_4
XTAP_TAPCELL_ROW_80_1611 VGND VPWR sky130_fd_sc_hd__tapvpwrvgnd_1
XFILLER_71_495 VGND VGND VPWR VPWR sky130_fd_sc_hd__decap_8
XFILLER_31_326 VGND VGND VPWR VPWR sky130_fd_sc_hd__decap_8
XFILLER_44_687 VPWR VGND VPWR VGND sky130_ef_sc_hd__decap_12
XFILLER_31_337 VPWR VGND VPWR VGND sky130_ef_sc_hd__decap_12
XFILLER_129_225 VPWR VGND VPWR VGND sky130_ef_sc_hd__decap_12
XTAP_TAPCELL_ROW_14_557 VGND VPWR sky130_fd_sc_hd__tapvpwrvgnd_1
XFILLER_77_8 VGND VGND VPWR VPWR sky130_fd_sc_hd__decap_6
XFILLER_61_83 VPWR VGND VPWR VGND sky130_ef_sc_hd__decap_12
XFILLER_8_533 VPWR VGND VPWR VGND sky130_ef_sc_hd__decap_12
XFILLER_145_729 VPWR VGND VPWR VGND sky130_ef_sc_hd__decap_12
XFILLER_138_781 VPWR VGND VPWR VGND sky130_ef_sc_hd__decap_12
XTAP_TAPCELL_ROW_78_1573 VGND VPWR sky130_fd_sc_hd__tapvpwrvgnd_1
XFILLER_113_615 VGND VGND VPWR VPWR sky130_fd_sc_hd__fill_1
XTAP_TAPCELL_ROW_111_2110 VGND VPWR sky130_fd_sc_hd__tapvpwrvgnd_1
XTAP_TAPCELL_ROW_78_1584 VGND VPWR sky130_fd_sc_hd__tapvpwrvgnd_1
XFILLER_140_401 VPWR VGND VPWR VGND sky130_ef_sc_hd__decap_12
XFILLER_125_497 VGND VGND VPWR VPWR sky130_fd_sc_hd__decap_6
XANTENNA__1881__S A_reg\[2\] VGND VGND VPWR VPWR sky130_fd_sc_hd__diode_2
XFILLER_140_445 VPWR VGND VPWR VGND sky130_ef_sc_hd__decap_12
XTAP_TAPCELL_ROW_91_1784 VGND VPWR sky130_fd_sc_hd__tapvpwrvgnd_1
XFILLER_3_293 VPWR VGND VPWR VGND sky130_ef_sc_hd__decap_12
X_3240_ clknet_3_4__leaf_clk u_slice0.start_d net36 VGND VGND VPWR VPWR ALU_Done_all
+ sky130_fd_sc_hd__dfrtp_1
XFILLER_140_489 VPWR VGND VPWR VGND sky130_ef_sc_hd__decap_12
XFILLER_100_309 VPWR VGND VPWR VGND sky130_ef_sc_hd__decap_12
XTAP_TAPCELL_ROW_91_1795 VGND VPWR sky130_fd_sc_hd__tapvpwrvgnd_1
X_3171_ _0561_ _0828_ _0857_ VGND VGND VPWR VPWR _0859_ sky130_fd_sc_hd__and3_1
X_2122_ B_reg\[7\] _1377_ _1378_ VGND VGND VPWR VPWR _1381_ sky130_fd_sc_hd__o21ai_1
XFILLER_13_3 VPWR VGND VPWR VGND sky130_ef_sc_hd__decap_12
XTAP_TAPCELL_ROW_109_2083 VGND VPWR sky130_fd_sc_hd__tapvpwrvgnd_1
XTAP_TAPCELL_ROW_109_2072 VGND VPWR sky130_fd_sc_hd__tapvpwrvgnd_1
XFILLER_94_587 VGND VGND VPWR VPWR sky130_fd_sc_hd__fill_1
XFILLER_54_418 VGND VGND VPWR VPWR sky130_fd_sc_hd__fill_2
XFILLER_26_109 VPWR VGND VPWR VGND sky130_ef_sc_hd__decap_12
X_2053_ B_reg\[5\] _1307_ _1310_ _1314_ VGND VGND VPWR VPWR _1315_ sky130_fd_sc_hd__a31o_1
XFILLER_81_237 VPWR VGND VPWR VGND sky130_ef_sc_hd__decap_12
XFILLER_66_289 VPWR VGND VPWR VGND sky130_ef_sc_hd__decap_12
XFILLER_19_161 VGND VGND VPWR VPWR sky130_fd_sc_hd__decap_6
XFILLER_35_665 VGND VGND VPWR VPWR sky130_fd_sc_hd__decap_6
XTAP_TAPCELL_ROW_122_2283 VGND VPWR sky130_fd_sc_hd__tapvpwrvgnd_1
XFILLER_90_793 VPWR VGND VPWR VGND sky130_ef_sc_hd__decap_12
XFILLER_62_462 VGND VGND VPWR VPWR sky130_fd_sc_hd__decap_6
XFILLER_50_613 VGND VGND VPWR VPWR sky130_fd_sc_hd__decap_4
XFILLER_34_153 VPWR VGND VPWR VGND sky130_ef_sc_hd__decap_12
XFILLER_50_657 VPWR VGND VPWR VGND sky130_ef_sc_hd__decap_12
XFILLER_34_197 VPWR VGND VPWR VGND sky130_ef_sc_hd__decap_12
XTAP_TAPCELL_ROW_33_855 VGND VPWR sky130_fd_sc_hd__tapvpwrvgnd_1
XFILLER_148_501 VPWR VGND VPWR VGND sky130_ef_sc_hd__decap_12
XTAP_TAPCELL_ROW_98_1905 VGND VPWR sky130_fd_sc_hd__tapvpwrvgnd_1
X_2955_ _0629_ _0641_ VGND VGND VPWR VPWR _0643_ sky130_fd_sc_hd__xor2_1
XTAP_TAPCELL_ROW_33_866 VGND VPWR sky130_fd_sc_hd__tapvpwrvgnd_1
XFILLER_148_545 VPWR VGND VPWR VGND sky130_ef_sc_hd__decap_12
X_2886_ u_crt.r3\[1\] _0568_ _0567_ VGND VGND VPWR VPWR _0574_ sky130_fd_sc_hd__o21bai_4
X_1906_ _1169_ _1170_ B_reg\[12\] VGND VGND VPWR VPWR _1171_ sky130_fd_sc_hd__o21ai_1
XFILLER_148_589 VPWR VGND VPWR VGND sky130_ef_sc_hd__decap_12
XFILLER_135_217 VGND VGND VPWR VPWR sky130_fd_sc_hd__decap_6
XFILLER_108_409 VGND VGND VPWR VPWR sky130_fd_sc_hd__decap_8
X_1837_ _1101_ _1107_ VGND VGND VPWR VPWR _1109_ sky130_fd_sc_hd__xnor2_1
XFILLER_150_209 VPWR VGND VPWR VGND sky130_ef_sc_hd__decap_12
X_1768_ A_reg\[9\] _1033_ _1036_ _1038_ VGND VGND VPWR VPWR _1041_ sky130_fd_sc_hd__a31o_1
XFILLER_143_261 VPWR VGND VPWR VGND sky130_ef_sc_hd__decap_12
XFILLER_116_475 VGND VGND VPWR VPWR sky130_fd_sc_hd__fill_1
XFILLER_104_637 VGND VGND VPWR VPWR sky130_fd_sc_hd__decap_6
XFILLER_89_337 VPWR VGND VPWR VGND sky130_ef_sc_hd__decap_12
X_1699_ _0969_ _0974_ VGND VGND VPWR VPWR _0975_ sky130_fd_sc_hd__nor2_1
XFILLER_103_125 VPWR VGND VPWR VGND sky130_ef_sc_hd__decap_12
XFILLER_112_681 VPWR VGND VPWR VGND sky130_ef_sc_hd__decap_12
XFILLER_103_169 VPWR VGND VPWR VGND sky130_ef_sc_hd__decap_12
XFILLER_98_893 VPWR VGND VPWR VGND sky130_ef_sc_hd__decap_12
XFILLER_66_39 VPWR VGND VPWR VGND sky130_ef_sc_hd__decap_12
XFILLER_58_757 VPWR VGND VPWR VGND sky130_ef_sc_hd__decap_12
XTAP_TAPCELL_ROW_142_2604 VGND VPWR sky130_fd_sc_hd__tapvpwrvgnd_1
XFILLER_73_705 VGND VGND VPWR VPWR sky130_fd_sc_hd__fill_2
XFILLER_45_429 VGND VGND VPWR VPWR sky130_fd_sc_hd__decap_8
XFILLER_82_27 VGND VGND VPWR VPWR sky130_fd_sc_hd__fill_1
XFILLER_14_805 VGND VGND VPWR VPWR sky130_fd_sc_hd__decap_6
XFILLER_26_643 VGND VGND VPWR VPWR sky130_fd_sc_hd__fill_1
XANTENNA__2127__S B_reg\[5\] VGND VGND VPWR VPWR sky130_fd_sc_hd__diode_2
XFILLER_14_849 VPWR VGND VPWR VGND sky130_ef_sc_hd__decap_12
XTAP_TAPCELL_ROW_62_1330 VGND VPWR sky130_fd_sc_hd__tapvpwrvgnd_1
XTAP_TAPCELL_ROW_45_1049 VGND VPWR sky130_fd_sc_hd__tapvpwrvgnd_1
XTAP_TAPCELL_ROW_11_505 VGND VPWR sky130_fd_sc_hd__tapvpwrvgnd_1
XFILLER_22_893 VPWR VGND VPWR VGND sky130_ef_sc_hd__decap_12
XFILLER_127_729 VPWR VGND VPWR VGND sky130_ef_sc_hd__decap_12
XFILLER_5_503 VGND VGND VPWR VPWR sky130_fd_sc_hd__fill_1
XTAP_TAPCELL_ROW_153_2799 VGND VPWR sky130_fd_sc_hd__tapvpwrvgnd_1
XTAP_TAPCELL_ROW_153_2788 VGND VPWR sky130_fd_sc_hd__tapvpwrvgnd_1
XTAP_TAPCELL_ROW_153_2777 VGND VPWR sky130_fd_sc_hd__tapvpwrvgnd_1
XFILLER_107_453 VGND VGND VPWR VPWR sky130_fd_sc_hd__fill_1
XFILLER_122_401 VPWR VGND VPWR VGND sky130_ef_sc_hd__decap_12
Xoutput42 net42 VGND VGND VPWR VPWR X_out[13] sky130_fd_sc_hd__buf_1
XFILLER_122_445 VPWR VGND VPWR VGND sky130_ef_sc_hd__decap_12
XFILLER_1_753 VPWR VGND VPWR VGND sky130_ef_sc_hd__decap_12
Xoutput53 net53 VGND VGND VPWR VPWR X_out[9] sky130_fd_sc_hd__buf_1
XFILLER_122_489 VPWR VGND VPWR VGND sky130_ef_sc_hd__decap_12
XTAP_TAPCELL_ROW_73_1492 VGND VPWR sky130_fd_sc_hd__tapvpwrvgnd_1
XFILLER_49_713 VGND VGND VPWR VPWR sky130_fd_sc_hd__decap_6
XFILLER_1_797 VPWR VGND VPWR VGND sky130_ef_sc_hd__decap_12
XFILLER_76_587 VGND VGND VPWR VPWR sky130_fd_sc_hd__fill_1
XFILLER_48_245 VGND VGND VPWR VPWR sky130_fd_sc_hd__decap_6
XFILLER_36_407 VGND VGND VPWR VPWR sky130_fd_sc_hd__fill_1
XFILLER_64_749 VGND VGND VPWR VPWR sky130_fd_sc_hd__decap_6
XFILLER_56_72 VPWR VGND VPWR VGND sky130_ef_sc_hd__decap_12
XFILLER_48_289 VPWR VGND VPWR VGND sky130_ef_sc_hd__decap_12
XTAP_TAPCELL_ROW_19_638 VGND VPWR sky130_fd_sc_hd__tapvpwrvgnd_1
XFILLER_91_557 VGND VGND VPWR VPWR sky130_fd_sc_hd__decap_3
XFILLER_63_259 VPWR VGND VPWR VGND sky130_ef_sc_hd__decap_12
XFILLER_17_665 VGND VGND VPWR VPWR sky130_fd_sc_hd__decap_6
XFILLER_16_153 VPWR VGND VPWR VGND sky130_ef_sc_hd__decap_12
XFILLER_32_613 VPWR VGND VPWR VGND sky130_ef_sc_hd__decap_12
XFILLER_71_281 VPWR VGND VPWR VGND sky130_ef_sc_hd__decap_12
XFILLER_16_197 VPWR VGND VPWR VGND sky130_ef_sc_hd__decap_12
XFILLER_32_657 VPWR VGND VPWR VGND sky130_ef_sc_hd__decap_12
XANTENNA__3248__RESET_B net36 VGND VGND VPWR VPWR sky130_fd_sc_hd__diode_2
XTAP_TAPCELL_ROW_30_814 VGND VPWR sky130_fd_sc_hd__tapvpwrvgnd_1
XFILLER_31_167 VGND VGND VPWR VPWR sky130_fd_sc_hd__fill_1
XANTENNA__1876__S A_reg\[4\] VGND VGND VPWR VPWR sky130_fd_sc_hd__diode_2
X_2740_ _0422_ _0453_ _0471_ VGND VGND VPWR VPWR _0480_ sky130_fd_sc_hd__o21ai_1
XFILLER_9_853 VPWR VGND VPWR VGND sky130_ef_sc_hd__decap_12
XFILLER_117_217 VGND VGND VPWR VPWR sky130_fd_sc_hd__decap_6
X_2671_ a_r3\[1\] b_r3\[1\] VGND VGND VPWR VPWR _0411_ sky130_fd_sc_hd__and2_1
XFILLER_9_897 VPWR VGND VPWR VGND sky130_ef_sc_hd__decap_12
XFILLER_8_352 VPWR VGND VPWR VGND sky130_ef_sc_hd__decap_12
XFILLER_145_559 VGND VGND VPWR VPWR sky130_fd_sc_hd__fill_1
X_1622_ B_reg\[8\] VGND VGND VPWR VPWR _0902_ sky130_fd_sc_hd__inv_2
XFILLER_132_209 VPWR VGND VPWR VGND sky130_ef_sc_hd__decap_12
XTAP_TAPCELL_ROW_93_1824 VGND VPWR sky130_fd_sc_hd__tapvpwrvgnd_1
XTAP_TAPCELL_ROW_93_1813 VGND VPWR sky130_fd_sc_hd__tapvpwrvgnd_1
XFILLER_141_721 VGND VGND VPWR VPWR sky130_fd_sc_hd__decap_6
XFILLER_125_261 VPWR VGND VPWR VGND sky130_ef_sc_hd__decap_12
XFILLER_141_765 VPWR VGND VPWR VGND sky130_ef_sc_hd__decap_12
XFILLER_140_253 VPWR VGND VPWR VGND sky130_ef_sc_hd__decap_12
XFILLER_101_629 VPWR VGND VPWR VGND sky130_ef_sc_hd__decap_12
XFILLER_86_307 VGND VGND VPWR VPWR sky130_fd_sc_hd__fill_1
X_3223_ clknet_3_4__leaf_clk Encode_EN net36 VGND VGND VPWR VPWR Encode_Done_A sky130_fd_sc_hd__dfrtp_1
XFILLER_100_139 VGND VGND VPWR VPWR sky130_fd_sc_hd__fill_1
XFILLER_95_841 VPWR VGND VPWR VGND sky130_ef_sc_hd__decap_12
XFILLER_39_223 VGND VGND VPWR VPWR sky130_fd_sc_hd__fill_1
XTAP_TAPCELL_ROW_124_2312 VGND VPWR sky130_fd_sc_hd__tapvpwrvgnd_1
XFILLER_94_351 VGND VGND VPWR VPWR sky130_fd_sc_hd__decap_4
XFILLER_55_705 VGND VGND VPWR VPWR sky130_fd_sc_hd__fill_1
X_3154_ _0841_ VGND VGND VPWR VPWR _0842_ sky130_fd_sc_hd__inv_2
XTAP_TAPCELL_ROW_124_2323 VGND VPWR sky130_fd_sc_hd__tapvpwrvgnd_1
XFILLER_82_513 VPWR VGND VPWR VGND sky130_ef_sc_hd__decap_12
XFILLER_67_598 VGND VGND VPWR VPWR sky130_fd_sc_hd__decap_4
X_3085_ _0771_ _0772_ VGND VGND VPWR VPWR _0773_ sky130_fd_sc_hd__nor2_1
X_2105_ B_reg\[12\] _1359_ _1361_ VGND VGND VPWR VPWR _1364_ sky130_fd_sc_hd__o21a_1
XTAP_TAPCELL_ROW_38_936 VGND VPWR sky130_fd_sc_hd__tapvpwrvgnd_1
XTAP_TAPCELL_ROW_38_947 VGND VPWR sky130_fd_sc_hd__tapvpwrvgnd_1
XANTENNA__2455__B OpSel_reg\[0\] VGND VGND VPWR VPWR sky130_fd_sc_hd__diode_2
X_2036_ _0903_ _1293_ _1295_ _1296_ VGND VGND VPWR VPWR _1298_ sky130_fd_sc_hd__a22o_1
XFILLER_63_771 VPWR VGND VPWR VGND sky130_ef_sc_hd__decap_12
XFILLER_63_760 VGND VGND VPWR VPWR sky130_fd_sc_hd__fill_1
XFILLER_35_473 VPWR VGND VPWR VGND sky130_ef_sc_hd__decap_12
XFILLER_149_821 VPWR VGND VPWR VGND sky130_ef_sc_hd__decap_12
XTAP_TAPCELL_ROW_102_1964 VGND VPWR sky130_fd_sc_hd__tapvpwrvgnd_1
XFILLER_10_307 VGND VGND VPWR VPWR sky130_fd_sc_hd__fill_1
XFILLER_149_865 VPWR VGND VPWR VGND sky130_ef_sc_hd__decap_12
X_2938_ _0624_ _0625_ VGND VGND VPWR VPWR _0626_ sky130_fd_sc_hd__nand2b_1
XFILLER_22_189 VGND VGND VPWR VPWR sky130_fd_sc_hd__decap_6
XFILLER_109_729 VPWR VGND VPWR VGND sky130_ef_sc_hd__decap_12
X_2869_ u_crt.r1\[1\] _0555_ VGND VGND VPWR VPWR _0557_ sky130_fd_sc_hd__or2_1
XTAP_TAPCELL_ROW_135_2496 VGND VPWR sky130_fd_sc_hd__tapvpwrvgnd_1
XTAP_TAPCELL_ROW_135_2485 VGND VPWR sky130_fd_sc_hd__tapvpwrvgnd_1
XFILLER_2_506 VPWR VGND VPWR VGND sky130_ef_sc_hd__decap_12
XFILLER_151_529 VPWR VGND VPWR VGND sky130_ef_sc_hd__decap_12
XFILLER_144_581 VGND VGND VPWR VPWR sky130_fd_sc_hd__decap_6
XFILLER_89_101 VGND VGND VPWR VPWR sky130_fd_sc_hd__decap_8
XFILLER_120_905 VGND VGND VPWR VPWR sky130_fd_sc_hd__decap_4
XFILLER_104_445 VPWR VGND VPWR VGND sky130_ef_sc_hd__decap_12
XFILLER_133_55 VGND VGND VPWR VPWR sky130_fd_sc_hd__fill_1
XFILLER_93_15 VGND VGND VPWR VPWR sky130_fd_sc_hd__decap_6
XFILLER_85_373 VPWR VGND VPWR VGND sky130_ef_sc_hd__decap_12
XFILLER_46_749 VGND VGND VPWR VPWR sky130_fd_sc_hd__decap_6
Xclkbuf_3_6__f_clk clknet_0_clk VGND VGND VPWR VPWR clknet_3_6__leaf_clk sky130_fd_sc_hd__clkbuf_16
XFILLER_14_613 VPWR VGND VPWR VGND sky130_ef_sc_hd__decap_12
XFILLER_26_53 VPWR VGND VPWR VGND sky130_ef_sc_hd__decap_12
XANTENNA__2642__A1 OpSel_reg\[0\] VGND VGND VPWR VPWR sky130_fd_sc_hd__diode_2
XFILLER_53_281 VPWR VGND VPWR VGND sky130_ef_sc_hd__decap_12
XFILLER_14_657 VPWR VGND VPWR VGND sky130_ef_sc_hd__decap_12
XFILLER_26_97 VPWR VGND VPWR VGND sky130_ef_sc_hd__decap_12
XFILLER_41_421 VPWR VGND VPWR VGND sky130_ef_sc_hd__decap_12
XFILLER_9_105 VGND VGND VPWR VPWR sky130_fd_sc_hd__decap_6
XFILLER_13_167 VGND VGND VPWR VPWR sky130_fd_sc_hd__fill_1
XFILLER_9_149 VPWR VGND VPWR VGND sky130_ef_sc_hd__decap_12
XFILLER_42_41 VPWR VGND VPWR VGND sky130_ef_sc_hd__decap_12
XFILLER_42_85 VPWR VGND VPWR VGND sky130_ef_sc_hd__decap_12
XFILLER_127_559 VGND VGND VPWR VPWR sky130_fd_sc_hd__fill_1
XFILLER_114_209 VPWR VGND VPWR VGND sky130_ef_sc_hd__decap_12
XFILLER_6_867 VGND VGND VPWR VPWR sky130_fd_sc_hd__fill_1
XFILLER_123_721 VGND VGND VPWR VPWR sky130_fd_sc_hd__decap_6
XFILLER_107_261 VPWR VGND VPWR VGND sky130_ef_sc_hd__decap_12
XTAP_TAPCELL_ROW_75_1532 VGND VPWR sky130_fd_sc_hd__tapvpwrvgnd_1
XFILLER_5_377 VGND VGND VPWR VPWR sky130_fd_sc_hd__decap_6
XFILLER_123_765 VPWR VGND VPWR VGND sky130_ef_sc_hd__decap_12
XANTENNA__1725__A A_reg\[0\] VGND VGND VPWR VPWR sky130_fd_sc_hd__diode_2
XFILLER_122_253 VPWR VGND VPWR VGND sky130_ef_sc_hd__decap_12
XFILLER_1_561 VPWR VGND VPWR VGND sky130_ef_sc_hd__decap_12
XFILLER_95_137 VPWR VGND VPWR VGND sky130_ef_sc_hd__decap_12
XFILLER_77_841 VPWR VGND VPWR VGND sky130_ef_sc_hd__decap_12
XFILLER_3_57 VPWR VGND VPWR VGND sky130_ef_sc_hd__decap_12
XFILLER_92_811 VGND VGND VPWR VPWR sky130_fd_sc_hd__fill_1
XFILLER_76_340 VPWR VGND VPWR VGND sky130_ef_sc_hd__decap_12
XTAP_TAPCELL_ROW_106_2031 VGND VPWR sky130_fd_sc_hd__tapvpwrvgnd_1
XTAP_TAPCELL_ROW_106_2020 VGND VPWR sky130_fd_sc_hd__tapvpwrvgnd_1
XFILLER_49_598 VPWR VGND VPWR VGND sky130_ef_sc_hd__decap_12
XFILLER_36_215 VGND VGND VPWR VPWR sky130_fd_sc_hd__fill_1
XFILLER_37_727 VGND VGND VPWR VPWR sky130_fd_sc_hd__fill_1
XFILLER_17_440 VGND VGND VPWR VPWR sky130_fd_sc_hd__decap_8
XFILLER_91_387 VGND VGND VPWR VPWR sky130_fd_sc_hd__decap_4
XFILLER_17_473 VPWR VGND VPWR VGND sky130_ef_sc_hd__decap_12
XFILLER_32_421 VPWR VGND VPWR VGND sky130_ef_sc_hd__decap_12
XFILLER_80_3 VPWR VGND VPWR VGND sky130_ef_sc_hd__decap_12
XFILLER_146_813 VPWR VGND VPWR VGND sky130_ef_sc_hd__decap_12
X_2723_ a_r3\[2\] b_r3\[3\] VGND VGND VPWR VPWR _0463_ sky130_fd_sc_hd__nand2_1
X_2654_ a_r3\[3\] _0393_ VGND VGND VPWR VPWR _0394_ sky130_fd_sc_hd__nor2_1
XFILLER_133_529 VPWR VGND VPWR VGND sky130_ef_sc_hd__decap_12
XFILLER_126_581 VGND VGND VPWR VPWR sky130_fd_sc_hd__decap_6
X_2585_ _0328_ _0329_ b_r2\[2\] VGND VGND VPWR VPWR _0330_ sky130_fd_sc_hd__a21o_1
X_1605_ b_r1\[1\] VGND VGND VPWR VPWR _0885_ sky130_fd_sc_hd__inv_2
XFILLER_102_905 VGND VGND VPWR VPWR sky130_fd_sc_hd__decap_4
XANTENNA__1635__A _0912_ VGND VGND VPWR VPWR sky130_fd_sc_hd__diode_2
XFILLER_141_573 VPWR VGND VPWR VGND sky130_ef_sc_hd__decap_12
XFILLER_99_498 VGND VGND VPWR VPWR sky130_fd_sc_hd__decap_6
XFILLER_87_649 VGND VGND VPWR VPWR sky130_fd_sc_hd__fill_2
X_3206_ CRT_Start _0857_ _0883_ _0882_ VGND VGND VPWR VPWR _0099_ sky130_fd_sc_hd__a31o_1
XFILLER_95_671 VGND VGND VPWR VPWR sky130_fd_sc_hd__fill_1
XFILLER_94_170 VGND VGND VPWR VPWR sky130_fd_sc_hd__decap_3
XFILLER_83_833 VGND VGND VPWR VPWR sky130_fd_sc_hd__decap_6
X_3137_ _0822_ _0823_ VGND VGND VPWR VPWR _0825_ sky130_fd_sc_hd__nand2_1
XFILLER_55_524 VPWR VGND VPWR VGND sky130_ef_sc_hd__decap_12
XFILLER_55_502 VGND VGND VPWR VPWR sky130_fd_sc_hd__fill_2
XFILLER_28_749 VGND VGND VPWR VPWR sky130_fd_sc_hd__decap_6
XFILLER_83_877 VPWR VGND VPWR VGND sky130_ef_sc_hd__decap_12
XFILLER_82_321 VGND VGND VPWR VPWR sky130_fd_sc_hd__decap_6
XTAP_TAPCELL_ROW_2_369 VGND VPWR sky130_fd_sc_hd__tapvpwrvgnd_1
XTAP_TAPCELL_ROW_2_358 VGND VPWR sky130_fd_sc_hd__tapvpwrvgnd_1
XPHY_EDGE_ROW_118_Right_118 VGND VGND VPWR VPWR sky130_fd_sc_hd__decap_3
XFILLER_103_69 VPWR VGND VPWR VGND sky130_ef_sc_hd__decap_12
XFILLER_82_365 VGND VGND VPWR VPWR sky130_fd_sc_hd__fill_1
XFILLER_70_527 VGND VGND VPWR VPWR sky130_fd_sc_hd__decap_4
X_3068_ _0749_ _0755_ VGND VGND VPWR VPWR _0756_ sky130_fd_sc_hd__nand2_1
X_2019_ _1276_ _1277_ _1279_ B_reg\[9\] VGND VGND VPWR VPWR _1281_ sky130_fd_sc_hd__o2bb2a_1
XFILLER_51_741 VPWR VGND VPWR VGND sky130_ef_sc_hd__decap_12
XFILLER_35_281 VGND VGND VPWR VPWR sky130_fd_sc_hd__decap_8
XFILLER_36_793 VPWR VGND VPWR VGND sky130_ef_sc_hd__decap_12
XTAP_TAPCELL_ROW_42_1008 VGND VPWR sky130_fd_sc_hd__tapvpwrvgnd_1
XTAP_TAPCELL_ROW_137_2525 VGND VPWR sky130_fd_sc_hd__tapvpwrvgnd_1
XFILLER_149_673 VPWR VGND VPWR VGND sky130_ef_sc_hd__decap_12
XFILLER_136_301 VGND VGND VPWR VPWR sky130_fd_sc_hd__decap_6
XTAP_TAPCELL_ROW_21_666 VGND VPWR sky130_fd_sc_hd__tapvpwrvgnd_1
XFILLER_152_805 VGND VGND VPWR VPWR sky130_fd_sc_hd__decap_6
XTAP_TAPCELL_ROW_150_2736 VGND VPWR sky130_fd_sc_hd__tapvpwrvgnd_1
XTAP_TAPCELL_ROW_150_2725 VGND VPWR sky130_fd_sc_hd__tapvpwrvgnd_1
XFILLER_136_345 VPWR VGND VPWR VGND sky130_ef_sc_hd__decap_12
XFILLER_12_77 VGND VGND VPWR VPWR sky130_fd_sc_hd__decap_6
XFILLER_152_849 VPWR VGND VPWR VGND sky130_ef_sc_hd__decap_12
XFILLER_136_389 VPWR VGND VPWR VGND sky130_ef_sc_hd__decap_12
XFILLER_128_77 VGND VGND VPWR VPWR sky130_fd_sc_hd__decap_6
XFILLER_105_721 VGND VGND VPWR VPWR sky130_fd_sc_hd__decap_6
XFILLER_88_15 VPWR VGND VPWR VGND sky130_ef_sc_hd__decap_12
XFILLER_151_337 VPWR VGND VPWR VGND sky130_ef_sc_hd__decap_12
XTAP_TAPCELL_ROW_57_1251 VGND VPWR sky130_fd_sc_hd__tapvpwrvgnd_1
XTAP_TAPCELL_ROW_57_1240 VGND VPWR sky130_fd_sc_hd__tapvpwrvgnd_1
XFILLER_120_713 VPWR VGND VPWR VGND sky130_ef_sc_hd__decap_12
XFILLER_105_765 VPWR VGND VPWR VGND sky130_ef_sc_hd__decap_12
XFILLER_104_253 VPWR VGND VPWR VGND sky130_ef_sc_hd__decap_12
XANTENNA__2560__B1 _0184_ VGND VGND VPWR VPWR sky130_fd_sc_hd__diode_2
XFILLER_144_65 VPWR VGND VPWR VGND sky130_ef_sc_hd__decap_12
XFILLER_120_757 VPWR VGND VPWR VGND sky130_ef_sc_hd__decap_12
XFILLER_78_649 VGND VGND VPWR VPWR sky130_fd_sc_hd__fill_1
XTAP_TAPCELL_ROW_70_1451 VGND VPWR sky130_fd_sc_hd__tapvpwrvgnd_1
XFILLER_59_841 VPWR VGND VPWR VGND sky130_ef_sc_hd__decap_12
XFILLER_59_830 VGND VGND VPWR VPWR sky130_fd_sc_hd__decap_8
XTAP_TAPCELL_ROW_148_2698 VGND VPWR sky130_fd_sc_hd__tapvpwrvgnd_1
XFILLER_58_351 VPWR VGND VPWR VGND sky130_ef_sc_hd__decap_12
XFILLER_86_682 VPWR VGND VPWR VGND sky130_ef_sc_hd__decap_12
XFILLER_19_727 VGND VGND VPWR VPWR sky130_fd_sc_hd__fill_1
XFILLER_46_557 VGND VGND VPWR VPWR sky130_fd_sc_hd__decap_4
XFILLER_73_354 VPWR VGND VPWR VGND sky130_ef_sc_hd__decap_12
XFILLER_61_505 VPWR VGND VPWR VGND sky130_ef_sc_hd__decap_12
XTAP_TAPCELL_ROW_29_788 VGND VPWR sky130_fd_sc_hd__tapvpwrvgnd_1
XFILLER_14_421 VPWR VGND VPWR VGND sky130_ef_sc_hd__decap_12
XTAP_TAPCELL_ROW_29_799 VGND VPWR sky130_fd_sc_hd__tapvpwrvgnd_1
XFILLER_42_730 VGND VGND VPWR VPWR sky130_fd_sc_hd__fill_1
XFILLER_53_40 VGND VGND VPWR VPWR sky130_fd_sc_hd__decap_4
XFILLER_42_774 VPWR VGND VPWR VGND sky130_ef_sc_hd__decap_12
XFILLER_146_109 VPWR VGND VPWR VGND sky130_ef_sc_hd__decap_12
XFILLER_128_813 VPWR VGND VPWR VGND sky130_ef_sc_hd__decap_12
XTAP_TAPCELL_ROW_40_964 VGND VPWR sky130_fd_sc_hd__tapvpwrvgnd_1
XFILLER_139_161 VGND VGND VPWR VPWR sky130_fd_sc_hd__decap_6
XTAP_TAPCELL_ROW_40_975 VGND VPWR sky130_fd_sc_hd__tapvpwrvgnd_1
XFILLER_10_693 VGND VGND VPWR VPWR sky130_fd_sc_hd__decap_6
XFILLER_115_529 VPWR VGND VPWR VGND sky130_ef_sc_hd__decap_12
XFILLER_123_573 VPWR VGND VPWR VGND sky130_ef_sc_hd__decap_12
X_2370_ _0905_ _0120_ _0122_ VGND VGND VPWR VPWR _0124_ sky130_fd_sc_hd__and3_1
XTAP_TAPCELL_ROW_9_480 VGND VPWR sky130_fd_sc_hd__tapvpwrvgnd_1
XFILLER_2_881 VPWR VGND VPWR VGND sky130_ef_sc_hd__decap_12
XFILLER_110_245 VGND VGND VPWR VPWR sky130_fd_sc_hd__decap_6
XFILLER_96_457 VPWR VGND VPWR VGND sky130_ef_sc_hd__decap_12
XFILLER_1_391 VGND VGND VPWR VPWR sky130_fd_sc_hd__fill_1
XFILLER_110_289 VPWR VGND VPWR VGND sky130_ef_sc_hd__decap_12
XTAP_TAPCELL_ROW_88_1734 VGND VPWR sky130_fd_sc_hd__tapvpwrvgnd_1
XANTENNA__2286__A a_r3\[0\] VGND VGND VPWR VPWR sky130_fd_sc_hd__diode_2
XFILLER_65_833 VGND VGND VPWR VPWR sky130_fd_sc_hd__decap_6
XTAP_TAPCELL_ROW_88_1745 VGND VPWR sky130_fd_sc_hd__tapvpwrvgnd_1
XANTENNA__2854__A1 B_reg\[4\] VGND VGND VPWR VPWR sky130_fd_sc_hd__diode_2
XFILLER_64_321 VPWR VGND VPWR VGND sky130_ef_sc_hd__decap_12
XFILLER_80_825 VPWR VGND VPWR VGND sky130_ef_sc_hd__decap_12
XFILLER_65_877 VPWR VGND VPWR VGND sky130_ef_sc_hd__decap_12
XFILLER_64_365 VPWR VGND VPWR VGND sky130_ef_sc_hd__decap_12
XANTENNA__3263__RESET_B net36 VGND VGND VPWR VPWR sky130_fd_sc_hd__diode_2
XFILLER_80_869 VPWR VGND VPWR VGND sky130_ef_sc_hd__decap_12
XANTENNA__2606__A1 _0188_ VGND VGND VPWR VPWR sky130_fd_sc_hd__diode_2
XFILLER_17_270 VGND VGND VPWR VPWR sky130_fd_sc_hd__decap_8
XFILLER_17_281 VPWR VGND VPWR VGND sky130_ef_sc_hd__decap_12
XFILLER_18_793 VPWR VGND VPWR VGND sky130_ef_sc_hd__decap_12
XFILLER_33_741 VPWR VGND VPWR VGND sky130_ef_sc_hd__decap_12
XFILLER_20_413 VGND VGND VPWR VPWR sky130_fd_sc_hd__decap_6
XFILLER_33_785 VPWR VGND VPWR VGND sky130_ef_sc_hd__decap_12
XTAP_TAPCELL_ROW_119_2233 VGND VPWR sky130_fd_sc_hd__tapvpwrvgnd_1
XFILLER_118_301 VGND VGND VPWR VPWR sky130_fd_sc_hd__decap_6
XFILLER_20_468 VGND VGND VPWR VPWR sky130_fd_sc_hd__decap_8
XFILLER_146_643 VGND VGND VPWR VPWR sky130_fd_sc_hd__fill_1
XFILLER_134_805 VGND VGND VPWR VPWR sky130_fd_sc_hd__decap_6
XFILLER_118_345 VPWR VGND VPWR VGND sky130_ef_sc_hd__decap_12
X_2706_ a_r3\[2\] b_r3\[1\] _0445_ VGND VGND VPWR VPWR _0446_ sky130_fd_sc_hd__nand3_1
XFILLER_134_849 VPWR VGND VPWR VGND sky130_ef_sc_hd__decap_12
XTAP_TAPCELL_ROW_132_2444 VGND VPWR sky130_fd_sc_hd__tapvpwrvgnd_1
XFILLER_118_389 VPWR VGND VPWR VGND sky130_ef_sc_hd__decap_12
X_2637_ _0368_ _0377_ VGND VGND VPWR VPWR _0381_ sky130_fd_sc_hd__nand2_1
XPHY_EDGE_ROW_12_Right_12 VGND VGND VPWR VPWR sky130_fd_sc_hd__decap_3
XFILLER_133_337 VPWR VGND VPWR VGND sky130_ef_sc_hd__decap_12
XANTENNA__3272__CLK clknet_3_5__leaf_clk VGND VGND VPWR VPWR sky130_fd_sc_hd__diode_2
XFILLER_102_713 VPWR VGND VPWR VGND sky130_ef_sc_hd__decap_12
X_2568_ a_r2\[2\] b_r2\[2\] VGND VGND VPWR VPWR _0313_ sky130_fd_sc_hd__and2_1
XFILLER_58_29 VGND VGND VPWR VPWR sky130_fd_sc_hd__decap_3
XTAP_TAPCELL_ROW_7_439 VGND VPWR sky130_fd_sc_hd__tapvpwrvgnd_1
XFILLER_142_893 VPWR VGND VPWR VGND sky130_ef_sc_hd__decap_12
XFILLER_101_223 VGND VGND VPWR VPWR sky130_fd_sc_hd__fill_1
XFILLER_87_446 VGND VGND VPWR VPWR sky130_fd_sc_hd__fill_2
XFILLER_59_126 VPWR VGND VPWR VGND sky130_ef_sc_hd__decap_12
X_2499_ _0233_ _0245_ b_r1\[2\] VGND VGND VPWR VPWR _0247_ sky130_fd_sc_hd__nor3b_1
XFILLER_102_757 VPWR VGND VPWR VGND sky130_ef_sc_hd__decap_12
XFILLER_56_811 VGND VGND VPWR VPWR sky130_fd_sc_hd__fill_1
XTAP_TAPCELL_ROW_52_1170 VGND VPWR sky130_fd_sc_hd__tapvpwrvgnd_1
XFILLER_28_513 VPWR VGND VPWR VGND sky130_ef_sc_hd__decap_12
XFILLER_83_641 VPWR VGND VPWR VGND sky130_ef_sc_hd__decap_12
XFILLER_67_181 VPWR VGND VPWR VGND sky130_ef_sc_hd__decap_12
XFILLER_55_332 VGND VGND VPWR VPWR sky130_fd_sc_hd__decap_4
XANTENNA__2845__A1 A_reg\[11\] VGND VGND VPWR VPWR sky130_fd_sc_hd__diode_2
XFILLER_28_557 VPWR VGND VPWR VGND sky130_ef_sc_hd__decap_12
XFILLER_83_685 VPWR VGND VPWR VGND sky130_ef_sc_hd__decap_12
XPHY_EDGE_ROW_21_Right_21 VGND VGND VPWR VPWR sky130_fd_sc_hd__decap_3
XFILLER_43_516 VPWR VGND VPWR VGND sky130_ef_sc_hd__decap_12
XTAP_TAPCELL_ROW_26_747 VGND VPWR sky130_fd_sc_hd__tapvpwrvgnd_1
XFILLER_70_357 VGND VGND VPWR VPWR sky130_fd_sc_hd__decap_6
XFILLER_128_109 VPWR VGND VPWR VGND sky130_ef_sc_hd__decap_12
XFILLER_11_457 VPWR VGND VPWR VGND sky130_ef_sc_hd__decap_12
XFILLER_128_3 VPWR VGND VPWR VGND sky130_ef_sc_hd__decap_12
XFILLER_7_428 VPWR VGND VPWR VGND sky130_ef_sc_hd__decap_12
XFILLER_137_665 VGND VGND VPWR VPWR sky130_fd_sc_hd__decap_6
XPHY_EDGE_ROW_30_Right_30 VGND VGND VPWR VPWR sky130_fd_sc_hd__decap_3
XFILLER_152_613 VPWR VGND VPWR VGND sky130_ef_sc_hd__decap_12
XFILLER_136_153 VPWR VGND VPWR VGND sky130_ef_sc_hd__decap_12
XFILLER_99_69 VPWR VGND VPWR VGND sky130_ef_sc_hd__decap_12
XFILLER_152_657 VPWR VGND VPWR VGND sky130_ef_sc_hd__decap_12
XFILLER_136_197 VPWR VGND VPWR VGND sky130_ef_sc_hd__decap_12
XFILLER_151_167 VGND VGND VPWR VPWR sky130_fd_sc_hd__fill_1
XFILLER_2_133 VGND VGND VPWR VPWR sky130_fd_sc_hd__decap_6
XFILLER_105_584 VPWR VGND VPWR VGND sky130_ef_sc_hd__decap_12
XFILLER_2_177 VPWR VGND VPWR VGND sky130_ef_sc_hd__decap_12
XFILLER_93_405 VPWR VGND VPWR VGND sky130_ef_sc_hd__decap_12
XFILLER_78_457 VPWR VGND VPWR VGND sky130_ef_sc_hd__decap_12
XFILLER_120_587 VGND VGND VPWR VPWR sky130_fd_sc_hd__fill_1
XFILLER_47_833 VGND VGND VPWR VPWR sky130_fd_sc_hd__decap_6
XANTENNA__2836__A1 A_reg\[2\] VGND VGND VPWR VPWR sky130_fd_sc_hd__diode_2
XFILLER_47_855 VPWR VGND VPWR VGND sky130_ef_sc_hd__decap_12
XFILLER_46_321 VPWR VGND VPWR VGND sky130_ef_sc_hd__decap_12
XFILLER_62_825 VPWR VGND VPWR VGND sky130_ef_sc_hd__decap_12
XFILLER_0_69 VPWR VGND VPWR VGND sky130_ef_sc_hd__decap_12
XFILLER_46_365 VPWR VGND VPWR VGND sky130_ef_sc_hd__decap_12
XTAP_TAPCELL_ROW_83_1664 VGND VPWR sky130_fd_sc_hd__tapvpwrvgnd_1
XTAP_TAPCELL_ROW_83_1653 VGND VPWR sky130_fd_sc_hd__tapvpwrvgnd_1
XFILLER_15_741 VPWR VGND VPWR VGND sky130_ef_sc_hd__decap_12
XFILLER_15_785 VPWR VGND VPWR VGND sky130_ef_sc_hd__decap_12
XFILLER_30_755 VGND VGND VPWR VPWR sky130_fd_sc_hd__fill_1
X_1870_ _1139_ _0894_ _1137_ VGND VGND VPWR VPWR _1140_ sky130_fd_sc_hd__mux2_1
XFILLER_147_429 VPWR VGND VPWR VGND sky130_ef_sc_hd__decap_12
XFILLER_128_643 VGND VGND VPWR VPWR sky130_fd_sc_hd__fill_1
XFILLER_116_805 VGND VGND VPWR VPWR sky130_fd_sc_hd__decap_6
XANTENNA__3295__CLK clknet_3_2__leaf_clk VGND VGND VPWR VPWR sky130_fd_sc_hd__diode_2
XFILLER_116_849 VPWR VGND VPWR VGND sky130_ef_sc_hd__decap_12
XFILLER_115_337 VPWR VGND VPWR VGND sky130_ef_sc_hd__decap_12
XTAP_TAPCELL_ROW_114_2163 VGND VPWR sky130_fd_sc_hd__tapvpwrvgnd_1
XTAP_TAPCELL_ROW_114_2152 VGND VPWR sky130_fd_sc_hd__tapvpwrvgnd_1
XFILLER_130_307 VGND VGND VPWR VPWR sky130_fd_sc_hd__fill_1
X_2422_ _0897_ _0174_ _0175_ VGND VGND VPWR VPWR _0176_ sky130_fd_sc_hd__nand3_1
XFILLER_43_3 VPWR VGND VPWR VGND sky130_ef_sc_hd__decap_12
XFILLER_142_189 VGND VGND VPWR VPWR sky130_fd_sc_hd__decap_6
XFILLER_124_893 VPWR VGND VPWR VGND sky130_ef_sc_hd__decap_12
XFILLER_96_221 VPWR VGND VPWR VGND sky130_ef_sc_hd__decap_12
X_2353_ _1595_ _1600_ _1598_ VGND VGND VPWR VPWR _0107_ sky130_fd_sc_hd__a21bo_1
XFILLER_69_413 VGND VGND VPWR VPWR sky130_fd_sc_hd__fill_2
XFILLER_97_777 VGND VGND VPWR VPWR sky130_fd_sc_hd__decap_6
XFILLER_96_265 VPWR VGND VPWR VGND sky130_ef_sc_hd__decap_12
X_2284_ A_reg\[0\] _1540_ VGND VGND VPWR VPWR _1541_ sky130_fd_sc_hd__or2_1
XFILLER_38_811 VGND VGND VPWR VPWR sky130_fd_sc_hd__fill_1
XFILLER_96_298 VGND VGND VPWR VPWR sky130_fd_sc_hd__fill_1
XFILLER_49_181 VPWR VGND VPWR VGND sky130_ef_sc_hd__decap_12
XFILLER_25_505 VPWR VGND VPWR VGND sky130_ef_sc_hd__decap_12
XFILLER_64_195 VGND VGND VPWR VPWR sky130_fd_sc_hd__fill_1
XFILLER_64_184 VGND VGND VPWR VPWR sky130_fd_sc_hd__decap_6
XFILLER_100_15 VPWR VGND VPWR VGND sky130_ef_sc_hd__decap_12
XFILLER_80_699 VGND VGND VPWR VPWR sky130_fd_sc_hd__fill_1
XFILLER_61_880 VGND VGND VPWR VPWR sky130_fd_sc_hd__decap_3
XTAP_TAPCELL_ROW_23_706 VGND VPWR sky130_fd_sc_hd__tapvpwrvgnd_1
XFILLER_20_221 VPWR VGND VPWR VGND sky130_ef_sc_hd__decap_12
XFILLER_20_265 VPWR VGND VPWR VGND sky130_ef_sc_hd__decap_12
XFILLER_21_777 VGND VGND VPWR VPWR sky130_fd_sc_hd__decap_6
XFILLER_119_665 VGND VGND VPWR VPWR sky130_fd_sc_hd__decap_6
X_1999_ B_reg\[12\] _1259_ _1257_ _1176_ VGND VGND VPWR VPWR _1261_ sky130_fd_sc_hd__o211ai_1
XFILLER_134_613 VPWR VGND VPWR VGND sky130_ef_sc_hd__decap_12
XFILLER_118_153 VPWR VGND VPWR VGND sky130_ef_sc_hd__decap_12
XFILLER_134_657 VPWR VGND VPWR VGND sky130_ef_sc_hd__decap_12
XFILLER_118_197 VPWR VGND VPWR VGND sky130_ef_sc_hd__decap_12
XFILLER_109_57 VPWR VGND VPWR VGND sky130_ef_sc_hd__decap_12
XFILLER_133_167 VGND VGND VPWR VPWR sky130_fd_sc_hd__fill_1
XFILLER_121_329 VGND VGND VPWR VPWR sky130_fd_sc_hd__decap_6
XFILLER_88_755 VGND VGND VPWR VPWR sky130_fd_sc_hd__fill_1
XANTENNA__1823__A A_reg\[1\] VGND VGND VPWR VPWR sky130_fd_sc_hd__diode_2
XTAP_TAPCELL_ROW_145_2646 VGND VPWR sky130_fd_sc_hd__tapvpwrvgnd_1
XFILLER_75_405 VPWR VGND VPWR VGND sky130_ef_sc_hd__decap_12
XTAP_TAPCELL_ROW_50_1129 VGND VPWR sky130_fd_sc_hd__tapvpwrvgnd_1
XTAP_TAPCELL_ROW_145_2657 VGND VPWR sky130_fd_sc_hd__tapvpwrvgnd_1
XFILLER_91_909 VGND VGND VPWR VPWR sky130_fd_sc_hd__fill_1
XFILLER_75_449 VPWR VGND VPWR VGND sky130_ef_sc_hd__decap_12
XFILLER_56_641 VGND VGND VPWR VPWR sky130_fd_sc_hd__decap_3
XFILLER_29_833 VGND VGND VPWR VPWR sky130_fd_sc_hd__decap_6
XFILLER_141_55 VGND VGND VPWR VPWR sky130_fd_sc_hd__fill_1
XFILLER_71_600 VPWR VGND VPWR VGND sky130_ef_sc_hd__decap_12
XFILLER_18_65 VPWR VGND VPWR VGND sky130_ef_sc_hd__decap_12
XFILLER_28_365 VPWR VGND VPWR VGND sky130_ef_sc_hd__decap_12
XFILLER_29_877 VPWR VGND VPWR VGND sky130_ef_sc_hd__decap_12
XFILLER_44_825 VPWR VGND VPWR VGND sky130_ef_sc_hd__decap_12
XANTENNA__2654__A a_r3\[3\] VGND VGND VPWR VPWR sky130_fd_sc_hd__diode_2
XFILLER_43_324 VGND VGND VPWR VPWR sky130_fd_sc_hd__fill_1
XFILLER_43_335 VGND VGND VPWR VPWR sky130_fd_sc_hd__fill_1
XFILLER_43_346 VGND VGND VPWR VPWR sky130_fd_sc_hd__decap_8
XFILLER_44_869 VPWR VGND VPWR VGND sky130_ef_sc_hd__decap_12
XTAP_TAPCELL_ROW_65_1372 VGND VPWR sky130_fd_sc_hd__tapvpwrvgnd_1
XFILLER_34_53 VPWR VGND VPWR VGND sky130_ef_sc_hd__decap_12
XFILLER_12_755 VGND VGND VPWR VPWR sky130_fd_sc_hd__fill_1
XFILLER_34_97 VPWR VGND VPWR VGND sky130_ef_sc_hd__decap_12
XFILLER_129_429 VPWR VGND VPWR VGND sky130_ef_sc_hd__decap_12
XFILLER_8_737 VPWR VGND VPWR VGND sky130_ef_sc_hd__decap_12
XFILLER_7_225 VPWR VGND VPWR VGND sky130_ef_sc_hd__decap_12
XFILLER_137_473 VPWR VGND VPWR VGND sky130_ef_sc_hd__decap_12
XFILLER_50_85 VGND VGND VPWR VPWR sky130_fd_sc_hd__fill_1
XFILLER_50_74 VGND VGND VPWR VPWR sky130_fd_sc_hd__decap_8
XFILLER_152_421 VPWR VGND VPWR VGND sky130_ef_sc_hd__decap_12
XFILLER_112_307 VGND VGND VPWR VPWR sky130_fd_sc_hd__fill_1
XFILLER_124_189 VGND VGND VPWR VPWR sky130_fd_sc_hd__decap_6
XFILLER_106_893 VPWR VGND VPWR VGND sky130_ef_sc_hd__decap_12
XFILLER_121_841 VPWR VGND VPWR VGND sky130_ef_sc_hd__decap_12
XFILLER_94_725 VPWR VGND VPWR VGND sky130_ef_sc_hd__decap_12
XFILLER_78_287 VPWR VGND VPWR VGND sky130_ef_sc_hd__decap_12
XFILLER_94_769 VPWR VGND VPWR VGND sky130_ef_sc_hd__decap_12
XFILLER_82_909 VGND VGND VPWR VPWR sky130_fd_sc_hd__fill_1
XFILLER_66_438 VGND VGND VPWR VPWR sky130_fd_sc_hd__decap_4
XFILLER_47_641 VPWR VGND VPWR VGND sky130_ef_sc_hd__decap_12
XFILLER_93_279 VGND VGND VPWR VPWR sky130_fd_sc_hd__fill_1
XFILLER_75_93 VPWR VGND VPWR VGND sky130_ef_sc_hd__decap_12
XFILLER_35_825 VPWR VGND VPWR VGND sky130_ef_sc_hd__decap_12
XFILLER_62_677 VPWR VGND VPWR VGND sky130_ef_sc_hd__decap_12
XFILLER_46_195 VGND VGND VPWR VPWR sky130_fd_sc_hd__fill_1
X_2971_ _0642_ _0644_ _0658_ VGND VGND VPWR VPWR _0659_ sky130_fd_sc_hd__o21ai_1
XFILLER_61_187 VGND VGND VPWR VPWR sky130_fd_sc_hd__fill_1
XFILLER_61_154 VPWR VGND VPWR VGND sky130_ef_sc_hd__decap_12
X_1922_ _0900_ _1173_ VGND VGND VPWR VPWR _1187_ sky130_fd_sc_hd__nor2_1
XTAP_TAPCELL_ROW_17_599 VGND VPWR sky130_fd_sc_hd__tapvpwrvgnd_1
XFILLER_148_749 VGND VGND VPWR VPWR sky130_fd_sc_hd__decap_6
X_1853_ A_reg\[10\] _1119_ _1122_ VGND VGND VPWR VPWR _1123_ sky130_fd_sc_hd__o21a_1
XFILLER_30_552 VPWR VGND VPWR VGND sky130_ef_sc_hd__decap_12
XFILLER_147_237 VPWR VGND VPWR VGND sky130_ef_sc_hd__decap_12
XFILLER_116_613 VPWR VGND VPWR VGND sky130_ef_sc_hd__decap_12
X_1784_ A_reg\[7\] _1047_ _1050_ _1054_ A_reg\[6\] VGND VGND VPWR VPWR _1057_ sky130_fd_sc_hd__a311o_1
XFILLER_116_657 VPWR VGND VPWR VGND sky130_ef_sc_hd__decap_12
XTAP_TAPCELL_ROW_96_1866 VGND VPWR sky130_fd_sc_hd__tapvpwrvgnd_1
XFILLER_115_167 VGND VGND VPWR VPWR sky130_fd_sc_hd__fill_1
XFILLER_103_329 VGND VGND VPWR VPWR sky130_fd_sc_hd__decap_6
X_2405_ _0145_ _0158_ VGND VGND VPWR VPWR _0159_ sky130_fd_sc_hd__xnor2_1
XFILLER_111_373 VPWR VGND VPWR VGND sky130_ef_sc_hd__decap_12
XFILLER_97_585 VPWR VGND VPWR VGND sky130_ef_sc_hd__decap_12
X_2336_ _1579_ _1588_ VGND VGND VPWR VPWR _1589_ sky130_fd_sc_hd__nand2_1
XANTENNA__3310__CLK clknet_3_7__leaf_clk VGND VGND VPWR VPWR sky130_fd_sc_hd__diode_2
XTAP_TAPCELL_ROW_127_2365 VGND VPWR sky130_fd_sc_hd__tapvpwrvgnd_1
XFILLER_73_909 VGND VGND VPWR VPWR sky130_fd_sc_hd__fill_1
XFILLER_69_298 VGND VGND VPWR VPWR sky130_fd_sc_hd__decap_3
XFILLER_57_449 VPWR VGND VPWR VGND sky130_ef_sc_hd__decap_12
X_2267_ A_reg\[2\] _1508_ _1519_ VGND VGND VPWR VPWR _1524_ sky130_fd_sc_hd__and3_1
XFILLER_72_419 VGND VGND VPWR VPWR sky130_fd_sc_hd__fill_1
X_2198_ _0891_ _1452_ VGND VGND VPWR VPWR _1455_ sky130_fd_sc_hd__xnor2_1
XFILLER_26_825 VPWR VGND VPWR VGND sky130_ef_sc_hd__decap_12
XTAP_TAPCELL_ROW_140_2576 VGND VPWR sky130_fd_sc_hd__tapvpwrvgnd_1
XTAP_TAPCELL_ROW_140_2565 VGND VPWR sky130_fd_sc_hd__tapvpwrvgnd_1
XFILLER_80_441 VGND VGND VPWR VPWR sky130_fd_sc_hd__fill_1
XFILLER_26_869 VPWR VGND VPWR VGND sky130_ef_sc_hd__decap_12
XFILLER_41_806 VGND VGND VPWR VPWR sky130_fd_sc_hd__decap_8
XFILLER_111_69 VPWR VGND VPWR VGND sky130_ef_sc_hd__decap_12
XFILLER_41_839 VGND VGND VPWR VPWR sky130_fd_sc_hd__fill_1
XFILLER_80_496 VPWR VGND VPWR VGND sky130_ef_sc_hd__decap_12
XTAP_TAPCELL_ROW_47_1091 VGND VPWR sky130_fd_sc_hd__tapvpwrvgnd_1
XFILLER_33_390 VGND VGND VPWR VPWR sky130_fd_sc_hd__fill_2
XFILLER_40_327 VPWR VGND VPWR VGND sky130_ef_sc_hd__decap_12
XTAP_TAPCELL_ROW_47_1080 VGND VPWR sky130_fd_sc_hd__tapvpwrvgnd_1
XFILLER_139_727 VGND VGND VPWR VPWR sky130_fd_sc_hd__fill_1
XFILLER_21_541 VPWR VGND VPWR VGND sky130_ef_sc_hd__decap_12
XFILLER_21_585 VPWR VGND VPWR VGND sky130_ef_sc_hd__decap_12
XFILLER_119_473 VPWR VGND VPWR VGND sky130_ef_sc_hd__decap_12
XTAP_TAPCELL_ROW_60_1291 VGND VPWR sky130_fd_sc_hd__tapvpwrvgnd_1
XFILLER_5_729 VPWR VGND VPWR VGND sky130_ef_sc_hd__decap_12
XFILLER_134_421 VPWR VGND VPWR VGND sky130_ef_sc_hd__decap_12
XFILLER_20_77 VGND VGND VPWR VPWR sky130_fd_sc_hd__decap_6
XFILLER_136_77 VGND VGND VPWR VPWR sky130_fd_sc_hd__decap_6
XFILLER_106_189 VGND VGND VPWR VPWR sky130_fd_sc_hd__decap_6
XFILLER_96_15 VPWR VGND VPWR VGND sky130_ef_sc_hd__decap_12
XFILLER_121_137 VPWR VGND VPWR VGND sky130_ef_sc_hd__decap_12
XFILLER_103_841 VPWR VGND VPWR VGND sky130_ef_sc_hd__decap_12
XFILLER_0_445 VGND VGND VPWR VPWR sky130_fd_sc_hd__decap_3
XFILLER_0_489 VPWR VGND VPWR VGND sky130_ef_sc_hd__decap_12
XFILLER_130_693 VGND VGND VPWR VPWR sky130_fd_sc_hd__decap_6
XFILLER_102_384 VPWR VGND VPWR VGND sky130_ef_sc_hd__decap_12
XFILLER_64_909 VGND VGND VPWR VPWR sky130_fd_sc_hd__fill_1
XFILLER_152_65 VPWR VGND VPWR VGND sky130_ef_sc_hd__decap_12
XFILLER_90_205 VGND VGND VPWR VPWR sky130_fd_sc_hd__fill_1
XFILLER_75_279 VGND VGND VPWR VPWR sky130_fd_sc_hd__fill_1
XTAP_TAPCELL_ROW_67_1401 VGND VPWR sky130_fd_sc_hd__tapvpwrvgnd_1
XFILLER_29_641 VPWR VGND VPWR VGND sky130_ef_sc_hd__decap_12
XFILLER_56_471 VGND VGND VPWR VPWR sky130_fd_sc_hd__decap_4
XFILLER_29_685 VPWR VGND VPWR VGND sky130_ef_sc_hd__decap_12
XFILLER_16_335 VPWR VGND VPWR VGND sky130_ef_sc_hd__decap_12
XFILLER_28_195 VGND VGND VPWR VPWR sky130_fd_sc_hd__fill_1
XTAP_TAPCELL_ROW_80_1612 VGND VPWR sky130_fd_sc_hd__tapvpwrvgnd_1
XFILLER_43_165 VGND VGND VPWR VPWR sky130_fd_sc_hd__fill_1
XFILLER_44_699 VGND VGND VPWR VPWR sky130_fd_sc_hd__fill_1
XFILLER_31_349 VPWR VGND VPWR VGND sky130_ef_sc_hd__decap_12
XFILLER_8_501 VPWR VGND VPWR VGND sky130_ef_sc_hd__decap_12
XTAP_TAPCELL_ROW_14_558 VGND VPWR sky130_fd_sc_hd__tapvpwrvgnd_1
XFILLER_129_237 VPWR VGND VPWR VGND sky130_ef_sc_hd__decap_12
XFILLER_61_95 VPWR VGND VPWR VGND sky130_ef_sc_hd__decap_12
XFILLER_8_545 VPWR VGND VPWR VGND sky130_ef_sc_hd__decap_12
XFILLER_8_589 VPWR VGND VPWR VGND sky130_ef_sc_hd__decap_12
XFILLER_153_741 VPWR VGND VPWR VGND sky130_ef_sc_hd__decap_12
XFILLER_138_793 VPWR VGND VPWR VGND sky130_ef_sc_hd__decap_12
XFILLER_137_281 VPWR VGND VPWR VGND sky130_ef_sc_hd__decap_12
XFILLER_152_251 VGND VGND VPWR VPWR sky130_fd_sc_hd__fill_1
XTAP_TAPCELL_ROW_111_2111 VGND VPWR sky130_fd_sc_hd__tapvpwrvgnd_1
XTAP_TAPCELL_ROW_111_2100 VGND VPWR sky130_fd_sc_hd__tapvpwrvgnd_1
XFILLER_98_305 VGND VGND VPWR VPWR sky130_fd_sc_hd__decap_3
XTAP_TAPCELL_ROW_78_1585 VGND VPWR sky130_fd_sc_hd__tapvpwrvgnd_1
XTAP_TAPCELL_ROW_78_1574 VGND VPWR sky130_fd_sc_hd__tapvpwrvgnd_1
XFILLER_153_785 VPWR VGND VPWR VGND sky130_ef_sc_hd__decap_12
XFILLER_140_413 VGND VGND VPWR VPWR sky130_fd_sc_hd__decap_6
XFILLER_99_839 VGND VGND VPWR VPWR sky130_fd_sc_hd__fill_1
XFILLER_140_457 VPWR VGND VPWR VGND sky130_ef_sc_hd__decap_12
XFILLER_121_671 VGND VGND VPWR VPWR sky130_fd_sc_hd__fill_1
XTAP_TAPCELL_ROW_91_1785 VGND VPWR sky130_fd_sc_hd__tapvpwrvgnd_1
XFILLER_67_725 VGND VGND VPWR VPWR sky130_fd_sc_hd__decap_3
X_3170_ _0828_ _0857_ VGND VGND VPWR VPWR _0858_ sky130_fd_sc_hd__and2_1
XFILLER_39_405 VGND VGND VPWR VPWR sky130_fd_sc_hd__fill_2
XFILLER_94_533 VPWR VGND VPWR VGND sky130_ef_sc_hd__decap_12
X_2121_ _0903_ _1377_ _1378_ _1379_ VGND VGND VPWR VPWR _1380_ sky130_fd_sc_hd__o211a_1
XFILLER_67_758 VGND VGND VPWR VPWR sky130_fd_sc_hd__fill_1
XFILLER_55_909 VGND VGND VPWR VPWR sky130_fd_sc_hd__fill_1
XFILLER_39_449 VPWR VGND VPWR VGND sky130_ef_sc_hd__decap_12
XTAP_TAPCELL_ROW_109_2073 VGND VPWR sky130_fd_sc_hd__tapvpwrvgnd_1
X_2052_ _1307_ _1312_ B_reg\[5\] VGND VGND VPWR VPWR _1314_ sky130_fd_sc_hd__a21oi_1
XFILLER_81_205 VPWR VGND VPWR VGND sky130_ef_sc_hd__decap_12
XFILLER_47_482 VGND VGND VPWR VPWR sky130_fd_sc_hd__decap_6
XFILLER_81_249 VPWR VGND VPWR VGND sky130_ef_sc_hd__decap_12
XFILLER_62_441 VGND VGND VPWR VPWR sky130_fd_sc_hd__decap_3
XFILLER_34_121 VPWR VGND VPWR VGND sky130_ef_sc_hd__decap_12
XTAP_TAPCELL_ROW_122_2284 VGND VPWR sky130_fd_sc_hd__tapvpwrvgnd_1
XFILLER_62_485 VGND VGND VPWR VPWR sky130_fd_sc_hd__fill_1
XFILLER_23_839 VGND VGND VPWR VPWR sky130_fd_sc_hd__fill_1
XFILLER_34_165 VPWR VGND VPWR VGND sky130_ef_sc_hd__decap_12
XFILLER_148_513 VPWR VGND VPWR VGND sky130_ef_sc_hd__decap_12
X_2954_ _0629_ _0641_ VGND VGND VPWR VPWR _0642_ sky130_fd_sc_hd__and2_1
XFILLER_50_669 VGND VGND VPWR VPWR sky130_fd_sc_hd__decap_8
XANTENNA__1769__A1 A_reg\[9\] VGND VGND VPWR VPWR sky130_fd_sc_hd__diode_2
XTAP_TAPCELL_ROW_33_856 VGND VPWR sky130_fd_sc_hd__tapvpwrvgnd_1
XTAP_TAPCELL_ROW_33_867 VGND VPWR sky130_fd_sc_hd__tapvpwrvgnd_1
XFILLER_148_557 VPWR VGND VPWR VGND sky130_ef_sc_hd__decap_12
XTAP_TAPCELL_ROW_98_1906 VGND VPWR sky130_fd_sc_hd__tapvpwrvgnd_1
X_2885_ u_crt.r2\[1\] u_crt.r2\[0\] u_crt.r2\[2\] VGND VGND VPWR VPWR _0573_ sky130_fd_sc_hd__a21bo_1
X_1905_ B_reg\[15\] B_reg\[14\] B_reg\[13\] VGND VGND VPWR VPWR _1170_ sky130_fd_sc_hd__and3b_1
XANTENNA__1638__A A_reg\[13\] VGND VGND VPWR VPWR sky130_fd_sc_hd__diode_2
XFILLER_30_371 VGND VGND VPWR VPWR sky130_fd_sc_hd__fill_1
XFILLER_31_894 VGND VGND VPWR VPWR sky130_fd_sc_hd__fill_2
XPHY_EDGE_ROW_6_Right_6 VGND VGND VPWR VPWR sky130_fd_sc_hd__decap_3
X_1836_ _1107_ _1108_ a_r1\[0\] Encode_EN VGND VGND VPWR VPWR _0003_ sky130_fd_sc_hd__o2bb2a_1
XFILLER_116_421 VPWR VGND VPWR VGND sky130_ef_sc_hd__decap_12
XANTENNA__2718__B1 _0186_ VGND VGND VPWR VPWR sky130_fd_sc_hd__diode_2
X_1767_ _1031_ _1038_ _1039_ VGND VGND VPWR VPWR _1040_ sky130_fd_sc_hd__o21ai_1
XFILLER_143_273 VGND VGND VPWR VPWR sky130_fd_sc_hd__decap_6
X_1698_ _0971_ _0973_ A_reg\[4\] VGND VGND VPWR VPWR _0974_ sky130_fd_sc_hd__o21a_1
XFILLER_103_137 VPWR VGND VPWR VGND sky130_ef_sc_hd__decap_12
XFILLER_98_861 VGND VGND VPWR VPWR sky130_fd_sc_hd__decap_6
XFILLER_89_349 VPWR VGND VPWR VGND sky130_ef_sc_hd__decap_12
XANTENNA__2469__A a_r1\[0\] VGND VGND VPWR VPWR sky130_fd_sc_hd__diode_2
XFILLER_100_811 VGND VGND VPWR VPWR sky130_fd_sc_hd__fill_1
XFILLER_112_693 VGND VGND VPWR VPWR sky130_fd_sc_hd__decap_6
XFILLER_111_181 VPWR VGND VPWR VGND sky130_ef_sc_hd__decap_12
XFILLER_97_393 VPWR VGND VPWR VGND sky130_ef_sc_hd__decap_12
X_2319_ _0900_ _1566_ _1568_ VGND VGND VPWR VPWR _1572_ sky130_fd_sc_hd__and3_1
XTAP_TAPCELL_ROW_142_2605 VGND VPWR sky130_fd_sc_hd__tapvpwrvgnd_1
X_3299_ clknet_3_2__leaf_clk _0082_ net36 VGND VGND VPWR VPWR B_reg\[9\] sky130_fd_sc_hd__dfrtp_4
XFILLER_58_769 VPWR VGND VPWR VGND sky130_ef_sc_hd__decap_12
XTAP_TAPCELL_ROW_49_1120 VGND VPWR sky130_fd_sc_hd__tapvpwrvgnd_1
XFILLER_38_482 VGND VGND VPWR VPWR sky130_fd_sc_hd__fill_1
XFILLER_53_441 VGND VGND VPWR VPWR sky130_fd_sc_hd__decap_4
XFILLER_81_783 VGND VGND VPWR VPWR sky130_fd_sc_hd__fill_1
XFILLER_26_699 VGND VGND VPWR VPWR sky130_fd_sc_hd__fill_1
XTAP_TAPCELL_ROW_62_1331 VGND VPWR sky130_fd_sc_hd__tapvpwrvgnd_1
XTAP_TAPCELL_ROW_62_1320 VGND VPWR sky130_fd_sc_hd__tapvpwrvgnd_1
XFILLER_15_55 VGND VGND VPWR VPWR sky130_fd_sc_hd__fill_1
XFILLER_22_861 VGND VGND VPWR VPWR sky130_fd_sc_hd__decap_6
XTAP_TAPCELL_ROW_11_506 VGND VPWR sky130_fd_sc_hd__tapvpwrvgnd_1
XFILLER_21_393 VPWR VGND VPWR VGND sky130_ef_sc_hd__decap_12
XTAP_TAPCELL_ROW_153_2789 VGND VPWR sky130_fd_sc_hd__tapvpwrvgnd_1
XTAP_TAPCELL_ROW_153_2778 VGND VPWR sky130_fd_sc_hd__tapvpwrvgnd_1
XFILLER_119_281 VPWR VGND VPWR VGND sky130_ef_sc_hd__decap_12
XFILLER_110_3 VPWR VGND VPWR VGND sky130_ef_sc_hd__decap_12
XFILLER_135_741 VPWR VGND VPWR VGND sky130_ef_sc_hd__decap_12
XFILLER_5_559 VGND VGND VPWR VPWR sky130_fd_sc_hd__fill_1
XFILLER_135_785 VPWR VGND VPWR VGND sky130_ef_sc_hd__decap_12
XFILLER_134_251 VGND VGND VPWR VPWR sky130_fd_sc_hd__fill_1
XFILLER_122_413 VGND VGND VPWR VPWR sky130_fd_sc_hd__decap_6
Xoutput43 net43 VGND VGND VPWR VPWR X_out[14] sky130_fd_sc_hd__buf_1
XFILLER_150_755 VGND VGND VPWR VPWR sky130_fd_sc_hd__fill_1
XFILLER_122_457 VPWR VGND VPWR VGND sky130_ef_sc_hd__decap_12
XFILLER_1_721 VGND VGND VPWR VPWR sky130_fd_sc_hd__decap_6
XFILLER_103_671 VGND VGND VPWR VPWR sky130_fd_sc_hd__fill_1
XTAP_TAPCELL_ROW_73_1493 VGND VPWR sky130_fd_sc_hd__tapvpwrvgnd_1
XFILLER_1_765 VPWR VGND VPWR VGND sky130_ef_sc_hd__decap_12
XANTENNA_input30_A B_in[7] VGND VGND VPWR VPWR sky130_fd_sc_hd__diode_2
XFILLER_76_533 VPWR VGND VPWR VGND sky130_ef_sc_hd__decap_12
XFILLER_49_747 VPWR VGND VPWR VGND sky130_ef_sc_hd__decap_12
XFILLER_37_909 VGND VGND VPWR VPWR sky130_fd_sc_hd__fill_1
XTAP_TAPCELL_ROW_19_628 VGND VPWR sky130_fd_sc_hd__tapvpwrvgnd_1
XTAP_TAPCELL_ROW_19_639 VGND VPWR sky130_fd_sc_hd__tapvpwrvgnd_1
XFILLER_16_121 VPWR VGND VPWR VGND sky130_ef_sc_hd__decap_12
XFILLER_60_901 VGND VGND VPWR VPWR sky130_fd_sc_hd__decap_6
XFILLER_16_165 VPWR VGND VPWR VGND sky130_ef_sc_hd__decap_12
XFILLER_71_293 VPWR VGND VPWR VGND sky130_ef_sc_hd__decap_12
XFILLER_31_113 VPWR VGND VPWR VGND sky130_ef_sc_hd__decap_12
XFILLER_32_625 VPWR VGND VPWR VGND sky130_ef_sc_hd__decap_12
XTAP_TAPCELL_ROW_30_804 VGND VPWR sky130_fd_sc_hd__tapvpwrvgnd_1
XFILLER_32_669 VPWR VGND VPWR VGND sky130_ef_sc_hd__decap_12
XPHY_EDGE_ROW_59_Right_59 VGND VGND VPWR VPWR sky130_fd_sc_hd__decap_3
XFILLER_9_821 VPWR VGND VPWR VGND sky130_ef_sc_hd__decap_12
XTAP_TAPCELL_ROW_30_815 VGND VPWR sky130_fd_sc_hd__tapvpwrvgnd_1
XFILLER_145_505 VPWR VGND VPWR VGND sky130_ef_sc_hd__decap_12
X_2670_ _0387_ _0409_ VGND VGND VPWR VPWR _0410_ sky130_fd_sc_hd__nand2_1
XFILLER_9_865 VPWR VGND VPWR VGND sky130_ef_sc_hd__decap_12
XANTENNA__3288__RESET_B net36 VGND VGND VPWR VPWR sky130_fd_sc_hd__diode_2
X_1621_ B_reg\[9\] VGND VGND VPWR VPWR _0901_ sky130_fd_sc_hd__inv_2
XANTENNA__3217__RESET_B net36 VGND VGND VPWR VPWR sky130_fd_sc_hd__diode_2
XTAP_TAPCELL_ROW_93_1825 VGND VPWR sky130_fd_sc_hd__tapvpwrvgnd_1
XTAP_TAPCELL_ROW_93_1814 VGND VPWR sky130_fd_sc_hd__tapvpwrvgnd_1
XANTENNA__1892__S Encode_EN VGND VGND VPWR VPWR sky130_fd_sc_hd__diode_2
XFILLER_125_273 VGND VGND VPWR VPWR sky130_fd_sc_hd__decap_6
XFILLER_140_221 VPWR VGND VPWR VGND sky130_ef_sc_hd__decap_12
XFILLER_87_809 VPWR VGND VPWR VGND sky130_ef_sc_hd__decap_12
XFILLER_141_777 VGND VGND VPWR VPWR sky130_fd_sc_hd__decap_6
XFILLER_140_265 VPWR VGND VPWR VGND sky130_ef_sc_hd__decap_12
X_3222_ clknet_3_4__leaf_clk _0010_ net36 VGND VGND VPWR VPWR CU_state_dbg\[2\] sky130_fd_sc_hd__dfrtp_2
XFILLER_79_393 VGND VGND VPWR VPWR sky130_fd_sc_hd__fill_1
XPHY_EDGE_ROW_68_Right_68 VGND VGND VPWR VPWR sky130_fd_sc_hd__decap_3
X_3153_ _0839_ _0840_ VGND VGND VPWR VPWR _0841_ sky130_fd_sc_hd__nor2_1
XFILLER_95_853 VPWR VGND VPWR VGND sky130_ef_sc_hd__decap_12
X_2104_ B_reg\[11\] _1357_ _1362_ VGND VGND VPWR VPWR _1363_ sky130_fd_sc_hd__and3_1
XFILLER_28_909 VGND VGND VPWR VPWR sky130_fd_sc_hd__fill_1
XTAP_TAPCELL_ROW_124_2313 VGND VPWR sky130_fd_sc_hd__tapvpwrvgnd_1
XFILLER_95_897 VPWR VGND VPWR VGND sky130_ef_sc_hd__decap_12
XFILLER_82_525 VGND VGND VPWR VPWR sky130_fd_sc_hd__decap_6
X_3084_ _0662_ _0765_ _0770_ VGND VGND VPWR VPWR _0772_ sky130_fd_sc_hd__and3_1
XFILLER_48_791 VGND VGND VPWR VPWR sky130_fd_sc_hd__fill_2
XTAP_TAPCELL_ROW_38_937 VGND VPWR sky130_fd_sc_hd__tapvpwrvgnd_1
XFILLER_39_279 VGND VGND VPWR VPWR sky130_fd_sc_hd__fill_1
X_2035_ _1295_ _1296_ VGND VGND VPWR VPWR _1297_ sky130_fd_sc_hd__and2_1
XPHY_EDGE_ROW_59_Left_213 VGND VGND VPWR VPWR sky130_fd_sc_hd__decap_3
XANTENNA__3229__CLK clknet_3_1__leaf_clk VGND VGND VPWR VPWR sky130_fd_sc_hd__diode_2
XFILLER_63_783 VGND VGND VPWR VPWR sky130_fd_sc_hd__fill_1
XFILLER_90_591 VPWR VGND VPWR VGND sky130_ef_sc_hd__decap_12
XFILLER_35_485 VPWR VGND VPWR VGND sky130_ef_sc_hd__decap_12
XFILLER_149_833 VGND VGND VPWR VPWR sky130_fd_sc_hd__decap_6
XTAP_TAPCELL_ROW_102_1965 VGND VPWR sky130_fd_sc_hd__tapvpwrvgnd_1
XPHY_EDGE_ROW_77_Right_77 VGND VGND VPWR VPWR sky130_fd_sc_hd__decap_3
XFILLER_11_809 VPWR VGND VPWR VGND sky130_ef_sc_hd__decap_12
XFILLER_148_321 VPWR VGND VPWR VGND sky130_ef_sc_hd__decap_12
X_2937_ _0603_ _0619_ VGND VGND VPWR VPWR _0625_ sky130_fd_sc_hd__xnor2_1
XFILLER_50_477 VPWR VGND VPWR VGND sky130_ef_sc_hd__decap_12
XFILLER_149_877 VPWR VGND VPWR VGND sky130_ef_sc_hd__decap_12
XFILLER_148_365 VPWR VGND VPWR VGND sky130_ef_sc_hd__decap_12
X_2868_ u_crt.r1\[0\] u_crt.r1\[2\] VGND VGND VPWR VPWR _0556_ sky130_fd_sc_hd__and2b_1
XTAP_TAPCELL_ROW_135_2497 VGND VPWR sky130_fd_sc_hd__tapvpwrvgnd_1
XTAP_TAPCELL_ROW_135_2486 VGND VPWR sky130_fd_sc_hd__tapvpwrvgnd_1
XFILLER_117_741 VPWR VGND VPWR VGND sky130_ef_sc_hd__decap_12
X_2799_ _0522_ _0526_ _0527_ _0538_ VGND VGND VPWR VPWR _0539_ sky130_fd_sc_hd__a31o_1
XPHY_EDGE_ROW_68_Left_222 VGND VGND VPWR VPWR sky130_fd_sc_hd__decap_3
X_1819_ A_reg\[2\] _1091_ VGND VGND VPWR VPWR _1092_ sky130_fd_sc_hd__or2_1
XFILLER_117_785 VPWR VGND VPWR VGND sky130_ef_sc_hd__decap_12
XFILLER_116_251 VGND VGND VPWR VPWR sky130_fd_sc_hd__fill_1
XFILLER_89_113 VGND VGND VPWR VPWR sky130_fd_sc_hd__decap_4
XFILLER_2_518 VGND VGND VPWR VPWR sky130_fd_sc_hd__decap_3
XFILLER_132_755 VGND VGND VPWR VPWR sky130_fd_sc_hd__fill_1
XFILLER_117_57 VPWR VGND VPWR VGND sky130_ef_sc_hd__decap_12
XFILLER_89_135 VGND VGND VPWR VPWR sky130_fd_sc_hd__decap_3
XANTENNA__2199__A A_reg\[8\] VGND VGND VPWR VPWR sky130_fd_sc_hd__diode_2
XFILLER_104_457 VPWR VGND VPWR VGND sky130_ef_sc_hd__decap_12
XPHY_EDGE_ROW_86_Right_86 VGND VGND VPWR VPWR sky130_fd_sc_hd__decap_3
XFILLER_58_533 VPWR VGND VPWR VGND sky130_ef_sc_hd__decap_12
XFILLER_58_566 VPWR VGND VPWR VGND sky130_ef_sc_hd__decap_12
XFILLER_18_408 VPWR VGND VPWR VGND sky130_ef_sc_hd__decap_12
XFILLER_19_909 VGND VGND VPWR VPWR sky130_fd_sc_hd__fill_1
XANTENNA__2646__B a_r3\[0\] VGND VGND VPWR VPWR sky130_fd_sc_hd__diode_2
XFILLER_85_385 VGND VGND VPWR VPWR sky130_fd_sc_hd__decap_6
XPHY_EDGE_ROW_77_Left_231 VGND VGND VPWR VPWR sky130_fd_sc_hd__decap_3
XFILLER_45_205 VPWR VGND VPWR VGND sky130_ef_sc_hd__decap_12
XFILLER_61_709 VGND VGND VPWR VPWR sky130_fd_sc_hd__decap_6
XFILLER_38_290 VPWR VGND VPWR VGND sky130_ef_sc_hd__decap_12
XFILLER_45_238 VPWR VGND VPWR VGND sky130_ef_sc_hd__decap_12
XFILLER_26_65 VPWR VGND VPWR VGND sky130_ef_sc_hd__decap_12
XPHY_EDGE_ROW_95_Right_95 VGND VGND VPWR VPWR sky130_fd_sc_hd__decap_3
XFILLER_53_293 VPWR VGND VPWR VGND sky130_ef_sc_hd__decap_12
XFILLER_53_260 VPWR VGND VPWR VGND sky130_ef_sc_hd__decap_12
XFILLER_13_113 VPWR VGND VPWR VGND sky130_ef_sc_hd__decap_12
XFILLER_14_625 VPWR VGND VPWR VGND sky130_ef_sc_hd__decap_12
XFILLER_41_433 VPWR VGND VPWR VGND sky130_ef_sc_hd__decap_12
XANTENNA__1850__B1 A_reg\[11\] VGND VGND VPWR VPWR sky130_fd_sc_hd__diode_2
XFILLER_14_669 VPWR VGND VPWR VGND sky130_ef_sc_hd__decap_12
XFILLER_42_53 VPWR VGND VPWR VGND sky130_ef_sc_hd__decap_12
XFILLER_127_505 VPWR VGND VPWR VGND sky130_ef_sc_hd__decap_12
XPHY_EDGE_ROW_86_Left_240 VGND VGND VPWR VPWR sky130_fd_sc_hd__decap_3
XFILLER_6_813 VPWR VGND VPWR VGND sky130_ef_sc_hd__decap_12
XFILLER_5_312 VGND VGND VPWR VPWR sky130_fd_sc_hd__decap_4
XFILLER_42_97 VPWR VGND VPWR VGND sky130_ef_sc_hd__decap_12
XANTENNA__3310__RESET_B net36 VGND VGND VPWR VPWR sky130_fd_sc_hd__diode_2
XFILLER_107_273 VGND VGND VPWR VPWR sky130_fd_sc_hd__decap_6
XTAP_TAPCELL_ROW_75_1533 VGND VPWR sky130_fd_sc_hd__tapvpwrvgnd_1
XFILLER_5_389 VGND VGND VPWR VPWR sky130_fd_sc_hd__decap_3
XFILLER_122_221 VPWR VGND VPWR VGND sky130_ef_sc_hd__decap_12
XFILLER_69_809 VPWR VGND VPWR VGND sky130_ef_sc_hd__decap_12
XFILLER_123_777 VGND VGND VPWR VPWR sky130_fd_sc_hd__decap_6
XFILLER_122_265 VPWR VGND VPWR VGND sky130_ef_sc_hd__decap_12
XANTENNA_input33_X net33 VGND VGND VPWR VPWR sky130_fd_sc_hd__diode_2
XFILLER_3_69 VPWR VGND VPWR VGND sky130_ef_sc_hd__decap_12
XFILLER_1_573 VPWR VGND VPWR VGND sky130_ef_sc_hd__decap_12
XFILLER_95_149 VPWR VGND VPWR VGND sky130_ef_sc_hd__decap_12
XFILLER_77_853 VPWR VGND VPWR VGND sky130_ef_sc_hd__decap_12
XFILLER_76_352 VPWR VGND VPWR VGND sky130_ef_sc_hd__decap_12
XTAP_TAPCELL_ROW_106_2021 VGND VPWR sky130_fd_sc_hd__tapvpwrvgnd_1
XFILLER_77_897 VPWR VGND VPWR VGND sky130_ef_sc_hd__decap_12
XTAP_TAPCELL_ROW_106_2032 VGND VPWR sky130_fd_sc_hd__tapvpwrvgnd_1
XFILLER_92_867 VGND VGND VPWR VPWR sky130_fd_sc_hd__fill_1
XFILLER_51_208 VPWR VGND VPWR VGND sky130_ef_sc_hd__decap_12
XFILLER_17_485 VPWR VGND VPWR VGND sky130_ef_sc_hd__decap_12
XFILLER_32_433 VPWR VGND VPWR VGND sky130_ef_sc_hd__decap_12
XFILLER_32_477 VPWR VGND VPWR VGND sky130_ef_sc_hd__decap_12
X_2722_ b_r3\[0\] a_r3\[3\] _0439_ _0438_ VGND VGND VPWR VPWR _0462_ sky130_fd_sc_hd__a31o_1
XFILLER_146_825 VPWR VGND VPWR VGND sky130_ef_sc_hd__decap_12
XFILLER_73_3 VPWR VGND VPWR VGND sky130_ef_sc_hd__decap_12
XFILLER_9_673 VPWR VGND VPWR VGND sky130_ef_sc_hd__decap_12
XFILLER_146_869 VPWR VGND VPWR VGND sky130_ef_sc_hd__decap_12
XFILLER_145_335 VGND VGND VPWR VPWR sky130_fd_sc_hd__fill_1
X_2653_ a_r3\[2\] _0392_ VGND VGND VPWR VPWR _0393_ sky130_fd_sc_hd__and2_1
X_2584_ a_r2\[2\] _0327_ VGND VGND VPWR VPWR _0329_ sky130_fd_sc_hd__nand2_1
X_1604_ CU_state_dbg\[0\] VGND VGND VPWR VPWR _0884_ sky130_fd_sc_hd__inv_2
XFILLER_141_541 VPWR VGND VPWR VGND sky130_ef_sc_hd__decap_12
XFILLER_114_755 VGND VGND VPWR VPWR sky130_fd_sc_hd__fill_1
XFILLER_99_477 VGND VGND VPWR VPWR sky130_fd_sc_hd__fill_1
XFILLER_87_617 VPWR VGND VPWR VGND sky130_ef_sc_hd__decap_12
XFILLER_141_585 VPWR VGND VPWR VGND sky130_ef_sc_hd__decap_12
XFILLER_101_416 VPWR VGND VPWR VGND sky130_ef_sc_hd__decap_12
X_3205_ _0828_ _0855_ _0856_ VGND VGND VPWR VPWR _0883_ sky130_fd_sc_hd__o21ai_1
XANTENNA__1651__A A_reg\[15\] VGND VGND VPWR VPWR sky130_fd_sc_hd__diode_2
XFILLER_103_15 VPWR VGND VPWR VGND sky130_ef_sc_hd__decap_12
X_3136_ _0823_ VGND VGND VPWR VPWR _0824_ sky130_fd_sc_hd__inv_2
XFILLER_27_205 VGND VGND VPWR VPWR sky130_fd_sc_hd__decap_8
XFILLER_55_536 VPWR VGND VPWR VGND sky130_ef_sc_hd__decap_12
XTAP_TAPCELL_ROW_2_359 VGND VPWR sky130_fd_sc_hd__tapvpwrvgnd_1
X_3067_ _0747_ _0748_ VGND VGND VPWR VPWR _0755_ sky130_fd_sc_hd__nand2_1
XFILLER_43_709 VPWR VGND VPWR VGND sky130_ef_sc_hd__decap_12
XFILLER_83_889 VGND VGND VPWR VPWR sky130_fd_sc_hd__decap_6
X_2018_ B_reg\[9\] _1279_ VGND VGND VPWR VPWR _1280_ sky130_fd_sc_hd__nor2_1
XFILLER_55_569 VGND VGND VPWR VPWR sky130_fd_sc_hd__fill_1
XFILLER_51_753 VPWR VGND VPWR VGND sky130_ef_sc_hd__decap_12
XTAP_TAPCELL_ROW_42_1009 VGND VPWR sky130_fd_sc_hd__tapvpwrvgnd_1
XFILLER_149_641 VPWR VGND VPWR VGND sky130_ef_sc_hd__decap_12
XTAP_TAPCELL_ROW_137_2526 VGND VPWR sky130_fd_sc_hd__tapvpwrvgnd_1
XFILLER_11_617 VPWR VGND VPWR VGND sky130_ef_sc_hd__decap_12
XFILLER_109_505 VGND VGND VPWR VPWR sky130_fd_sc_hd__fill_2
XFILLER_149_685 VPWR VGND VPWR VGND sky130_ef_sc_hd__decap_12
XFILLER_6_109 VPWR VGND VPWR VGND sky130_ef_sc_hd__decap_12
XTAP_TAPCELL_ROW_21_667 VGND VPWR sky130_fd_sc_hd__tapvpwrvgnd_1
XTAP_TAPCELL_ROW_150_2737 VGND VPWR sky130_fd_sc_hd__tapvpwrvgnd_1
XTAP_TAPCELL_ROW_150_2726 VGND VPWR sky130_fd_sc_hd__tapvpwrvgnd_1
XFILLER_148_195 VGND VGND VPWR VPWR sky130_fd_sc_hd__fill_1
XFILLER_136_357 VGND VGND VPWR VPWR sky130_fd_sc_hd__decap_6
XFILLER_151_305 VPWR VGND VPWR VGND sky130_ef_sc_hd__decap_12
XFILLER_88_27 VGND VGND VPWR VPWR sky130_fd_sc_hd__fill_1
XFILLER_151_349 VPWR VGND VPWR VGND sky130_ef_sc_hd__decap_12
XFILLER_104_221 VPWR VGND VPWR VGND sky130_ef_sc_hd__decap_12
XTAP_TAPCELL_ROW_57_1241 VGND VPWR sky130_fd_sc_hd__tapvpwrvgnd_1
XANTENNA__1899__B1 _0911_ VGND VGND VPWR VPWR sky130_fd_sc_hd__diode_2
XFILLER_105_777 VGND VGND VPWR VPWR sky130_fd_sc_hd__decap_6
XFILLER_104_265 VPWR VGND VPWR VGND sky130_ef_sc_hd__decap_12
XFILLER_78_628 VGND VGND VPWR VPWR sky130_fd_sc_hd__fill_1
XFILLER_120_725 VPWR VGND VPWR VGND sky130_ef_sc_hd__decap_12
XFILLER_144_77 VGND VGND VPWR VPWR sky130_fd_sc_hd__decap_6
XFILLER_120_769 VPWR VGND VPWR VGND sky130_ef_sc_hd__decap_12
XTAP_TAPCELL_ROW_70_1452 VGND VPWR sky130_fd_sc_hd__tapvpwrvgnd_1
XFILLER_59_853 VPWR VGND VPWR VGND sky130_ef_sc_hd__decap_12
XTAP_TAPCELL_ROW_148_2699 VGND VPWR sky130_fd_sc_hd__tapvpwrvgnd_1
XFILLER_86_694 VGND VGND VPWR VPWR sky130_fd_sc_hd__decap_3
XFILLER_59_897 VPWR VGND VPWR VGND sky130_ef_sc_hd__decap_12
XFILLER_58_363 VGND VGND VPWR VPWR sky130_fd_sc_hd__fill_1
XFILLER_46_525 VGND VGND VPWR VPWR sky130_fd_sc_hd__decap_6
XFILLER_74_867 VGND VGND VPWR VPWR sky130_fd_sc_hd__fill_1
XFILLER_73_366 VGND VGND VPWR VPWR sky130_fd_sc_hd__decap_4
XFILLER_61_517 VPWR VGND VPWR VGND sky130_ef_sc_hd__decap_12
XTAP_TAPCELL_ROW_29_789 VGND VPWR sky130_fd_sc_hd__tapvpwrvgnd_1
XFILLER_14_400 VPWR VGND VPWR VGND sky130_ef_sc_hd__decap_12
XFILLER_27_783 VGND VGND VPWR VPWR sky130_fd_sc_hd__fill_1
XFILLER_33_219 VGND VGND VPWR VPWR sky130_fd_sc_hd__decap_4
XFILLER_14_433 VGND VGND VPWR VPWR sky130_fd_sc_hd__decap_4
XFILLER_30_904 VGND VGND VPWR VPWR sky130_fd_sc_hd__decap_6
XFILLER_14_477 VPWR VGND VPWR VGND sky130_ef_sc_hd__decap_12
XFILLER_42_786 VGND VGND VPWR VPWR sky130_fd_sc_hd__decap_6
XFILLER_128_825 VPWR VGND VPWR VGND sky130_ef_sc_hd__decap_12
XFILLER_6_621 VGND VGND VPWR VPWR sky130_fd_sc_hd__fill_1
XTAP_TAPCELL_ROW_40_965 VGND VPWR sky130_fd_sc_hd__tapvpwrvgnd_1
XTAP_TAPCELL_ROW_40_976 VGND VPWR sky130_fd_sc_hd__tapvpwrvgnd_1
XFILLER_128_869 VPWR VGND VPWR VGND sky130_ef_sc_hd__decap_12
XFILLER_127_335 VGND VGND VPWR VPWR sky130_fd_sc_hd__fill_1
XFILLER_6_654 VPWR VGND VPWR VGND sky130_ef_sc_hd__decap_12
XFILLER_143_839 VGND VGND VPWR VPWR sky130_fd_sc_hd__fill_1
XANTENNA__2607__A1_N _0185_ VGND VGND VPWR VPWR sky130_fd_sc_hd__diode_2
XFILLER_6_698 VGND VGND VPWR VPWR sky130_fd_sc_hd__fill_2
XFILLER_123_541 VPWR VGND VPWR VGND sky130_ef_sc_hd__decap_12
XFILLER_69_617 VPWR VGND VPWR VGND sky130_ef_sc_hd__decap_12
XTAP_TAPCELL_ROW_9_470 VGND VPWR sky130_fd_sc_hd__tapvpwrvgnd_1
XFILLER_123_585 VPWR VGND VPWR VGND sky130_ef_sc_hd__decap_12
XTAP_TAPCELL_ROW_9_481 VGND VPWR sky130_fd_sc_hd__tapvpwrvgnd_1
XFILLER_2_893 VPWR VGND VPWR VGND sky130_ef_sc_hd__decap_12
XFILLER_96_469 VGND VGND VPWR VPWR sky130_fd_sc_hd__decap_6
XFILLER_68_138 VGND VGND VPWR VPWR sky130_fd_sc_hd__fill_2
XTAP_TAPCELL_ROW_88_1735 VGND VPWR sky130_fd_sc_hd__tapvpwrvgnd_1
XFILLER_37_503 VGND VGND VPWR VPWR sky130_fd_sc_hd__fill_1
XFILLER_92_631 VPWR VGND VPWR VGND sky130_ef_sc_hd__decap_12
XTAP_TAPCELL_ROW_88_1746 VGND VPWR sky130_fd_sc_hd__tapvpwrvgnd_1
XANTENNA__2286__B _0911_ VGND VGND VPWR VPWR sky130_fd_sc_hd__diode_2
XFILLER_64_333 VGND VGND VPWR VPWR sky130_fd_sc_hd__fill_2
XFILLER_94_92 VPWR VGND VPWR VGND sky130_ef_sc_hd__decap_12
XFILLER_65_889 VGND VGND VPWR VPWR sky130_fd_sc_hd__decap_6
XFILLER_64_377 VPWR VGND VPWR VGND sky130_ef_sc_hd__decap_12
XFILLER_52_506 VPWR VGND VPWR VGND sky130_ef_sc_hd__decap_12
XFILLER_25_709 VPWR VGND VPWR VGND sky130_ef_sc_hd__decap_12
XFILLER_91_174 VGND VGND VPWR VPWR sky130_fd_sc_hd__decap_8
XFILLER_80_837 VPWR VGND VPWR VGND sky130_ef_sc_hd__decap_12
XFILLER_17_293 VPWR VGND VPWR VGND sky130_ef_sc_hd__decap_12
XFILLER_33_753 VPWR VGND VPWR VGND sky130_ef_sc_hd__decap_12
XANTENNA__3232__RESET_B net36 VGND VGND VPWR VPWR sky130_fd_sc_hd__diode_2
XFILLER_33_797 VGND VGND VPWR VPWR sky130_fd_sc_hd__decap_8
XTAP_TAPCELL_ROW_119_2234 VGND VPWR sky130_fd_sc_hd__tapvpwrvgnd_1
XFILLER_118_357 VGND VGND VPWR VPWR sky130_fd_sc_hd__decap_6
X_2705_ _0443_ _0444_ VGND VGND VPWR VPWR _0445_ sky130_fd_sc_hd__and2_1
XFILLER_146_699 VGND VGND VPWR VPWR sky130_fd_sc_hd__fill_1
XTAP_TAPCELL_ROW_132_2445 VGND VPWR sky130_fd_sc_hd__tapvpwrvgnd_1
XFILLER_133_305 VPWR VGND VPWR VGND sky130_ef_sc_hd__decap_12
X_2636_ _0373_ _0376_ VGND VGND VPWR VPWR _0380_ sky130_fd_sc_hd__or2_1
XANTENNA__1646__A A_reg\[15\] VGND VGND VPWR VPWR sky130_fd_sc_hd__diode_2
XFILLER_133_349 VPWR VGND VPWR VGND sky130_ef_sc_hd__decap_12
XPHY_EDGE_ROW_151_Right_151 VGND VGND VPWR VPWR sky130_fd_sc_hd__decap_3
XFILLER_142_861 VGND VGND VPWR VPWR sky130_fd_sc_hd__decap_6
XFILLER_99_252 VGND VGND VPWR VPWR sky130_fd_sc_hd__fill_2
X_2567_ a_r2\[0\] b_r2\[2\] _0310_ _0308_ VGND VGND VPWR VPWR _0312_ sky130_fd_sc_hd__a31o_1
XFILLER_102_725 VPWR VGND VPWR VGND sky130_ef_sc_hd__decap_12
XFILLER_59_105 VGND VGND VPWR VPWR sky130_fd_sc_hd__decap_6
X_2498_ _0233_ _0245_ b_r1\[2\] VGND VGND VPWR VPWR _0246_ sky130_fd_sc_hd__o21ba_1
XFILLER_141_393 VPWR VGND VPWR VGND sky130_ef_sc_hd__decap_12
XFILLER_102_769 VPWR VGND VPWR VGND sky130_ef_sc_hd__decap_12
XFILLER_59_138 VPWR VGND VPWR VGND sky130_ef_sc_hd__decap_12
XTAP_TAPCELL_ROW_52_1160 VGND VPWR sky130_fd_sc_hd__tapvpwrvgnd_1
XFILLER_101_279 VGND VGND VPWR VPWR sky130_fd_sc_hd__fill_1
XFILLER_56_823 VPWR VGND VPWR VGND sky130_ef_sc_hd__decap_12
XFILLER_56_801 VGND VGND VPWR VPWR sky130_fd_sc_hd__fill_1
XTAP_TAPCELL_ROW_52_1171 VGND VPWR sky130_fd_sc_hd__tapvpwrvgnd_1
XFILLER_74_29 VPWR VGND VPWR VGND sky130_ef_sc_hd__decap_12
XFILLER_67_193 VGND VGND VPWR VPWR sky130_fd_sc_hd__decap_4
XFILLER_56_867 VGND VGND VPWR VPWR sky130_fd_sc_hd__fill_1
XFILLER_28_525 VGND VGND VPWR VPWR sky130_fd_sc_hd__decap_6
XFILLER_83_653 VPWR VGND VPWR VGND sky130_ef_sc_hd__decap_12
XFILLER_82_141 VPWR VGND VPWR VGND sky130_ef_sc_hd__decap_12
XFILLER_28_569 VPWR VGND VPWR VGND sky130_ef_sc_hd__decap_12
X_3119_ _0778_ _0791_ _0798_ VGND VGND VPWR VPWR _0807_ sky130_fd_sc_hd__and3_1
XFILLER_83_697 VPWR VGND VPWR VGND sky130_ef_sc_hd__decap_12
XFILLER_43_528 VPWR VGND VPWR VGND sky130_ef_sc_hd__decap_12
XTAP_TAPCELL_ROW_26_748 VGND VPWR sky130_fd_sc_hd__tapvpwrvgnd_1
XFILLER_51_561 VPWR VGND VPWR VGND sky130_ef_sc_hd__decap_12
XFILLER_23_55 VGND VGND VPWR VPWR sky130_fd_sc_hd__fill_1
XFILLER_139_55 VGND VGND VPWR VPWR sky130_fd_sc_hd__fill_1
XFILLER_11_469 VPWR VGND VPWR VGND sky130_ef_sc_hd__decap_12
XFILLER_136_121 VPWR VGND VPWR VGND sky130_ef_sc_hd__decap_12
XFILLER_109_335 VGND VGND VPWR VPWR sky130_fd_sc_hd__fill_1
XFILLER_99_15 VPWR VGND VPWR VGND sky130_ef_sc_hd__decap_12
XFILLER_152_625 VPWR VGND VPWR VGND sky130_ef_sc_hd__decap_12
XFILLER_136_165 VPWR VGND VPWR VGND sky130_ef_sc_hd__decap_12
XFILLER_125_839 VGND VGND VPWR VPWR sky130_fd_sc_hd__fill_1
XFILLER_151_113 VPWR VGND VPWR VGND sky130_ef_sc_hd__decap_12
XFILLER_152_669 VPWR VGND VPWR VGND sky130_ef_sc_hd__decap_12
XFILLER_105_541 VGND VGND VPWR VPWR sky130_fd_sc_hd__decap_3
XFILLER_3_3 VPWR VGND VPWR VGND sky130_ef_sc_hd__decap_12
XFILLER_105_596 VPWR VGND VPWR VGND sky130_ef_sc_hd__decap_12
XFILLER_2_189 VGND VGND VPWR VPWR sky130_fd_sc_hd__decap_6
XFILLER_120_533 VPWR VGND VPWR VGND sky130_ef_sc_hd__decap_12
XFILLER_78_469 VGND VGND VPWR VPWR sky130_fd_sc_hd__decap_6
XFILLER_93_417 VPWR VGND VPWR VGND sky130_ef_sc_hd__decap_12
XFILLER_48_85 VPWR VGND VPWR VGND sky130_ef_sc_hd__decap_12
XFILLER_48_63 VPWR VGND VPWR VGND sky130_ef_sc_hd__decap_12
XFILLER_19_503 VGND VGND VPWR VPWR sky130_fd_sc_hd__fill_1
XFILLER_74_631 VPWR VGND VPWR VGND sky130_ef_sc_hd__decap_12
XFILLER_47_845 VGND VGND VPWR VPWR sky130_fd_sc_hd__fill_1
XFILLER_0_15 VPWR VGND VPWR VGND sky130_ef_sc_hd__decap_12
XFILLER_46_333 VPWR VGND VPWR VGND sky130_ef_sc_hd__decap_12
XFILLER_74_675 VGND VGND VPWR VPWR sky130_fd_sc_hd__fill_1
XFILLER_73_141 VPWR VGND VPWR VGND sky130_ef_sc_hd__decap_12
XFILLER_47_867 VPWR VGND VPWR VGND sky130_ef_sc_hd__decap_12
XFILLER_64_73 VGND VGND VPWR VPWR sky130_fd_sc_hd__fill_2
XFILLER_62_837 VGND VGND VPWR VPWR sky130_fd_sc_hd__decap_8
XFILLER_61_303 VGND VGND VPWR VPWR sky130_fd_sc_hd__fill_1
XFILLER_34_528 VGND VGND VPWR VPWR sky130_fd_sc_hd__decap_4
XFILLER_46_377 VPWR VGND VPWR VGND sky130_ef_sc_hd__decap_12
XTAP_TAPCELL_ROW_83_1665 VGND VPWR sky130_fd_sc_hd__tapvpwrvgnd_1
XTAP_TAPCELL_ROW_83_1654 VGND VPWR sky130_fd_sc_hd__tapvpwrvgnd_1
XFILLER_15_753 VPWR VGND VPWR VGND sky130_ef_sc_hd__decap_12
XFILLER_70_881 VPWR VGND VPWR VGND sky130_ef_sc_hd__decap_12
XPHY_EDGE_ROW_14_Left_168 VGND VGND VPWR VPWR sky130_fd_sc_hd__decap_3
XFILLER_14_263 VPWR VGND VPWR VGND sky130_ef_sc_hd__decap_12
XFILLER_15_797 VPWR VGND VPWR VGND sky130_ef_sc_hd__decap_12
XFILLER_30_701 VPWR VGND VPWR VGND sky130_ef_sc_hd__decap_12
XFILLER_148_909 VGND VGND VPWR VPWR sky130_fd_sc_hd__fill_1
XFILLER_9_57 VPWR VGND VPWR VGND sky130_ef_sc_hd__decap_12
XFILLER_128_699 VGND VGND VPWR VPWR sky130_fd_sc_hd__fill_1
XFILLER_115_305 VPWR VGND VPWR VGND sky130_ef_sc_hd__decap_12
XFILLER_115_349 VPWR VGND VPWR VGND sky130_ef_sc_hd__decap_12
XTAP_TAPCELL_ROW_114_2153 VGND VPWR sky130_fd_sc_hd__tapvpwrvgnd_1
XFILLER_131_809 VPWR VGND VPWR VGND sky130_ef_sc_hd__decap_12
XFILLER_124_861 VGND VGND VPWR VPWR sky130_fd_sc_hd__decap_6
X_2421_ _0157_ _0155_ _0163_ VGND VGND VPWR VPWR _0175_ sky130_fd_sc_hd__mux2_1
XPHY_EDGE_ROW_23_Left_177 VGND VGND VPWR VPWR sky130_fd_sc_hd__decap_3
X_2352_ _0904_ _1601_ _1603_ VGND VGND VPWR VPWR _0106_ sky130_fd_sc_hd__or3_1
XFILLER_36_3 VPWR VGND VPWR VGND sky130_ef_sc_hd__decap_12
XFILLER_123_393 VPWR VGND VPWR VGND sky130_ef_sc_hd__decap_12
XFILLER_96_233 VPWR VGND VPWR VGND sky130_ef_sc_hd__decap_12
X_2283_ _1535_ _1537_ _1539_ VGND VGND VPWR VPWR _1540_ sky130_fd_sc_hd__a21o_1
XFILLER_96_277 VPWR VGND VPWR VGND sky130_ef_sc_hd__decap_12
XFILLER_49_193 VPWR VGND VPWR VGND sky130_ef_sc_hd__decap_12
XFILLER_38_845 VGND VGND VPWR VPWR sky130_fd_sc_hd__fill_1
XFILLER_80_601 VGND VGND VPWR VPWR sky130_fd_sc_hd__fill_2
XFILLER_37_355 VPWR VGND VPWR VGND sky130_ef_sc_hd__decap_12
XFILLER_25_517 VPWR VGND VPWR VGND sky130_ef_sc_hd__decap_12
XFILLER_80_645 VPWR VGND VPWR VGND sky130_ef_sc_hd__decap_12
XFILLER_52_336 VGND VGND VPWR VPWR sky130_fd_sc_hd__fill_1
XPHY_EDGE_ROW_32_Left_186 VGND VGND VPWR VPWR sky130_fd_sc_hd__decap_3
XFILLER_100_27 VGND VGND VPWR VPWR sky130_fd_sc_hd__fill_1
XTAP_TAPCELL_ROW_23_707 VGND VPWR sky130_fd_sc_hd__tapvpwrvgnd_1
XFILLER_139_909 VGND VGND VPWR VPWR sky130_fd_sc_hd__fill_1
XFILLER_20_233 VPWR VGND VPWR VGND sky130_ef_sc_hd__decap_12
XFILLER_138_419 VGND VGND VPWR VPWR sky130_fd_sc_hd__fill_1
XFILLER_118_121 VPWR VGND VPWR VGND sky130_ef_sc_hd__decap_12
X_1998_ B_reg\[12\] _1259_ VGND VGND VPWR VPWR _1260_ sky130_fd_sc_hd__xnor2_1
XFILLER_20_277 VPWR VGND VPWR VGND sky130_ef_sc_hd__decap_12
XFILLER_118_165 VPWR VGND VPWR VGND sky130_ef_sc_hd__decap_12
XFILLER_107_839 VGND VGND VPWR VPWR sky130_fd_sc_hd__fill_1
XFILLER_134_625 VPWR VGND VPWR VGND sky130_ef_sc_hd__decap_12
XFILLER_133_113 VPWR VGND VPWR VGND sky130_ef_sc_hd__decap_12
XFILLER_109_69 VPWR VGND VPWR VGND sky130_ef_sc_hd__decap_12
XPHY_EDGE_ROW_41_Left_195 VGND VGND VPWR VPWR sky130_fd_sc_hd__decap_3
XFILLER_134_669 VPWR VGND VPWR VGND sky130_ef_sc_hd__decap_12
XFILLER_88_701 VPWR VGND VPWR VGND sky130_ef_sc_hd__decap_12
X_2619_ _0359_ _0363_ VGND VGND VPWR VPWR _0364_ sky130_fd_sc_hd__xnor2_1
XTAP_TAPCELL_ROW_54_1200 VGND VPWR sky130_fd_sc_hd__tapvpwrvgnd_1
XFILLER_125_57 VPWR VGND VPWR VGND sky130_ef_sc_hd__decap_12
XFILLER_102_533 VPWR VGND VPWR VGND sky130_ef_sc_hd__decap_12
XFILLER_87_233 VGND VGND VPWR VPWR sky130_fd_sc_hd__fill_1
XFILLER_87_255 VPWR VGND VPWR VGND sky130_ef_sc_hd__decap_12
XFILLER_75_417 VPWR VGND VPWR VGND sky130_ef_sc_hd__decap_12
XTAP_TAPCELL_ROW_145_2658 VGND VPWR sky130_fd_sc_hd__tapvpwrvgnd_1
XTAP_TAPCELL_ROW_145_2647 VGND VPWR sky130_fd_sc_hd__tapvpwrvgnd_1
XFILLER_83_461 VPWR VGND VPWR VGND sky130_ef_sc_hd__decap_12
XFILLER_18_77 VGND VGND VPWR VPWR sky130_fd_sc_hd__decap_6
XFILLER_29_889 VGND VGND VPWR VPWR sky130_fd_sc_hd__decap_6
XFILLER_71_612 VGND VGND VPWR VPWR sky130_fd_sc_hd__decap_4
XFILLER_28_377 VGND VGND VPWR VPWR sky130_fd_sc_hd__decap_8
XFILLER_44_837 VPWR VGND VPWR VGND sky130_ef_sc_hd__decap_12
XTAP_TAPCELL_ROW_65_1373 VGND VPWR sky130_fd_sc_hd__tapvpwrvgnd_1
XFILLER_12_701 VPWR VGND VPWR VGND sky130_ef_sc_hd__decap_12
XFILLER_140_3 VPWR VGND VPWR VGND sky130_ef_sc_hd__decap_12
XFILLER_51_380 VPWR VGND VPWR VGND sky130_ef_sc_hd__decap_12
XFILLER_34_65 VPWR VGND VPWR VGND sky130_ef_sc_hd__decap_12
XFILLER_137_441 VGND VGND VPWR VPWR sky130_fd_sc_hd__decap_6
XFILLER_11_277 VGND VGND VPWR VPWR sky130_fd_sc_hd__fill_1
XFILLER_8_749 VGND VGND VPWR VPWR sky130_fd_sc_hd__decap_6
XFILLER_7_237 VPWR VGND VPWR VGND sky130_ef_sc_hd__decap_12
XFILLER_152_433 VPWR VGND VPWR VGND sky130_ef_sc_hd__decap_12
XFILLER_137_485 VPWR VGND VPWR VGND sky130_ef_sc_hd__decap_12
XFILLER_113_809 VPWR VGND VPWR VGND sky130_ef_sc_hd__decap_12
XFILLER_106_861 VGND VGND VPWR VPWR sky130_fd_sc_hd__decap_6
XANTENNA__3274__Q A_reg\[0\] VGND VGND VPWR VPWR sky130_fd_sc_hd__diode_2
XFILLER_152_477 VPWR VGND VPWR VGND sky130_ef_sc_hd__decap_12
XFILLER_79_734 VPWR VGND VPWR VGND sky130_ef_sc_hd__decap_12
XFILLER_121_853 VPWR VGND VPWR VGND sky130_ef_sc_hd__decap_12
XFILLER_105_393 VPWR VGND VPWR VGND sky130_ef_sc_hd__decap_12
XFILLER_39_609 VGND VGND VPWR VPWR sky130_fd_sc_hd__decap_6
XFILLER_121_897 VPWR VGND VPWR VGND sky130_ef_sc_hd__decap_12
XFILLER_120_363 VGND VGND VPWR VPWR sky130_fd_sc_hd__fill_1
XFILLER_94_737 VPWR VGND VPWR VGND sky130_ef_sc_hd__decap_12
XFILLER_66_406 VPWR VGND VPWR VGND sky130_ef_sc_hd__decap_12
XFILLER_93_225 VPWR VGND VPWR VGND sky130_ef_sc_hd__decap_12
XFILLER_78_299 VGND VGND VPWR VPWR sky130_fd_sc_hd__decap_8
XFILLER_47_653 VGND VGND VPWR VPWR sky130_fd_sc_hd__fill_1
XFILLER_19_366 VPWR VGND VPWR VGND sky130_ef_sc_hd__decap_12
XFILLER_46_141 VPWR VGND VPWR VGND sky130_ef_sc_hd__decap_12
XFILLER_62_601 VGND VGND VPWR VPWR sky130_fd_sc_hd__fill_1
XANTENNA_clkload6_A clknet_3_6__leaf_clk VGND VGND VPWR VPWR sky130_fd_sc_hd__diode_2
XFILLER_47_686 VPWR VGND VPWR VGND sky130_ef_sc_hd__decap_12
XFILLER_35_837 VGND VGND VPWR VPWR sky130_fd_sc_hd__decap_3
XANTENNA__3262__CLK clknet_3_7__leaf_clk VGND VGND VPWR VPWR sky130_fd_sc_hd__diode_2
XFILLER_61_111 VGND VGND VPWR VPWR sky130_fd_sc_hd__fill_1
X_2970_ _0656_ _0657_ VGND VGND VPWR VPWR _0658_ sky130_fd_sc_hd__and2_1
XFILLER_62_689 VGND VGND VPWR VPWR sky130_fd_sc_hd__decap_6
XFILLER_61_166 VGND VGND VPWR VPWR sky130_fd_sc_hd__fill_2
XFILLER_15_561 VPWR VGND VPWR VGND sky130_ef_sc_hd__decap_12
X_1921_ B_reg\[11\] _1179_ _1182_ VGND VGND VPWR VPWR _1186_ sky130_fd_sc_hd__o21a_2
XFILLER_30_531 VGND VGND VPWR VPWR sky130_fd_sc_hd__fill_1
XFILLER_42_380 VGND VGND VPWR VPWR sky130_fd_sc_hd__decap_6
XFILLER_147_205 VPWR VGND VPWR VGND sky130_ef_sc_hd__decap_12
X_1852_ _1119_ _1121_ A_reg\[10\] VGND VGND VPWR VPWR _1122_ sky130_fd_sc_hd__o21ai_1
XFILLER_30_564 VPWR VGND VPWR VGND sky130_ef_sc_hd__decap_12
XFILLER_147_249 VPWR VGND VPWR VGND sky130_ef_sc_hd__decap_12
X_1783_ A_reg\[6\] _1055_ VGND VGND VPWR VPWR _1056_ sky130_fd_sc_hd__nor2_1
XFILLER_116_625 VPWR VGND VPWR VGND sky130_ef_sc_hd__decap_12
XFILLER_115_113 VPWR VGND VPWR VGND sky130_ef_sc_hd__decap_12
XTAP_TAPCELL_ROW_96_1867 VGND VPWR sky130_fd_sc_hd__tapvpwrvgnd_1
XFILLER_116_669 VPWR VGND VPWR VGND sky130_ef_sc_hd__decap_12
XFILLER_131_617 VPWR VGND VPWR VGND sky130_ef_sc_hd__decap_12
X_2404_ _0151_ _0153_ _0908_ VGND VGND VPWR VPWR _0158_ sky130_fd_sc_hd__a21oi_1
XFILLER_85_704 VGND VGND VPWR VPWR sky130_fd_sc_hd__decap_4
X_2335_ _1570_ _1576_ _1578_ VGND VGND VPWR VPWR _1588_ sky130_fd_sc_hd__o21ai_1
XFILLER_111_385 VGND VGND VPWR VPWR sky130_fd_sc_hd__decap_6
XFILLER_97_597 VPWR VGND VPWR VGND sky130_ef_sc_hd__decap_12
X_2266_ _1509_ _1512_ _1518_ _1522_ VGND VGND VPWR VPWR _1523_ sky130_fd_sc_hd__a31o_1
XTAP_TAPCELL_ROW_127_2366 VGND VPWR sky130_fd_sc_hd__tapvpwrvgnd_1
X_2197_ _1453_ _1448_ _1450_ VGND VGND VPWR VPWR _1454_ sky130_fd_sc_hd__mux2_1
XFILLER_26_837 VPWR VGND VPWR VGND sky130_ef_sc_hd__decap_12
XTAP_TAPCELL_ROW_140_2566 VGND VPWR sky130_fd_sc_hd__tapvpwrvgnd_1
XFILLER_111_15 VPWR VGND VPWR VGND sky130_ef_sc_hd__decap_12
XFILLER_52_122 VGND VGND VPWR VPWR sky130_fd_sc_hd__decap_8
XTAP_TAPCELL_ROW_140_2577 VGND VPWR sky130_fd_sc_hd__tapvpwrvgnd_1
XFILLER_80_475 VGND VGND VPWR VPWR sky130_fd_sc_hd__fill_1
XFILLER_25_369 VGND VGND VPWR VPWR sky130_fd_sc_hd__decap_3
XFILLER_34_881 VGND VGND VPWR VPWR sky130_fd_sc_hd__decap_8
XFILLER_40_339 VPWR VGND VPWR VGND sky130_ef_sc_hd__decap_12
XTAP_TAPCELL_ROW_47_1081 VGND VPWR sky130_fd_sc_hd__tapvpwrvgnd_1
XFILLER_21_553 VGND VGND VPWR VPWR sky130_fd_sc_hd__decap_6
XFILLER_21_597 VPWR VGND VPWR VGND sky130_ef_sc_hd__decap_12
XFILLER_119_441 VGND VGND VPWR VPWR sky130_fd_sc_hd__decap_6
XTAP_TAPCELL_ROW_60_1292 VGND VPWR sky130_fd_sc_hd__tapvpwrvgnd_1
XFILLER_147_783 VGND VGND VPWR VPWR sky130_fd_sc_hd__fill_1
XFILLER_134_433 VPWR VGND VPWR VGND sky130_ef_sc_hd__decap_12
XFILLER_119_485 VPWR VGND VPWR VGND sky130_ef_sc_hd__decap_12
XFILLER_4_229 VGND VGND VPWR VPWR sky130_fd_sc_hd__fill_2
XFILLER_134_477 VPWR VGND VPWR VGND sky130_ef_sc_hd__decap_12
XFILLER_121_105 VGND VGND VPWR VPWR sky130_fd_sc_hd__decap_6
XANTENNA__1834__A A_reg\[0\] VGND VGND VPWR VPWR sky130_fd_sc_hd__diode_2
XFILLER_121_149 VPWR VGND VPWR VGND sky130_ef_sc_hd__decap_12
XFILLER_103_853 VPWR VGND VPWR VGND sky130_ef_sc_hd__decap_12
XFILLER_96_27 VGND VGND VPWR VPWR sky130_fd_sc_hd__fill_1
XFILLER_88_553 VGND VGND VPWR VPWR sky130_fd_sc_hd__decap_3
XFILLER_88_531 VGND VGND VPWR VPWR sky130_fd_sc_hd__fill_1
XFILLER_102_363 VGND VGND VPWR VPWR sky130_fd_sc_hd__fill_1
XFILLER_0_468 VGND VGND VPWR VPWR sky130_fd_sc_hd__fill_2
XFILLER_103_897 VPWR VGND VPWR VGND sky130_ef_sc_hd__decap_12
XFILLER_102_396 VPWR VGND VPWR VGND sky130_ef_sc_hd__decap_12
XFILLER_88_597 VGND VGND VPWR VPWR sky130_fd_sc_hd__fill_1
XFILLER_75_225 VPWR VGND VPWR VGND sky130_ef_sc_hd__decap_12
XFILLER_152_77 VGND VGND VPWR VPWR sky130_fd_sc_hd__decap_6
XANTENNA__3285__CLK clknet_3_5__leaf_clk VGND VGND VPWR VPWR sky130_fd_sc_hd__diode_2
XFILLER_28_141 VPWR VGND VPWR VGND sky130_ef_sc_hd__decap_12
XFILLER_29_653 VPWR VGND VPWR VGND sky130_ef_sc_hd__decap_12
XFILLER_91_729 VPWR VGND VPWR VGND sky130_ef_sc_hd__decap_12
XFILLER_84_781 VPWR VGND VPWR VGND sky130_ef_sc_hd__decap_12
XTAP_TAPCELL_ROW_67_1402 VGND VPWR sky130_fd_sc_hd__tapvpwrvgnd_1
XFILLER_29_697 VPWR VGND VPWR VGND sky130_ef_sc_hd__decap_12
XFILLER_44_601 VPWR VGND VPWR VGND sky130_ef_sc_hd__decap_12
XFILLER_16_347 VPWR VGND VPWR VGND sky130_ef_sc_hd__decap_12
XFILLER_43_111 VGND VGND VPWR VPWR sky130_fd_sc_hd__fill_1
XFILLER_44_645 VPWR VGND VPWR VGND sky130_ef_sc_hd__decap_12
XFILLER_71_475 VGND VGND VPWR VPWR sky130_fd_sc_hd__fill_1
XTAP_TAPCELL_ROW_80_1613 VGND VPWR sky130_fd_sc_hd__tapvpwrvgnd_1
XFILLER_129_205 VPWR VGND VPWR VGND sky130_ef_sc_hd__decap_12
XFILLER_101_81 VPWR VGND VPWR VGND sky130_ef_sc_hd__decap_12
XFILLER_8_513 VPWR VGND VPWR VGND sky130_ef_sc_hd__decap_12
XFILLER_12_531 VGND VGND VPWR VPWR sky130_fd_sc_hd__fill_1
XTAP_TAPCELL_ROW_14_548 VGND VPWR sky130_fd_sc_hd__tapvpwrvgnd_1
XTAP_TAPCELL_ROW_14_559 VGND VPWR sky130_fd_sc_hd__tapvpwrvgnd_1
XFILLER_129_249 VPWR VGND VPWR VGND sky130_ef_sc_hd__decap_12
XFILLER_145_709 VPWR VGND VPWR VGND sky130_ef_sc_hd__decap_12
XFILLER_8_557 VGND VGND VPWR VPWR sky130_fd_sc_hd__decap_6
XFILLER_153_753 VGND VGND VPWR VPWR sky130_fd_sc_hd__decap_3
XFILLER_137_293 VPWR VGND VPWR VGND sky130_ef_sc_hd__decap_12
XTAP_TAPCELL_ROW_111_2112 VGND VPWR sky130_fd_sc_hd__tapvpwrvgnd_1
XTAP_TAPCELL_ROW_111_2101 VGND VPWR sky130_fd_sc_hd__tapvpwrvgnd_1
XTAP_TAPCELL_ROW_78_1586 VGND VPWR sky130_fd_sc_hd__tapvpwrvgnd_1
XTAP_TAPCELL_ROW_78_1575 VGND VPWR sky130_fd_sc_hd__tapvpwrvgnd_1
XFILLER_153_797 VPWR VGND VPWR VGND sky130_ef_sc_hd__decap_12
XFILLER_113_617 VPWR VGND VPWR VGND sky130_ef_sc_hd__decap_12
XFILLER_140_469 VGND VGND VPWR VPWR sky130_fd_sc_hd__decap_6
XFILLER_94_501 VGND VGND VPWR VPWR sky130_fd_sc_hd__decap_6
XTAP_TAPCELL_ROW_91_1786 VGND VPWR sky130_fd_sc_hd__tapvpwrvgnd_1
XFILLER_94_545 VPWR VGND VPWR VGND sky130_ef_sc_hd__decap_12
X_2120_ B_reg\[7\] _1376_ VGND VGND VPWR VPWR _1379_ sky130_fd_sc_hd__or2_1
XFILLER_66_203 VPWR VGND VPWR VGND sky130_ef_sc_hd__decap_12
XTAP_TAPCELL_ROW_109_2074 VGND VPWR sky130_fd_sc_hd__tapvpwrvgnd_1
XFILLER_94_567 VPWR VGND VPWR VGND sky130_ef_sc_hd__decap_12
X_2051_ _1307_ _1312_ VGND VGND VPWR VPWR _1313_ sky130_fd_sc_hd__nand2_1
XFILLER_94_589 VPWR VGND VPWR VGND sky130_ef_sc_hd__decap_12
XFILLER_81_217 VGND VGND VPWR VPWR sky130_fd_sc_hd__decap_6
XFILLER_47_461 VPWR VGND VPWR VGND sky130_ef_sc_hd__decap_12
XFILLER_34_133 VGND VGND VPWR VPWR sky130_fd_sc_hd__decap_6
XTAP_TAPCELL_ROW_122_2285 VGND VPWR sky130_fd_sc_hd__tapvpwrvgnd_1
XPHY_EDGE_ROW_106_Left_260 VGND VGND VPWR VPWR sky130_fd_sc_hd__decap_3
X_2953_ _0604_ _0639_ VGND VGND VPWR VPWR _0641_ sky130_fd_sc_hd__xor2_1
XFILLER_50_626 VPWR VGND VPWR VGND sky130_ef_sc_hd__decap_12
XFILLER_16_881 VPWR VGND VPWR VGND sky130_ef_sc_hd__decap_12
XFILLER_34_177 VPWR VGND VPWR VGND sky130_ef_sc_hd__decap_12
XFILLER_148_525 VGND VGND VPWR VPWR sky130_fd_sc_hd__decap_6
X_1904_ B_reg\[14\] B_reg\[13\] B_reg\[15\] VGND VGND VPWR VPWR _1169_ sky130_fd_sc_hd__a21boi_1
XTAP_TAPCELL_ROW_33_857 VGND VPWR sky130_fd_sc_hd__tapvpwrvgnd_1
XTAP_TAPCELL_ROW_98_1907 VGND VPWR sky130_fd_sc_hd__tapvpwrvgnd_1
X_2884_ _0564_ _0571_ VGND VGND VPWR VPWR _0572_ sky130_fd_sc_hd__or2_1
XFILLER_148_569 VPWR VGND VPWR VGND sky130_ef_sc_hd__decap_12
XFILLER_30_394 VPWR VGND VPWR VGND sky130_ef_sc_hd__decap_12
X_1835_ A_reg\[0\] _1106_ _0911_ VGND VGND VPWR VPWR _1108_ sky130_fd_sc_hd__a21oi_1
XFILLER_129_783 VGND VGND VPWR VPWR sky130_fd_sc_hd__fill_1
X_1766_ A_reg\[9\] _1030_ _1033_ VGND VGND VPWR VPWR _1039_ sky130_fd_sc_hd__or3_1
XFILLER_116_433 VPWR VGND VPWR VGND sky130_ef_sc_hd__decap_12
XFILLER_7_590 VGND VGND VPWR VPWR sky130_fd_sc_hd__fill_2
XFILLER_116_477 VPWR VGND VPWR VGND sky130_ef_sc_hd__decap_12
XFILLER_103_105 VGND VGND VPWR VPWR sky130_fd_sc_hd__decap_6
X_1697_ _0963_ _0972_ VGND VGND VPWR VPWR _0973_ sky130_fd_sc_hd__nor2_1
XFILLER_131_447 VGND VGND VPWR VPWR sky130_fd_sc_hd__fill_1
XFILLER_103_149 VPWR VGND VPWR VGND sky130_ef_sc_hd__decap_12
XANTENNA__2469__B b_r1\[0\] VGND VGND VPWR VPWR sky130_fd_sc_hd__diode_2
XFILLER_97_361 VPWR VGND VPWR VGND sky130_ef_sc_hd__decap_12
X_2318_ _1566_ _1568_ _0900_ VGND VGND VPWR VPWR _1571_ sky130_fd_sc_hd__a21oi_1
XFILLER_57_225 VPWR VGND VPWR VGND sky130_ef_sc_hd__decap_12
XTAP_TAPCELL_ROW_142_2606 VGND VPWR sky130_fd_sc_hd__tapvpwrvgnd_1
XFILLER_111_193 VPWR VGND VPWR VGND sky130_ef_sc_hd__decap_12
XFILLER_100_867 VGND VGND VPWR VPWR sky130_fd_sc_hd__fill_1
X_3298_ clknet_3_2__leaf_clk _0081_ net36 VGND VGND VPWR VPWR B_reg\[8\] sky130_fd_sc_hd__dfrtp_4
XANTENNA__2695__B1_N OpSel_reg\[0\] VGND VGND VPWR VPWR sky130_fd_sc_hd__diode_2
XFILLER_73_729 VPWR VGND VPWR VGND sky130_ef_sc_hd__decap_12
XTAP_TAPCELL_ROW_49_1110 VGND VPWR sky130_fd_sc_hd__tapvpwrvgnd_1
XFILLER_26_601 VPWR VGND VPWR VGND sky130_ef_sc_hd__decap_12
X_2249_ _1491_ _1493_ _1505_ VGND VGND VPWR VPWR _1506_ sky130_fd_sc_hd__a21oi_2
XTAP_TAPCELL_ROW_49_1121 VGND VPWR sky130_fd_sc_hd__tapvpwrvgnd_1
XFILLER_25_111 VGND VGND VPWR VPWR sky130_fd_sc_hd__fill_1
XFILLER_26_645 VPWR VGND VPWR VGND sky130_ef_sc_hd__decap_12
XFILLER_80_250 VGND VGND VPWR VPWR sky130_fd_sc_hd__fill_2
XFILLER_41_615 VGND VGND VPWR VPWR sky130_fd_sc_hd__fill_1
XTAP_TAPCELL_ROW_62_1321 VGND VPWR sky130_fd_sc_hd__tapvpwrvgnd_1
XFILLER_139_503 VGND VGND VPWR VPWR sky130_fd_sc_hd__fill_1
XANTENNA__1829__A A_reg\[0\] VGND VGND VPWR VPWR sky130_fd_sc_hd__diode_2
XTAP_TAPCELL_ROW_11_507 VGND VPWR sky130_fd_sc_hd__tapvpwrvgnd_1
XFILLER_21_361 VPWR VGND VPWR VGND sky130_ef_sc_hd__decap_12
XFILLER_127_709 VPWR VGND VPWR VGND sky130_ef_sc_hd__decap_12
XFILLER_5_505 VPWR VGND VPWR VGND sky130_ef_sc_hd__decap_12
XTAP_TAPCELL_ROW_153_2779 VGND VPWR sky130_fd_sc_hd__tapvpwrvgnd_1
XFILLER_31_55 VGND VGND VPWR VPWR sky130_fd_sc_hd__fill_1
XFILLER_147_55 VGND VGND VPWR VPWR sky130_fd_sc_hd__fill_1
XFILLER_135_753 VPWR VGND VPWR VGND sky130_ef_sc_hd__decap_12
XFILLER_119_293 VPWR VGND VPWR VGND sky130_ef_sc_hd__decap_12
XFILLER_150_701 VPWR VGND VPWR VGND sky130_ef_sc_hd__decap_12
XFILLER_135_797 VPWR VGND VPWR VGND sky130_ef_sc_hd__decap_12
XFILLER_107_466 VPWR VGND VPWR VGND sky130_ef_sc_hd__decap_12
XFILLER_103_3 VPWR VGND VPWR VGND sky130_ef_sc_hd__decap_12
XFILLER_0_221 VGND VGND VPWR VPWR sky130_fd_sc_hd__decap_3
Xoutput44 net44 VGND VGND VPWR VPWR X_out[15] sky130_fd_sc_hd__buf_1
XFILLER_122_469 VGND VGND VPWR VPWR sky130_fd_sc_hd__decap_6
XFILLER_76_501 VPWR VGND VPWR VGND sky130_ef_sc_hd__decap_12
XTAP_TAPCELL_ROW_73_1494 VGND VPWR sky130_fd_sc_hd__tapvpwrvgnd_1
XFILLER_1_777 VGND VGND VPWR VPWR sky130_fd_sc_hd__decap_6
XFILLER_89_895 VGND VGND VPWR VPWR sky130_fd_sc_hd__fill_1
XFILLER_49_759 VPWR VGND VPWR VGND sky130_ef_sc_hd__decap_12
XFILLER_0_265 VPWR VGND VPWR VGND sky130_ef_sc_hd__decap_12
XFILLER_76_545 VPWR VGND VPWR VGND sky130_ef_sc_hd__decap_12
XANTENNA_input23_A B_in[15] VGND VGND VPWR VPWR sky130_fd_sc_hd__diode_2
XFILLER_76_589 VGND VGND VPWR VPWR sky130_fd_sc_hd__decap_8
XFILLER_63_206 VPWR VGND VPWR VGND sky130_ef_sc_hd__decap_12
XFILLER_57_770 VGND VGND VPWR VPWR sky130_fd_sc_hd__decap_8
XTAP_TAPCELL_ROW_19_629 VGND VPWR sky130_fd_sc_hd__tapvpwrvgnd_1
XFILLER_29_461 VPWR VGND VPWR VGND sky130_ef_sc_hd__decap_12
XFILLER_56_85 VPWR VGND VPWR VGND sky130_ef_sc_hd__decap_12
XANTENNA_clkbuf_3_1__f_clk_A clknet_0_clk VGND VGND VPWR VPWR sky130_fd_sc_hd__diode_2
XFILLER_16_133 VGND VGND VPWR VPWR sky130_fd_sc_hd__decap_6
XFILLER_44_475 VGND VGND VPWR VPWR sky130_fd_sc_hd__fill_1
XFILLER_16_177 VPWR VGND VPWR VGND sky130_ef_sc_hd__decap_12
XFILLER_31_125 VPWR VGND VPWR VGND sky130_ef_sc_hd__decap_12
XFILLER_32_637 VGND VGND VPWR VPWR sky130_fd_sc_hd__decap_6
XANTENNA__1739__A A_reg\[13\] VGND VGND VPWR VPWR sky130_fd_sc_hd__diode_2
XTAP_TAPCELL_ROW_30_805 VGND VPWR sky130_fd_sc_hd__tapvpwrvgnd_1
XFILLER_9_833 VGND VGND VPWR VPWR sky130_fd_sc_hd__decap_6
XFILLER_12_361 VGND VGND VPWR VPWR sky130_fd_sc_hd__decap_3
XFILLER_13_895 VGND VGND VPWR VPWR sky130_fd_sc_hd__fill_1
XTAP_TAPCELL_ROW_30_816 VGND VPWR sky130_fd_sc_hd__tapvpwrvgnd_1
XFILLER_31_169 VPWR VGND VPWR VGND sky130_ef_sc_hd__decap_12
XFILLER_145_517 VPWR VGND VPWR VGND sky130_ef_sc_hd__decap_12
XANTENNA__3300__CLK clknet_3_2__leaf_clk VGND VGND VPWR VPWR sky130_fd_sc_hd__diode_2
XFILLER_9_877 VPWR VGND VPWR VGND sky130_ef_sc_hd__decap_12
X_1620_ B_reg\[10\] VGND VGND VPWR VPWR _0900_ sky130_fd_sc_hd__inv_2
XFILLER_8_365 VPWR VGND VPWR VGND sky130_ef_sc_hd__decap_12
XTAP_TAPCELL_ROW_93_1826 VGND VPWR sky130_fd_sc_hd__tapvpwrvgnd_1
XTAP_TAPCELL_ROW_93_1815 VGND VPWR sky130_fd_sc_hd__tapvpwrvgnd_1
XFILLER_153_583 VGND VGND VPWR VPWR sky130_fd_sc_hd__decap_4
XFILLER_99_615 VGND VGND VPWR VPWR sky130_fd_sc_hd__fill_1
XFILLER_140_233 VPWR VGND VPWR VGND sky130_ef_sc_hd__decap_12
XFILLER_113_447 VGND VGND VPWR VPWR sky130_fd_sc_hd__fill_1
XANTENNA__3257__RESET_B net36 VGND VGND VPWR VPWR sky130_fd_sc_hd__diode_2
XFILLER_4_593 VGND VGND VPWR VPWR sky130_fd_sc_hd__decap_4
XFILLER_97_81 VPWR VGND VPWR VGND sky130_ef_sc_hd__decap_12
XFILLER_79_361 VGND VGND VPWR VPWR sky130_fd_sc_hd__decap_6
X_3221_ clknet_3_4__leaf_clk _0009_ net36 VGND VGND VPWR VPWR CU_state_dbg\[1\] sky130_fd_sc_hd__dfrtp_2
XFILLER_140_277 VPWR VGND VPWR VGND sky130_ef_sc_hd__decap_12
XFILLER_95_821 VPWR VGND VPWR VGND sky130_ef_sc_hd__decap_12
XFILLER_39_225 VGND VGND VPWR VPWR sky130_fd_sc_hd__decap_8
X_3152_ _0814_ _0838_ VGND VGND VPWR VPWR _0840_ sky130_fd_sc_hd__nor2_1
XFILLER_95_865 VPWR VGND VPWR VGND sky130_ef_sc_hd__decap_12
X_2103_ _1356_ _1361_ VGND VGND VPWR VPWR _1362_ sky130_fd_sc_hd__nand2_1
XFILLER_39_258 VGND VGND VPWR VPWR sky130_fd_sc_hd__fill_1
XTAP_TAPCELL_ROW_124_2314 VGND VPWR sky130_fd_sc_hd__tapvpwrvgnd_1
X_3083_ _0662_ _0765_ _0770_ VGND VGND VPWR VPWR _0771_ sky130_fd_sc_hd__a21oi_1
XFILLER_55_729 VPWR VGND VPWR VGND sky130_ef_sc_hd__decap_12
XTAP_TAPCELL_ROW_38_938 VGND VPWR sky130_fd_sc_hd__tapvpwrvgnd_1
X_2034_ _0902_ _1290_ _1285_ VGND VGND VPWR VPWR _1296_ sky130_fd_sc_hd__a21bo_1
XFILLER_23_615 VGND VGND VPWR VPWR sky130_fd_sc_hd__fill_1
XFILLER_50_423 VPWR VGND VPWR VGND sky130_ef_sc_hd__decap_12
XFILLER_35_497 VGND VGND VPWR VPWR sky130_fd_sc_hd__decap_6
XTAP_TAPCELL_ROW_102_1966 VGND VPWR sky130_fd_sc_hd__tapvpwrvgnd_1
XANTENNA__1649__A A_reg\[13\] VGND VGND VPWR VPWR sky130_fd_sc_hd__diode_2
XTAP_TAPCELL_ROW_44_1040 VGND VPWR sky130_fd_sc_hd__tapvpwrvgnd_1
XFILLER_148_333 VPWR VGND VPWR VGND sky130_ef_sc_hd__decap_12
X_2936_ _0622_ _0623_ VGND VGND VPWR VPWR _0624_ sky130_fd_sc_hd__nand2b_1
XFILLER_50_489 VPWR VGND VPWR VGND sky130_ef_sc_hd__decap_12
XFILLER_10_309 VPWR VGND VPWR VGND sky130_ef_sc_hd__decap_12
XFILLER_149_889 VGND VGND VPWR VPWR sky130_fd_sc_hd__decap_6
XFILLER_109_709 VPWR VGND VPWR VGND sky130_ef_sc_hd__decap_12
X_2867_ u_crt.r1\[2\] u_crt.r1\[0\] VGND VGND VPWR VPWR _0555_ sky130_fd_sc_hd__and2b_1
XFILLER_148_377 VPWR VGND VPWR VGND sky130_ef_sc_hd__decap_12
X_1818_ _1086_ _1088_ _1090_ VGND VGND VPWR VPWR _1091_ sky130_fd_sc_hd__o21ba_1
XTAP_TAPCELL_ROW_135_2498 VGND VPWR sky130_fd_sc_hd__tapvpwrvgnd_1
XTAP_TAPCELL_ROW_135_2487 VGND VPWR sky130_fd_sc_hd__tapvpwrvgnd_1
XFILLER_117_753 VPWR VGND VPWR VGND sky130_ef_sc_hd__decap_12
X_2798_ _0526_ _0531_ _0527_ VGND VGND VPWR VPWR _0538_ sky130_fd_sc_hd__a21oi_1
XFILLER_132_701 VPWR VGND VPWR VGND sky130_ef_sc_hd__decap_12
XFILLER_117_797 VPWR VGND VPWR VGND sky130_ef_sc_hd__decap_12
X_1749_ _0888_ _1019_ VGND VGND VPWR VPWR _1022_ sky130_fd_sc_hd__xnor2_1
XFILLER_117_69 VPWR VGND VPWR VGND sky130_ef_sc_hd__decap_12
XFILLER_89_125 VGND VGND VPWR VPWR sky130_fd_sc_hd__fill_1
XFILLER_104_469 VGND VGND VPWR VPWR sky130_fd_sc_hd__decap_6
XFILLER_89_169 VPWR VGND VPWR VGND sky130_ef_sc_hd__decap_12
XFILLER_98_681 VPWR VGND VPWR VGND sky130_ef_sc_hd__decap_12
XFILLER_58_501 VPWR VGND VPWR VGND sky130_ef_sc_hd__decap_12
XFILLER_133_57 VPWR VGND VPWR VGND sky130_ef_sc_hd__decap_12
XFILLER_58_545 VPWR VGND VPWR VGND sky130_ef_sc_hd__decap_12
XFILLER_58_589 VGND VGND VPWR VPWR sky130_fd_sc_hd__decap_6
XFILLER_58_578 VGND VGND VPWR VPWR sky130_fd_sc_hd__decap_8
XFILLER_39_781 VGND VGND VPWR VPWR sky130_fd_sc_hd__decap_3
XFILLER_45_217 VGND VGND VPWR VPWR sky130_fd_sc_hd__fill_1
XFILLER_73_559 VGND VGND VPWR VPWR sky130_fd_sc_hd__fill_1
XFILLER_60_209 VPWR VGND VPWR VGND sky130_ef_sc_hd__decap_12
XFILLER_53_272 VGND VGND VPWR VPWR sky130_fd_sc_hd__decap_8
XFILLER_14_637 VGND VGND VPWR VPWR sky130_fd_sc_hd__decap_6
XFILLER_26_77 VGND VGND VPWR VPWR sky130_fd_sc_hd__decap_6
XFILLER_26_475 VGND VGND VPWR VPWR sky130_fd_sc_hd__fill_1
XFILLER_13_125 VPWR VGND VPWR VGND sky130_ef_sc_hd__decap_12
XFILLER_41_445 VGND VGND VPWR VPWR sky130_fd_sc_hd__decap_3
XFILLER_13_169 VPWR VGND VPWR VGND sky130_ef_sc_hd__decap_12
XFILLER_22_681 VPWR VGND VPWR VGND sky130_ef_sc_hd__decap_12
XFILLER_42_65 VPWR VGND VPWR VGND sky130_ef_sc_hd__decap_12
XFILLER_127_517 VPWR VGND VPWR VGND sky130_ef_sc_hd__decap_12
XFILLER_6_825 VPWR VGND VPWR VGND sky130_ef_sc_hd__decap_12
XFILLER_6_869 VPWR VGND VPWR VGND sky130_ef_sc_hd__decap_12
XFILLER_5_346 VGND VGND VPWR VPWR sky130_fd_sc_hd__fill_1
XFILLER_5_335 VGND VGND VPWR VPWR sky130_fd_sc_hd__fill_1
XFILLER_135_561 VPWR VGND VPWR VGND sky130_ef_sc_hd__decap_12
XTAP_TAPCELL_ROW_75_1534 VGND VPWR sky130_fd_sc_hd__tapvpwrvgnd_1
XFILLER_150_531 VGND VGND VPWR VPWR sky130_fd_sc_hd__fill_1
XFILLER_122_233 VPWR VGND VPWR VGND sky130_ef_sc_hd__decap_12
XFILLER_68_309 VPWR VGND VPWR VGND sky130_ef_sc_hd__decap_12
XANTENNA__3282__Q A_reg\[8\] VGND VGND VPWR VPWR sky130_fd_sc_hd__diode_2
XFILLER_3_15 VPWR VGND VPWR VGND sky130_ef_sc_hd__decap_12
XFILLER_1_541 VPWR VGND VPWR VGND sky130_ef_sc_hd__decap_12
XFILLER_122_277 VPWR VGND VPWR VGND sky130_ef_sc_hd__decap_12
XFILLER_77_821 VPWR VGND VPWR VGND sky130_ef_sc_hd__decap_12
XFILLER_1_585 VPWR VGND VPWR VGND sky130_ef_sc_hd__decap_12
XFILLER_77_865 VPWR VGND VPWR VGND sky130_ef_sc_hd__decap_12
XTAP_TAPCELL_ROW_106_2022 VGND VPWR sky130_fd_sc_hd__tapvpwrvgnd_1
XFILLER_92_813 VPWR VGND VPWR VGND sky130_ef_sc_hd__decap_12
XFILLER_37_729 VPWR VGND VPWR VGND sky130_ef_sc_hd__decap_12
XTAP_TAPCELL_ROW_106_2033 VGND VPWR sky130_fd_sc_hd__tapvpwrvgnd_1
XFILLER_91_345 VGND VGND VPWR VPWR sky130_fd_sc_hd__fill_1
XTAP_TAPCELL_ROW_4_390 VGND VPWR sky130_fd_sc_hd__tapvpwrvgnd_1
XFILLER_17_497 VGND VGND VPWR VPWR sky130_fd_sc_hd__decap_6
XFILLER_32_401 VPWR VGND VPWR VGND sky130_ef_sc_hd__decap_12
XFILLER_32_445 VPWR VGND VPWR VGND sky130_ef_sc_hd__decap_12
XFILLER_32_489 VPWR VGND VPWR VGND sky130_ef_sc_hd__decap_12
X_2721_ _0409_ _0460_ VGND VGND VPWR VPWR _0461_ sky130_fd_sc_hd__or2_1
XFILLER_9_641 VPWR VGND VPWR VGND sky130_ef_sc_hd__decap_12
XFILLER_146_837 VPWR VGND VPWR VGND sky130_ef_sc_hd__decap_12
XPHY_EDGE_ROW_132_Right_132 VGND VGND VPWR VPWR sky130_fd_sc_hd__decap_3
XFILLER_9_685 VPWR VGND VPWR VGND sky130_ef_sc_hd__decap_12
X_2652_ a_r3\[0\] a_r3\[1\] VGND VGND VPWR VPWR _0392_ sky130_fd_sc_hd__or2_1
XFILLER_8_195 VGND VGND VPWR VPWR sky130_fd_sc_hd__fill_1
XFILLER_114_701 VPWR VGND VPWR VGND sky130_ef_sc_hd__decap_12
X_2583_ a_r2\[2\] _0327_ VGND VGND VPWR VPWR _0328_ sky130_fd_sc_hd__or2_1
XFILLER_141_553 VGND VGND VPWR VPWR sky130_fd_sc_hd__decap_6
XFILLER_141_597 VPWR VGND VPWR VGND sky130_ef_sc_hd__decap_12
XFILLER_101_428 VPWR VGND VPWR VGND sky130_ef_sc_hd__decap_12
XFILLER_87_629 VPWR VGND VPWR VGND sky130_ef_sc_hd__decap_12
X_3204_ X_crt\[10\] _0912_ VGND VGND VPWR VPWR _0882_ sky130_fd_sc_hd__and2_1
XANTENNA__1651__B A_reg\[13\] VGND VGND VPWR VPWR sky130_fd_sc_hd__diode_2
XFILLER_95_673 VPWR VGND VPWR VGND sky130_ef_sc_hd__decap_12
XFILLER_82_301 VGND VGND VPWR VPWR sky130_fd_sc_hd__decap_6
X_3135_ _0778_ _0799_ VGND VGND VPWR VPWR _0823_ sky130_fd_sc_hd__and2_1
XFILLER_103_27 VPWR VGND VPWR VGND sky130_ef_sc_hd__decap_12
XANTENNA__2609__B1 _0187_ VGND VGND VPWR VPWR sky130_fd_sc_hd__diode_2
XFILLER_55_548 VGND VGND VPWR VPWR sky130_fd_sc_hd__fill_2
X_3066_ _0746_ _0753_ VGND VGND VPWR VPWR _0754_ sky130_fd_sc_hd__or2_1
X_2017_ B_reg\[10\] _1273_ VGND VGND VPWR VPWR _1279_ sky130_fd_sc_hd__xnor2_1
XFILLER_42_209 VGND VGND VPWR VPWR sky130_fd_sc_hd__decap_6
XFILLER_51_765 VPWR VGND VPWR VGND sky130_ef_sc_hd__decap_12
XTAP_TAPCELL_ROW_137_2516 VGND VPWR sky130_fd_sc_hd__tapvpwrvgnd_1
XFILLER_50_253 VPWR VGND VPWR VGND sky130_ef_sc_hd__decap_12
XFILLER_11_629 VPWR VGND VPWR VGND sky130_ef_sc_hd__decap_12
XFILLER_149_653 VPWR VGND VPWR VGND sky130_ef_sc_hd__decap_12
XFILLER_148_141 VPWR VGND VPWR VGND sky130_ef_sc_hd__decap_12
XTAP_TAPCELL_ROW_137_2527 VGND VPWR sky130_fd_sc_hd__tapvpwrvgnd_1
X_2919_ _0562_ _0606_ VGND VGND VPWR VPWR _0607_ sky130_fd_sc_hd__nand2_2
XFILLER_10_139 VGND VGND VPWR VPWR sky130_fd_sc_hd__fill_1
XFILLER_149_697 VPWR VGND VPWR VGND sky130_ef_sc_hd__decap_12
XTAP_TAPCELL_ROW_21_668 VGND VPWR sky130_fd_sc_hd__tapvpwrvgnd_1
XTAP_TAPCELL_ROW_150_2738 VGND VPWR sky130_fd_sc_hd__tapvpwrvgnd_1
XTAP_TAPCELL_ROW_150_2727 VGND VPWR sky130_fd_sc_hd__tapvpwrvgnd_1
XFILLER_151_317 VPWR VGND VPWR VGND sky130_ef_sc_hd__decap_12
XFILLER_117_561 VPWR VGND VPWR VGND sky130_ef_sc_hd__decap_12
XFILLER_132_531 VGND VGND VPWR VPWR sky130_fd_sc_hd__fill_1
XTAP_TAPCELL_ROW_57_1242 VGND VPWR sky130_fd_sc_hd__tapvpwrvgnd_1
XFILLER_3_839 VGND VGND VPWR VPWR sky130_fd_sc_hd__fill_1
XFILLER_104_233 VPWR VGND VPWR VGND sky130_ef_sc_hd__decap_12
XANTENNA__2560__A2 _0910_ VGND VGND VPWR VPWR sky130_fd_sc_hd__diode_2
XFILLER_120_737 VPWR VGND VPWR VGND sky130_ef_sc_hd__decap_12
XFILLER_104_277 VPWR VGND VPWR VGND sky130_ef_sc_hd__decap_12
XFILLER_59_821 VGND VGND VPWR VPWR sky130_fd_sc_hd__decap_6
XFILLER_86_651 VGND VGND VPWR VPWR sky130_fd_sc_hd__fill_1
XTAP_TAPCELL_ROW_70_1453 VGND VPWR sky130_fd_sc_hd__tapvpwrvgnd_1
XFILLER_59_865 VPWR VGND VPWR VGND sky130_ef_sc_hd__decap_12
XFILLER_92_109 VPWR VGND VPWR VGND sky130_ef_sc_hd__decap_12
XFILLER_74_813 VPWR VGND VPWR VGND sky130_ef_sc_hd__decap_12
XFILLER_74_802 VGND VGND VPWR VPWR sky130_fd_sc_hd__decap_8
XFILLER_46_504 VPWR VGND VPWR VGND sky130_ef_sc_hd__decap_12
XFILLER_19_729 VPWR VGND VPWR VGND sky130_ef_sc_hd__decap_12
XFILLER_61_529 VPWR VGND VPWR VGND sky130_ef_sc_hd__decap_12
XFILLER_14_412 VGND VGND VPWR VPWR sky130_fd_sc_hd__decap_8
XFILLER_26_261 VGND VGND VPWR VPWR sky130_fd_sc_hd__fill_1
XFILLER_14_489 VPWR VGND VPWR VGND sky130_ef_sc_hd__decap_12
XANTENNA__3277__Q A_reg\[3\] VGND VGND VPWR VPWR sky130_fd_sc_hd__diode_2
XFILLER_128_837 VPWR VGND VPWR VGND sky130_ef_sc_hd__decap_12
XTAP_TAPCELL_ROW_40_966 VGND VPWR sky130_fd_sc_hd__tapvpwrvgnd_1
XTAP_TAPCELL_ROW_40_977 VGND VPWR sky130_fd_sc_hd__tapvpwrvgnd_1
XANTENNA__3219__CLK clknet_3_3__leaf_clk VGND VGND VPWR VPWR sky130_fd_sc_hd__diode_2
XFILLER_6_666 VPWR VGND VPWR VGND sky130_ef_sc_hd__decap_12
XFILLER_136_881 VPWR VGND VPWR VGND sky130_ef_sc_hd__decap_12
XFILLER_135_391 VGND VGND VPWR VPWR sky130_fd_sc_hd__fill_1
XFILLER_123_553 VGND VGND VPWR VPWR sky130_fd_sc_hd__decap_6
XFILLER_2_861 VGND VGND VPWR VPWR sky130_fd_sc_hd__decap_6
XFILLER_151_895 VGND VGND VPWR VPWR sky130_fd_sc_hd__fill_1
XFILLER_123_597 VPWR VGND VPWR VGND sky130_ef_sc_hd__decap_12
XFILLER_69_629 VGND VGND VPWR VPWR sky130_fd_sc_hd__fill_1
XFILLER_68_106 VPWR VGND VPWR VGND sky130_ef_sc_hd__decap_12
XTAP_TAPCELL_ROW_9_482 VGND VPWR sky130_fd_sc_hd__tapvpwrvgnd_1
XTAP_TAPCELL_ROW_9_471 VGND VPWR sky130_fd_sc_hd__tapvpwrvgnd_1
XFILLER_1_393 VPWR VGND VPWR VGND sky130_ef_sc_hd__decap_12
XANTENNA__2839__A0 net12 VGND VGND VPWR VPWR sky130_fd_sc_hd__diode_2
XFILLER_83_109 VGND VGND VPWR VPWR sky130_fd_sc_hd__decap_3
XFILLER_77_673 VPWR VGND VPWR VGND sky130_ef_sc_hd__decap_12
XFILLER_64_301 VGND VGND VPWR VPWR sky130_fd_sc_hd__decap_6
XFILLER_49_353 VPWR VGND VPWR VGND sky130_ef_sc_hd__decap_12
XFILLER_92_643 VGND VGND VPWR VPWR sky130_fd_sc_hd__fill_1
XTAP_TAPCELL_ROW_88_1747 VGND VPWR sky130_fd_sc_hd__tapvpwrvgnd_1
XTAP_TAPCELL_ROW_88_1736 VGND VPWR sky130_fd_sc_hd__tapvpwrvgnd_1
XFILLER_80_805 VGND VGND VPWR VPWR sky130_fd_sc_hd__decap_6
XFILLER_52_518 VPWR VGND VPWR VGND sky130_ef_sc_hd__decap_12
XFILLER_24_209 VPWR VGND VPWR VGND sky130_ef_sc_hd__decap_12
XFILLER_80_849 VPWR VGND VPWR VGND sky130_ef_sc_hd__decap_12
XFILLER_64_389 VPWR VGND VPWR VGND sky130_ef_sc_hd__decap_12
XFILLER_17_261 VGND VGND VPWR VPWR sky130_fd_sc_hd__fill_2
XFILLER_33_721 VGND VGND VPWR VPWR sky130_fd_sc_hd__decap_6
XFILLER_33_765 VGND VGND VPWR VPWR sky130_fd_sc_hd__decap_4
XFILLER_60_584 VGND VGND VPWR VPWR sky130_fd_sc_hd__decap_4
XFILLER_32_253 VGND VGND VPWR VPWR sky130_fd_sc_hd__decap_6
XFILLER_33_776 VGND VGND VPWR VPWR sky130_fd_sc_hd__decap_8
XTAP_TAPCELL_ROW_119_2235 VGND VPWR sky130_fd_sc_hd__tapvpwrvgnd_1
XFILLER_32_286 VGND VGND VPWR VPWR sky130_fd_sc_hd__decap_3
XFILLER_146_601 VPWR VGND VPWR VGND sky130_ef_sc_hd__decap_12
XFILLER_146_645 VPWR VGND VPWR VGND sky130_ef_sc_hd__decap_12
XFILLER_145_111 VGND VGND VPWR VPWR sky130_fd_sc_hd__fill_1
X_2704_ _0428_ _0442_ VGND VGND VPWR VPWR _0444_ sky130_fd_sc_hd__or2_1
XANTENNA__3272__RESET_B net36 VGND VGND VPWR VPWR sky130_fd_sc_hd__diode_2
XTAP_TAPCELL_ROW_132_2446 VGND VPWR sky130_fd_sc_hd__tapvpwrvgnd_1
XFILLER_133_317 VPWR VGND VPWR VGND sky130_ef_sc_hd__decap_12
X_2635_ _0373_ _0376_ VGND VGND VPWR VPWR _0379_ sky130_fd_sc_hd__nor2_1
XFILLER_114_531 VGND VGND VPWR VPWR sky130_fd_sc_hd__fill_1
XFILLER_88_905 VGND VGND VPWR VPWR sky130_fd_sc_hd__decap_4
X_2566_ _0308_ _0310_ VGND VGND VPWR VPWR _0311_ sky130_fd_sc_hd__and2b_1
XFILLER_0_809 VGND VGND VPWR VPWR sky130_fd_sc_hd__decap_3
XFILLER_141_361 VPWR VGND VPWR VGND sky130_ef_sc_hd__decap_12
XFILLER_102_737 VPWR VGND VPWR VGND sky130_ef_sc_hd__decap_12
XFILLER_87_426 VPWR VGND VPWR VGND sky130_ef_sc_hd__decap_12
X_2497_ a_r1\[0\] a_r1\[1\] a_r1\[2\] VGND VGND VPWR VPWR _0245_ sky130_fd_sc_hd__and3_1
XFILLER_114_15 VPWR VGND VPWR VGND sky130_ef_sc_hd__decap_12
XFILLER_101_225 VPWR VGND VPWR VGND sky130_ef_sc_hd__decap_12
XFILLER_74_109 VPWR VGND VPWR VGND sky130_ef_sc_hd__decap_12
XTAP_TAPCELL_ROW_52_1161 VGND VPWR sky130_fd_sc_hd__tapvpwrvgnd_1
XFILLER_110_781 VPWR VGND VPWR VGND sky130_ef_sc_hd__decap_12
XFILLER_67_161 VGND VGND VPWR VPWR sky130_fd_sc_hd__decap_6
XFILLER_56_835 VPWR VGND VPWR VGND sky130_ef_sc_hd__decap_12
X_3118_ _0778_ _0791_ _0793_ _0798_ VGND VGND VPWR VPWR _0806_ sky130_fd_sc_hd__and4_1
XFILLER_83_665 VGND VGND VPWR VPWR sky130_fd_sc_hd__decap_6
XFILLER_82_153 VPWR VGND VPWR VGND sky130_ef_sc_hd__decap_12
XFILLER_82_175 VGND VGND VPWR VPWR sky130_fd_sc_hd__decap_8
XFILLER_55_378 VGND VGND VPWR VPWR sky130_fd_sc_hd__fill_1
X_3049_ _0623_ _0736_ _0735_ VGND VGND VPWR VPWR _0737_ sky130_fd_sc_hd__o21a_1
XFILLER_90_18 VGND VGND VPWR VPWR sky130_fd_sc_hd__fill_1
XFILLER_82_197 VPWR VGND VPWR VGND sky130_ef_sc_hd__decap_12
XFILLER_12_905 VGND VGND VPWR VPWR sky130_fd_sc_hd__decap_4
XTAP_TAPCELL_ROW_26_749 VGND VPWR sky130_fd_sc_hd__tapvpwrvgnd_1
XFILLER_90_29 VGND VGND VPWR VPWR sky130_fd_sc_hd__fill_1
XFILLER_51_573 VPWR VGND VPWR VGND sky130_ef_sc_hd__decap_12
XFILLER_8_909 VGND VGND VPWR VPWR sky130_fd_sc_hd__fill_1
XFILLER_149_461 VPWR VGND VPWR VGND sky130_ef_sc_hd__decap_12
XFILLER_136_133 VGND VGND VPWR VPWR sky130_fd_sc_hd__decap_6
XFILLER_99_27 VPWR VGND VPWR VGND sky130_ef_sc_hd__decap_12
XFILLER_152_637 VGND VGND VPWR VPWR sky130_fd_sc_hd__decap_6
XFILLER_151_125 VPWR VGND VPWR VGND sky130_ef_sc_hd__decap_12
XFILLER_136_177 VPWR VGND VPWR VGND sky130_ef_sc_hd__decap_12
XFILLER_118_881 VPWR VGND VPWR VGND sky130_ef_sc_hd__decap_12
XFILLER_3_614 VGND VGND VPWR VPWR sky130_fd_sc_hd__fill_2
XFILLER_151_169 VPWR VGND VPWR VGND sky130_ef_sc_hd__decap_12
XFILLER_117_391 VGND VGND VPWR VPWR sky130_fd_sc_hd__fill_1
XFILLER_133_895 VGND VGND VPWR VPWR sky130_fd_sc_hd__fill_1
XFILLER_120_501 VPWR VGND VPWR VGND sky130_ef_sc_hd__decap_12
XFILLER_120_545 VPWR VGND VPWR VGND sky130_ef_sc_hd__decap_12
XTAP_TAPCELL_ROW_6_430 VGND VPWR sky130_fd_sc_hd__tapvpwrvgnd_1
XFILLER_120_589 VPWR VGND VPWR VGND sky130_ef_sc_hd__decap_12
XFILLER_93_429 VGND VGND VPWR VPWR sky130_fd_sc_hd__decap_8
XFILLER_59_673 VPWR VGND VPWR VGND sky130_ef_sc_hd__decap_12
XFILLER_48_75 VGND VGND VPWR VPWR sky130_fd_sc_hd__decap_8
XFILLER_74_643 VGND VGND VPWR VPWR sky130_fd_sc_hd__fill_1
XFILLER_48_97 VPWR VGND VPWR VGND sky130_ef_sc_hd__decap_12
XFILLER_73_153 VPWR VGND VPWR VGND sky130_ef_sc_hd__decap_12
XFILLER_62_805 VGND VGND VPWR VPWR sky130_fd_sc_hd__decap_6
XFILLER_47_879 VGND VGND VPWR VPWR sky130_fd_sc_hd__decap_6
XFILLER_0_27 VGND VGND VPWR VPWR sky130_fd_sc_hd__fill_1
XFILLER_19_559 VGND VGND VPWR VPWR sky130_fd_sc_hd__fill_1
XFILLER_46_345 VPWR VGND VPWR VGND sky130_ef_sc_hd__decap_12
XFILLER_64_41 VPWR VGND VPWR VGND sky130_ef_sc_hd__decap_12
XFILLER_15_721 VGND VGND VPWR VPWR sky130_fd_sc_hd__decap_6
XFILLER_46_389 VPWR VGND VPWR VGND sky130_ef_sc_hd__decap_12
XTAP_TAPCELL_ROW_83_1655 VGND VPWR sky130_fd_sc_hd__tapvpwrvgnd_1
XFILLER_73_197 VPWR VGND VPWR VGND sky130_ef_sc_hd__decap_12
XFILLER_64_85 VPWR VGND VPWR VGND sky130_ef_sc_hd__decap_12
XFILLER_61_337 VPWR VGND VPWR VGND sky130_ef_sc_hd__decap_12
XTAP_TAPCELL_ROW_83_1666 VGND VPWR sky130_fd_sc_hd__tapvpwrvgnd_1
XFILLER_15_765 VPWR VGND VPWR VGND sky130_ef_sc_hd__decap_12
XFILLER_30_713 VPWR VGND VPWR VGND sky130_ef_sc_hd__decap_12
XFILLER_70_893 VPWR VGND VPWR VGND sky130_ef_sc_hd__decap_12
XFILLER_9_69 VPWR VGND VPWR VGND sky130_ef_sc_hd__decap_12
XFILLER_14_275 VPWR VGND VPWR VGND sky130_ef_sc_hd__decap_12
XFILLER_30_757 VPWR VGND VPWR VGND sky130_ef_sc_hd__decap_12
XFILLER_128_601 VPWR VGND VPWR VGND sky130_ef_sc_hd__decap_12
XFILLER_128_645 VPWR VGND VPWR VGND sky130_ef_sc_hd__decap_12
XFILLER_127_111 VGND VGND VPWR VPWR sky130_fd_sc_hd__fill_1
XFILLER_143_615 VGND VGND VPWR VPWR sky130_fd_sc_hd__fill_1
XFILLER_115_317 VPWR VGND VPWR VGND sky130_ef_sc_hd__decap_12
XTAP_TAPCELL_ROW_114_2154 VGND VPWR sky130_fd_sc_hd__tapvpwrvgnd_1
X_2420_ _0169_ _0170_ _0173_ VGND VGND VPWR VPWR _0174_ sky130_fd_sc_hd__a21o_1
XFILLER_130_309 VPWR VGND VPWR VGND sky130_ef_sc_hd__decap_12
XFILLER_123_361 VPWR VGND VPWR VGND sky130_ef_sc_hd__decap_12
X_2351_ _1601_ _1603_ VGND VGND VPWR VPWR _0105_ sky130_fd_sc_hd__nor2_1
XFILLER_96_245 VGND VGND VPWR VPWR sky130_fd_sc_hd__decap_6
X_2282_ _1523_ _1529_ _1538_ VGND VGND VPWR VPWR _1539_ sky130_fd_sc_hd__a21boi_1
XFILLER_56_109 VGND VGND VPWR VPWR sky130_fd_sc_hd__decap_3
XFILLER_29_3 VPWR VGND VPWR VGND sky130_ef_sc_hd__decap_12
XFILLER_38_813 VPWR VGND VPWR VGND sky130_ef_sc_hd__decap_12
XFILLER_96_289 VGND VGND VPWR VPWR sky130_fd_sc_hd__fill_2
XFILLER_49_161 VGND VGND VPWR VPWR sky130_fd_sc_hd__decap_6
XFILLER_37_367 VPWR VGND VPWR VGND sky130_ef_sc_hd__decap_12
XFILLER_38_879 VGND VGND VPWR VPWR sky130_fd_sc_hd__fill_1
XFILLER_25_529 VPWR VGND VPWR VGND sky130_ef_sc_hd__decap_12
XFILLER_80_657 VPWR VGND VPWR VGND sky130_ef_sc_hd__decap_12
XFILLER_18_581 VGND VGND VPWR VPWR sky130_fd_sc_hd__decap_6
XFILLER_61_860 VPWR VGND VPWR VGND sky130_ef_sc_hd__decap_12
XANTENNA__2460__A1 OpSel_reg\[0\] VGND VGND VPWR VPWR sky130_fd_sc_hd__diode_2
X_1997_ _1256_ _1258_ _1255_ VGND VGND VPWR VPWR _1259_ sky130_fd_sc_hd__o21a_1
XFILLER_20_245 VGND VGND VPWR VPWR sky130_fd_sc_hd__decap_6
XANTENNA__2212__A1 A_reg\[7\] VGND VGND VPWR VPWR sky130_fd_sc_hd__diode_2
XFILLER_146_475 VGND VGND VPWR VPWR sky130_fd_sc_hd__fill_1
XFILLER_118_133 VGND VGND VPWR VPWR sky130_fd_sc_hd__decap_6
XFILLER_109_15 VPWR VGND VPWR VGND sky130_ef_sc_hd__decap_12
XFILLER_134_637 VGND VGND VPWR VPWR sky130_fd_sc_hd__decap_6
XFILLER_133_125 VPWR VGND VPWR VGND sky130_ef_sc_hd__decap_12
XFILLER_118_177 VPWR VGND VPWR VGND sky130_ef_sc_hd__decap_12
X_2618_ _0187_ _0360_ _0362_ _0319_ VGND VGND VPWR VPWR _0363_ sky130_fd_sc_hd__o22a_1
XTAP_TAPCELL_ROW_54_1201 VGND VPWR sky130_fd_sc_hd__tapvpwrvgnd_1
XFILLER_142_681 VPWR VGND VPWR VGND sky130_ef_sc_hd__decap_12
XFILLER_133_169 VPWR VGND VPWR VGND sky130_ef_sc_hd__decap_12
XFILLER_115_895 VGND VGND VPWR VPWR sky130_fd_sc_hd__fill_1
XFILLER_88_713 VPWR VGND VPWR VGND sky130_ef_sc_hd__decap_12
X_2549_ _0290_ _0280_ _0285_ VGND VGND VPWR VPWR _0297_ sky130_fd_sc_hd__mux2_1
XFILLER_0_617 VPWR VGND VPWR VGND sky130_ef_sc_hd__decap_12
XFILLER_102_545 VPWR VGND VPWR VGND sky130_ef_sc_hd__decap_12
XFILLER_88_757 VPWR VGND VPWR VGND sky130_ef_sc_hd__decap_12
XFILLER_87_223 VGND VGND VPWR VPWR sky130_fd_sc_hd__fill_1
XFILLER_125_69 VPWR VGND VPWR VGND sky130_ef_sc_hd__decap_12
XFILLER_102_589 VPWR VGND VPWR VGND sky130_ef_sc_hd__decap_12
XFILLER_87_267 VPWR VGND VPWR VGND sky130_ef_sc_hd__decap_12
XTAP_TAPCELL_ROW_145_2659 VGND VPWR sky130_fd_sc_hd__tapvpwrvgnd_1
XTAP_TAPCELL_ROW_145_2648 VGND VPWR sky130_fd_sc_hd__tapvpwrvgnd_1
XFILLER_75_429 VPWR VGND VPWR VGND sky130_ef_sc_hd__decap_12
XFILLER_28_323 VPWR VGND VPWR VGND sky130_ef_sc_hd__decap_12
XFILLER_44_805 VGND VGND VPWR VPWR sky130_fd_sc_hd__decap_6
XFILLER_141_57 VPWR VGND VPWR VGND sky130_ef_sc_hd__decap_12
XANTENNA__2427__S Encode_EN VGND VGND VPWR VPWR sky130_fd_sc_hd__diode_2
XFILLER_83_473 VGND VGND VPWR VPWR sky130_fd_sc_hd__decap_8
XFILLER_44_849 VPWR VGND VPWR VGND sky130_ef_sc_hd__decap_12
XFILLER_70_123 VGND VGND VPWR VPWR sky130_fd_sc_hd__fill_1
XTAP_TAPCELL_ROW_65_1374 VGND VPWR sky130_fd_sc_hd__tapvpwrvgnd_1
XFILLER_12_713 VPWR VGND VPWR VGND sky130_ef_sc_hd__decap_12
XFILLER_11_223 VGND VGND VPWR VPWR sky130_fd_sc_hd__fill_1
XFILLER_34_77 VGND VGND VPWR VPWR sky130_fd_sc_hd__decap_6
XFILLER_133_3 VPWR VGND VPWR VGND sky130_ef_sc_hd__decap_12
XFILLER_7_205 VPWR VGND VPWR VGND sky130_ef_sc_hd__decap_12
XFILLER_12_757 VPWR VGND VPWR VGND sky130_ef_sc_hd__decap_12
XFILLER_109_111 VGND VGND VPWR VPWR sky130_fd_sc_hd__fill_1
XFILLER_11_289 VPWR VGND VPWR VGND sky130_ef_sc_hd__decap_12
XFILLER_125_615 VGND VGND VPWR VPWR sky130_fd_sc_hd__fill_1
XFILLER_7_249 VPWR VGND VPWR VGND sky130_ef_sc_hd__decap_12
XFILLER_152_401 VPWR VGND VPWR VGND sky130_ef_sc_hd__decap_12
XFILLER_137_497 VGND VGND VPWR VPWR sky130_fd_sc_hd__decap_6
XFILLER_3_411 VPWR VGND VPWR VGND sky130_ef_sc_hd__decap_12
XFILLER_152_445 VPWR VGND VPWR VGND sky130_ef_sc_hd__decap_12
XFILLER_152_489 VPWR VGND VPWR VGND sky130_ef_sc_hd__decap_12
XFILLER_121_821 VPWR VGND VPWR VGND sky130_ef_sc_hd__decap_12
XFILLER_112_309 VPWR VGND VPWR VGND sky130_ef_sc_hd__decap_12
XFILLER_105_361 VPWR VGND VPWR VGND sky130_ef_sc_hd__decap_12
XFILLER_79_746 VPWR VGND VPWR VGND sky130_ef_sc_hd__decap_12
XFILLER_121_865 VPWR VGND VPWR VGND sky130_ef_sc_hd__decap_12
XFILLER_66_418 VGND VGND VPWR VPWR sky130_fd_sc_hd__fill_2
XFILLER_38_109 VPWR VGND VPWR VGND sky130_ef_sc_hd__decap_12
XFILLER_94_749 VGND VGND VPWR VPWR sky130_fd_sc_hd__decap_6
XFILLER_93_237 VPWR VGND VPWR VGND sky130_ef_sc_hd__decap_12
XFILLER_47_698 VPWR VGND VPWR VGND sky130_ef_sc_hd__decap_12
XFILLER_19_378 VPWR VGND VPWR VGND sky130_ef_sc_hd__decap_12
XFILLER_46_153 VPWR VGND VPWR VGND sky130_ef_sc_hd__decap_12
XFILLER_46_197 VPWR VGND VPWR VGND sky130_ef_sc_hd__decap_12
X_1920_ _1168_ _1184_ VGND VGND VPWR VPWR _1185_ sky130_fd_sc_hd__xor2_2
XFILLER_15_573 VPWR VGND VPWR VGND sky130_ef_sc_hd__decap_12
XFILLER_42_370 VGND VGND VPWR VPWR sky130_fd_sc_hd__fill_1
XFILLER_147_217 VGND VGND VPWR VPWR sky130_fd_sc_hd__decap_6
X_1851_ _1118_ _1120_ VGND VGND VPWR VPWR _1121_ sky130_fd_sc_hd__nor2_1
XFILLER_30_576 VPWR VGND VPWR VGND sky130_ef_sc_hd__decap_12
X_1782_ A_reg\[7\] _1047_ _1050_ _1054_ VGND VGND VPWR VPWR _1055_ sky130_fd_sc_hd__a31o_1
XFILLER_128_475 VGND VGND VPWR VPWR sky130_fd_sc_hd__fill_1
XFILLER_116_637 VGND VGND VPWR VPWR sky130_fd_sc_hd__decap_6
XTAP_TAPCELL_ROW_96_1868 VGND VPWR sky130_fd_sc_hd__tapvpwrvgnd_1
XFILLER_7_783 VGND VGND VPWR VPWR sky130_fd_sc_hd__fill_1
XFILLER_115_125 VPWR VGND VPWR VGND sky130_ef_sc_hd__decap_12
XFILLER_131_629 VPWR VGND VPWR VGND sky130_ef_sc_hd__decap_12
XFILLER_115_169 VPWR VGND VPWR VGND sky130_ef_sc_hd__decap_12
X_2403_ _0147_ _0156_ VGND VGND VPWR VPWR _0157_ sky130_fd_sc_hd__xnor2_1
XFILLER_130_139 VGND VGND VPWR VPWR sky130_fd_sc_hd__fill_1
XFILLER_124_681 VPWR VGND VPWR VGND sky130_ef_sc_hd__decap_12
XFILLER_69_223 VGND VGND VPWR VPWR sky130_fd_sc_hd__fill_1
X_2334_ _1583_ _1584_ _1586_ VGND VGND VPWR VPWR _1587_ sky130_fd_sc_hd__a21o_1
XANTENNA__1705__B1 A_reg\[3\] VGND VGND VPWR VPWR sky130_fd_sc_hd__diode_2
XFILLER_85_727 VGND VGND VPWR VPWR sky130_fd_sc_hd__fill_1
XTAP_TAPCELL_ROW_127_2356 VGND VPWR sky130_fd_sc_hd__tapvpwrvgnd_1
X_2265_ _1509_ _1519_ _1512_ VGND VGND VPWR VPWR _1522_ sky130_fd_sc_hd__a21oi_1
XTAP_TAPCELL_ROW_127_2367 VGND VPWR sky130_fd_sc_hd__tapvpwrvgnd_1
X_2196_ _1447_ _1452_ VGND VGND VPWR VPWR _1453_ sky130_fd_sc_hd__and2_1
XFILLER_26_805 VGND VGND VPWR VPWR sky130_fd_sc_hd__decap_6
XFILLER_38_643 VGND VGND VPWR VPWR sky130_fd_sc_hd__fill_1
XFILLER_1_81 VPWR VGND VPWR VGND sky130_ef_sc_hd__decap_12
XTAP_TAPCELL_ROW_140_2567 VGND VPWR sky130_fd_sc_hd__tapvpwrvgnd_1
XFILLER_111_27 VPWR VGND VPWR VGND sky130_ef_sc_hd__decap_12
XFILLER_80_421 VPWR VGND VPWR VGND sky130_ef_sc_hd__decap_12
XFILLER_25_337 VPWR VGND VPWR VGND sky130_ef_sc_hd__decap_12
XFILLER_26_849 VPWR VGND VPWR VGND sky130_ef_sc_hd__decap_12
XTAP_TAPCELL_ROW_140_2578 VGND VPWR sky130_fd_sc_hd__tapvpwrvgnd_1
XFILLER_40_307 VGND VGND VPWR VPWR sky130_fd_sc_hd__fill_1
XANTENNA__2433__A1 Encode_EN VGND VGND VPWR VPWR sky130_fd_sc_hd__diode_2
XTAP_TAPCELL_ROW_47_1082 VGND VPWR sky130_fd_sc_hd__tapvpwrvgnd_1
XFILLER_139_729 VPWR VGND VPWR VGND sky130_ef_sc_hd__decap_12
XTAP_TAPCELL_ROW_16_590 VGND VPWR sky130_fd_sc_hd__tapvpwrvgnd_1
XFILLER_153_209 VPWR VGND VPWR VGND sky130_ef_sc_hd__decap_12
XTAP_TAPCELL_ROW_60_1293 VGND VPWR sky130_fd_sc_hd__tapvpwrvgnd_1
XFILLER_5_709 VPWR VGND VPWR VGND sky130_ef_sc_hd__decap_12
XFILLER_134_401 VPWR VGND VPWR VGND sky130_ef_sc_hd__decap_12
XFILLER_119_497 VGND VGND VPWR VPWR sky130_fd_sc_hd__decap_6
XFILLER_107_615 VGND VGND VPWR VPWR sky130_fd_sc_hd__fill_1
XFILLER_150_905 VGND VGND VPWR VPWR sky130_fd_sc_hd__decap_4
XFILLER_134_445 VPWR VGND VPWR VGND sky130_ef_sc_hd__decap_12
XFILLER_134_489 VPWR VGND VPWR VGND sky130_ef_sc_hd__decap_12
XFILLER_103_821 VPWR VGND VPWR VGND sky130_ef_sc_hd__decap_12
XFILLER_103_865 VPWR VGND VPWR VGND sky130_ef_sc_hd__decap_12
XFILLER_88_587 VGND VGND VPWR VPWR sky130_fd_sc_hd__fill_1
XFILLER_75_237 VPWR VGND VPWR VGND sky130_ef_sc_hd__decap_12
XFILLER_29_55 VGND VGND VPWR VPWR sky130_fd_sc_hd__fill_1
XFILLER_29_665 VGND VGND VPWR VPWR sky130_fd_sc_hd__decap_6
XFILLER_84_793 VPWR VGND VPWR VGND sky130_ef_sc_hd__decap_12
XTAP_TAPCELL_ROW_67_1403 VGND VPWR sky130_fd_sc_hd__tapvpwrvgnd_1
XFILLER_28_153 VPWR VGND VPWR VGND sky130_ef_sc_hd__decap_12
XFILLER_44_613 VGND VGND VPWR VPWR sky130_fd_sc_hd__decap_8
XFILLER_83_281 VPWR VGND VPWR VGND sky130_ef_sc_hd__decap_12
XFILLER_28_197 VPWR VGND VPWR VGND sky130_ef_sc_hd__decap_12
XFILLER_44_657 VPWR VGND VPWR VGND sky130_ef_sc_hd__decap_12
XANTENNA__3304__RESET_B net36 VGND VGND VPWR VPWR sky130_fd_sc_hd__diode_2
XFILLER_16_359 VGND VGND VPWR VPWR sky130_fd_sc_hd__decap_4
XTAP_TAPCELL_ROW_80_1614 VGND VPWR sky130_fd_sc_hd__tapvpwrvgnd_1
XFILLER_129_217 VGND VGND VPWR VPWR sky130_fd_sc_hd__decap_6
XFILLER_101_93 VPWR VGND VPWR VGND sky130_ef_sc_hd__decap_12
XTAP_TAPCELL_ROW_14_549 VGND VPWR sky130_fd_sc_hd__tapvpwrvgnd_1
XFILLER_8_525 VGND VGND VPWR VPWR sky130_fd_sc_hd__decap_6
XFILLER_12_565 VGND VGND VPWR VPWR sky130_fd_sc_hd__fill_1
XFILLER_144_209 VPWR VGND VPWR VGND sky130_ef_sc_hd__decap_12
XFILLER_6_15 VPWR VGND VPWR VGND sky130_ef_sc_hd__decap_12
XFILLER_137_261 VPWR VGND VPWR VGND sky130_ef_sc_hd__decap_12
XANTENNA__3285__Q A_reg\[11\] VGND VGND VPWR VPWR sky130_fd_sc_hd__diode_2
XTAP_TAPCELL_ROW_111_2113 VGND VPWR sky130_fd_sc_hd__tapvpwrvgnd_1
XTAP_TAPCELL_ROW_111_2102 VGND VPWR sky130_fd_sc_hd__tapvpwrvgnd_1
XTAP_TAPCELL_ROW_78_1587 VGND VPWR sky130_fd_sc_hd__tapvpwrvgnd_1
XTAP_TAPCELL_ROW_78_1576 VGND VPWR sky130_fd_sc_hd__tapvpwrvgnd_1
XFILLER_152_253 VPWR VGND VPWR VGND sky130_ef_sc_hd__decap_12
XFILLER_113_629 VPWR VGND VPWR VGND sky130_ef_sc_hd__decap_12
XFILLER_98_318 VPWR VGND VPWR VGND sky130_ef_sc_hd__decap_12
XFILLER_112_139 VGND VGND VPWR VPWR sky130_fd_sc_hd__fill_1
XFILLER_106_681 VPWR VGND VPWR VGND sky130_ef_sc_hd__decap_12
XFILLER_3_274 VGND VGND VPWR VPWR sky130_fd_sc_hd__decap_6
XTAP_TAPCELL_ROW_91_1787 VGND VPWR sky130_fd_sc_hd__tapvpwrvgnd_1
XFILLER_79_576 VPWR VGND VPWR VGND sky130_ef_sc_hd__decap_12
XFILLER_121_673 VPWR VGND VPWR VGND sky130_ef_sc_hd__decap_12
XFILLER_94_513 VPWR VGND VPWR VGND sky130_ef_sc_hd__decap_12
XFILLER_86_83 VGND VGND VPWR VPWR sky130_fd_sc_hd__fill_1
XFILLER_66_215 VPWR VGND VPWR VGND sky130_ef_sc_hd__decap_12
XFILLER_94_579 VGND VGND VPWR VPWR sky130_fd_sc_hd__decap_8
XFILLER_94_557 VGND VGND VPWR VPWR sky130_fd_sc_hd__decap_6
X_2050_ B_reg\[5\] _1311_ _1309_ _1308_ VGND VGND VPWR VPWR _1312_ sky130_fd_sc_hd__a2bb2o_1
XTAP_TAPCELL_ROW_109_2075 VGND VPWR sky130_fd_sc_hd__tapvpwrvgnd_1
XFILLER_47_473 VGND VGND VPWR VPWR sky130_fd_sc_hd__decap_4
XFILLER_62_421 VPWR VGND VPWR VGND sky130_ef_sc_hd__decap_12
XTAP_TAPCELL_ROW_122_2286 VGND VPWR sky130_fd_sc_hd__tapvpwrvgnd_1
XFILLER_96_3 VPWR VGND VPWR VGND sky130_ef_sc_hd__decap_12
X_2952_ _0604_ _0639_ VGND VGND VPWR VPWR _0640_ sky130_fd_sc_hd__or2_1
XFILLER_50_638 VGND VGND VPWR VPWR sky130_fd_sc_hd__decap_6
XFILLER_15_381 VGND VGND VPWR VPWR sky130_fd_sc_hd__fill_1
XFILLER_16_893 VPWR VGND VPWR VGND sky130_ef_sc_hd__decap_12
XFILLER_34_189 VGND VGND VPWR VPWR sky130_fd_sc_hd__decap_6
X_1903_ B_reg\[13\] _1167_ VGND VGND VPWR VPWR _1168_ sky130_fd_sc_hd__nand2_1
XFILLER_31_863 VPWR VGND VPWR VGND sky130_ef_sc_hd__decap_12
XTAP_TAPCELL_ROW_33_858 VGND VPWR sky130_fd_sc_hd__tapvpwrvgnd_1
X_2883_ u_crt.r3\[3\] u_crt.r3\[0\] VGND VGND VPWR VPWR _0571_ sky130_fd_sc_hd__xnor2_2
XANTENNA__2179__B1 A_reg\[9\] VGND VGND VPWR VPWR sky130_fd_sc_hd__diode_2
X_1834_ A_reg\[0\] _1106_ VGND VGND VPWR VPWR _1107_ sky130_fd_sc_hd__or2_1
XFILLER_116_401 VPWR VGND VPWR VGND sky130_ef_sc_hd__decap_12
X_1765_ _1033_ _1037_ A_reg\[9\] VGND VGND VPWR VPWR _1038_ sky130_fd_sc_hd__a21oi_1
XFILLER_132_905 VGND VGND VPWR VPWR sky130_fd_sc_hd__decap_4
XFILLER_116_445 VPWR VGND VPWR VGND sky130_ef_sc_hd__decap_12
XFILLER_116_489 VPWR VGND VPWR VGND sky130_ef_sc_hd__decap_12
X_1696_ _0968_ _0969_ VGND VGND VPWR VPWR _0972_ sky130_fd_sc_hd__or2_1
XFILLER_111_161 VGND VGND VPWR VPWR sky130_fd_sc_hd__decap_6
XFILLER_100_813 VPWR VGND VPWR VGND sky130_ef_sc_hd__decap_12
XFILLER_97_373 VPWR VGND VPWR VGND sky130_ef_sc_hd__decap_12
X_3297_ clknet_3_2__leaf_clk _0080_ net36 VGND VGND VPWR VPWR B_reg\[7\] sky130_fd_sc_hd__dfrtp_4
X_2317_ _1566_ _1569_ VGND VGND VPWR VPWR _1570_ sky130_fd_sc_hd__nand2_1
XTAP_TAPCELL_ROW_142_2607 VGND VPWR sky130_fd_sc_hd__tapvpwrvgnd_1
XFILLER_57_237 VPWR VGND VPWR VGND sky130_ef_sc_hd__decap_12
X_2248_ _1491_ _1495_ _1493_ VGND VGND VPWR VPWR _1505_ sky130_fd_sc_hd__a21oi_1
XFILLER_122_15 VPWR VGND VPWR VGND sky130_ef_sc_hd__decap_12
XTAP_TAPCELL_ROW_49_1111 VGND VPWR sky130_fd_sc_hd__tapvpwrvgnd_1
XFILLER_26_613 VPWR VGND VPWR VGND sky130_ef_sc_hd__decap_12
XFILLER_81_741 VPWR VGND VPWR VGND sky130_ef_sc_hd__decap_12
XFILLER_65_281 VPWR VGND VPWR VGND sky130_ef_sc_hd__decap_12
XTAP_TAPCELL_ROW_49_1122 VGND VPWR sky130_fd_sc_hd__tapvpwrvgnd_1
X_2179_ _1433_ _1434_ A_reg\[9\] _1431_ VGND VGND VPWR VPWR _1436_ sky130_fd_sc_hd__a2bb2o_1
XFILLER_26_657 VPWR VGND VPWR VGND sky130_ef_sc_hd__decap_12
XPHY_EDGE_ROW_146_Right_146 VGND VGND VPWR VPWR sky130_fd_sc_hd__decap_3
XFILLER_81_785 VPWR VGND VPWR VGND sky130_ef_sc_hd__decap_12
XFILLER_25_167 VGND VGND VPWR VPWR sky130_fd_sc_hd__fill_1
XTAP_TAPCELL_ROW_62_1322 VGND VPWR sky130_fd_sc_hd__tapvpwrvgnd_1
XFILLER_15_57 VPWR VGND VPWR VGND sky130_ef_sc_hd__decap_12
XTAP_TAPCELL_ROW_11_508 VGND VPWR sky130_fd_sc_hd__tapvpwrvgnd_1
XFILLER_21_373 VPWR VGND VPWR VGND sky130_ef_sc_hd__decap_12
XFILLER_139_559 VGND VGND VPWR VPWR sky130_fd_sc_hd__fill_1
XFILLER_135_721 VGND VGND VPWR VPWR sky130_fd_sc_hd__decap_6
XFILLER_126_209 VPWR VGND VPWR VGND sky130_ef_sc_hd__decap_12
XFILLER_119_261 VPWR VGND VPWR VGND sky130_ef_sc_hd__decap_12
XFILLER_5_517 VPWR VGND VPWR VGND sky130_ef_sc_hd__decap_12
XFILLER_135_765 VPWR VGND VPWR VGND sky130_ef_sc_hd__decap_12
XFILLER_107_423 VPWR VGND VPWR VGND sky130_ef_sc_hd__decap_12
XFILLER_150_713 VPWR VGND VPWR VGND sky130_ef_sc_hd__decap_12
XFILLER_134_253 VPWR VGND VPWR VGND sky130_ef_sc_hd__decap_12
XFILLER_107_478 VPWR VGND VPWR VGND sky130_ef_sc_hd__decap_12
XFILLER_150_757 VPWR VGND VPWR VGND sky130_ef_sc_hd__decap_12
XANTENNA__3252__CLK clknet_3_6__leaf_clk VGND VGND VPWR VPWR sky130_fd_sc_hd__diode_2
XFILLER_89_841 VPWR VGND VPWR VGND sky130_ef_sc_hd__decap_12
Xoutput45 net45 VGND VGND VPWR VPWR X_out[1] sky130_fd_sc_hd__buf_1
XFILLER_103_673 VPWR VGND VPWR VGND sky130_ef_sc_hd__decap_12
XFILLER_76_513 VPWR VGND VPWR VGND sky130_ef_sc_hd__decap_12
XTAP_TAPCELL_ROW_73_1495 VGND VPWR sky130_fd_sc_hd__tapvpwrvgnd_1
XFILLER_49_727 VGND VGND VPWR VPWR sky130_fd_sc_hd__fill_1
XFILLER_0_277 VGND VGND VPWR VPWR sky130_fd_sc_hd__decap_3
XFILLER_76_557 VPWR VGND VPWR VGND sky130_ef_sc_hd__decap_12
XFILLER_56_20 VGND VGND VPWR VPWR sky130_fd_sc_hd__decap_8
XFILLER_91_505 VPWR VGND VPWR VGND sky130_ef_sc_hd__decap_12
XFILLER_63_218 VGND VGND VPWR VPWR sky130_fd_sc_hd__decap_6
XANTENNA_input16_A A_in[9] VGND VGND VPWR VPWR sky130_fd_sc_hd__diode_2
XFILLER_29_473 VPWR VGND VPWR VGND sky130_ef_sc_hd__decap_12
XFILLER_91_549 VGND VGND VPWR VPWR sky130_fd_sc_hd__decap_8
XFILLER_63_229 VGND VGND VPWR VPWR sky130_fd_sc_hd__fill_1
XFILLER_56_97 VPWR VGND VPWR VGND sky130_ef_sc_hd__decap_12
XFILLER_44_421 VPWR VGND VPWR VGND sky130_ef_sc_hd__decap_12
XPHY_EDGE_ROW_113_Right_113 VGND VGND VPWR VPWR sky130_fd_sc_hd__decap_3
XFILLER_72_752 VGND VGND VPWR VPWR sky130_fd_sc_hd__decap_4
XFILLER_16_189 VGND VGND VPWR VPWR sky130_fd_sc_hd__decap_6
XFILLER_72_74 VGND VGND VPWR VPWR sky130_fd_sc_hd__decap_3
XFILLER_13_841 VPWR VGND VPWR VGND sky130_ef_sc_hd__decap_12
XFILLER_31_137 VPWR VGND VPWR VGND sky130_ef_sc_hd__decap_12
XFILLER_72_96 VPWR VGND VPWR VGND sky130_ef_sc_hd__decap_12
XTAP_TAPCELL_ROW_30_806 VGND VPWR sky130_fd_sc_hd__tapvpwrvgnd_1
XTAP_TAPCELL_ROW_30_817 VGND VPWR sky130_fd_sc_hd__tapvpwrvgnd_1
XFILLER_40_693 VGND VGND VPWR VPWR sky130_fd_sc_hd__decap_6
XFILLER_145_529 VPWR VGND VPWR VGND sky130_ef_sc_hd__decap_12
XFILLER_138_581 VGND VGND VPWR VPWR sky130_fd_sc_hd__decap_6
XFILLER_9_889 VGND VGND VPWR VPWR sky130_fd_sc_hd__decap_6
XFILLER_8_377 VPWR VGND VPWR VGND sky130_ef_sc_hd__decap_12
XTAP_TAPCELL_ROW_93_1816 VGND VPWR sky130_fd_sc_hd__tapvpwrvgnd_1
XFILLER_114_905 VGND VGND VPWR VPWR sky130_fd_sc_hd__decap_4
XTAP_TAPCELL_ROW_93_1827 VGND VPWR sky130_fd_sc_hd__tapvpwrvgnd_1
XFILLER_140_245 VGND VGND VPWR VPWR sky130_fd_sc_hd__decap_6
X_3220_ clknet_3_4__leaf_clk _0008_ net36 VGND VGND VPWR VPWR CU_state_dbg\[0\] sky130_fd_sc_hd__dfrtp_1
XFILLER_140_289 VPWR VGND VPWR VGND sky130_ef_sc_hd__decap_12
XFILLER_100_109 VPWR VGND VPWR VGND sky130_ef_sc_hd__decap_12
XFILLER_97_93 VPWR VGND VPWR VGND sky130_ef_sc_hd__decap_12
XFILLER_95_833 VGND VGND VPWR VPWR sky130_fd_sc_hd__decap_6
X_3151_ _0814_ _0838_ VGND VGND VPWR VPWR _0839_ sky130_fd_sc_hd__and2_1
XFILLER_95_877 VPWR VGND VPWR VGND sky130_ef_sc_hd__decap_12
XANTENNA__3297__RESET_B net36 VGND VGND VPWR VPWR sky130_fd_sc_hd__diode_2
X_2102_ _1356_ _1360_ _0898_ VGND VGND VPWR VPWR _1361_ sky130_fd_sc_hd__a21o_1
XFILLER_11_3 VPWR VGND VPWR VGND sky130_ef_sc_hd__decap_12
XTAP_TAPCELL_ROW_124_2315 VGND VPWR sky130_fd_sc_hd__tapvpwrvgnd_1
XANTENNA__3226__RESET_B net36 VGND VGND VPWR VPWR sky130_fd_sc_hd__diode_2
X_3082_ _0768_ _0769_ VGND VGND VPWR VPWR _0770_ sky130_fd_sc_hd__or2_1
X_2033_ _1286_ _1289_ VGND VGND VPWR VPWR _1295_ sky130_fd_sc_hd__or2_1
XTAP_TAPCELL_ROW_38_939 VGND VPWR sky130_fd_sc_hd__tapvpwrvgnd_1
XFILLER_47_281 VPWR VGND VPWR VGND sky130_ef_sc_hd__decap_12
XFILLER_62_251 VGND VGND VPWR VPWR sky130_fd_sc_hd__fill_1
XFILLER_63_785 VPWR VGND VPWR VGND sky130_ef_sc_hd__decap_12
XANTENNA__2525__S _0187_ VGND VGND VPWR VPWR sky130_fd_sc_hd__diode_2
XTAP_TAPCELL_ROW_102_1956 VGND VPWR sky130_fd_sc_hd__tapvpwrvgnd_1
XFILLER_50_435 VPWR VGND VPWR VGND sky130_ef_sc_hd__decap_12
XTAP_TAPCELL_ROW_44_1030 VGND VPWR sky130_fd_sc_hd__tapvpwrvgnd_1
XTAP_TAPCELL_ROW_44_1041 VGND VPWR sky130_fd_sc_hd__tapvpwrvgnd_1
XFILLER_148_301 VGND VGND VPWR VPWR sky130_fd_sc_hd__decap_6
XTAP_TAPCELL_ROW_102_1967 VGND VPWR sky130_fd_sc_hd__tapvpwrvgnd_1
X_2935_ u_crt.r1\[1\] _0555_ VGND VGND VPWR VPWR _0623_ sky130_fd_sc_hd__nand2_2
XFILLER_31_671 VGND VGND VPWR VPWR sky130_fd_sc_hd__fill_1
XFILLER_148_345 VPWR VGND VPWR VGND sky130_ef_sc_hd__decap_12
X_2866_ u_crt.r0\[1\] u_crt.r0\[0\] VGND VGND VPWR VPWR _0554_ sky130_fd_sc_hd__nand2b_4
XFILLER_148_389 VPWR VGND VPWR VGND sky130_ef_sc_hd__decap_12
XFILLER_117_721 VGND VGND VPWR VPWR sky130_fd_sc_hd__decap_6
XFILLER_108_209 VPWR VGND VPWR VGND sky130_ef_sc_hd__decap_12
X_1817_ _1082_ _1083_ _1089_ _1078_ VGND VGND VPWR VPWR _1090_ sky130_fd_sc_hd__a22o_1
XTAP_TAPCELL_ROW_135_2499 VGND VPWR sky130_fd_sc_hd__tapvpwrvgnd_1
XTAP_TAPCELL_ROW_135_2488 VGND VPWR sky130_fd_sc_hd__tapvpwrvgnd_1
X_2797_ _0536_ VGND VGND VPWR VPWR _0537_ sky130_fd_sc_hd__inv_2
XANTENNA__3275__CLK clknet_3_0__leaf_clk VGND VGND VPWR VPWR sky130_fd_sc_hd__diode_2
XFILLER_132_713 VPWR VGND VPWR VGND sky130_ef_sc_hd__decap_12
XFILLER_117_765 VPWR VGND VPWR VGND sky130_ef_sc_hd__decap_12
XFILLER_117_15 VPWR VGND VPWR VGND sky130_ef_sc_hd__decap_12
XFILLER_116_253 VPWR VGND VPWR VGND sky130_ef_sc_hd__decap_12
X_1748_ _1015_ _1016_ _1020_ VGND VGND VPWR VPWR _1021_ sky130_fd_sc_hd__a21oi_2
XFILLER_131_223 VGND VGND VPWR VPWR sky130_fd_sc_hd__fill_1
X_1679_ _0952_ _0954_ _0892_ VGND VGND VPWR VPWR _0955_ sky130_fd_sc_hd__a21oi_2
XFILLER_132_757 VPWR VGND VPWR VGND sky130_ef_sc_hd__decap_12
XFILLER_98_693 VGND VGND VPWR VPWR sky130_fd_sc_hd__decap_6
XFILLER_86_811 VGND VGND VPWR VPWR sky130_fd_sc_hd__fill_1
XANTENNA_input8_A A_in[1] VGND VGND VPWR VPWR sky130_fd_sc_hd__diode_2
XFILLER_58_513 VPWR VGND VPWR VGND sky130_ef_sc_hd__decap_12
XFILLER_100_643 VGND VGND VPWR VPWR sky130_fd_sc_hd__fill_1
XFILLER_85_321 VGND VGND VPWR VPWR sky130_fd_sc_hd__decap_8
XFILLER_58_557 VGND VGND VPWR VPWR sky130_fd_sc_hd__decap_6
XFILLER_133_69 VPWR VGND VPWR VGND sky130_ef_sc_hd__decap_12
XFILLER_73_505 VPWR VGND VPWR VGND sky130_ef_sc_hd__decap_12
XFILLER_39_760 VPWR VGND VPWR VGND sky130_ef_sc_hd__decap_12
XFILLER_26_421 VPWR VGND VPWR VGND sky130_ef_sc_hd__decap_12
XFILLER_13_137 VPWR VGND VPWR VGND sky130_ef_sc_hd__decap_12
XFILLER_10_811 VGND VGND VPWR VPWR sky130_fd_sc_hd__fill_1
XFILLER_21_181 VPWR VGND VPWR VGND sky130_ef_sc_hd__decap_12
XFILLER_22_693 VGND VGND VPWR VPWR sky130_fd_sc_hd__decap_6
XFILLER_42_77 VGND VGND VPWR VPWR sky130_fd_sc_hd__decap_6
XFILLER_127_529 VPWR VGND VPWR VGND sky130_ef_sc_hd__decap_12
XFILLER_6_837 VPWR VGND VPWR VGND sky130_ef_sc_hd__decap_12
XPHY_EDGE_ROW_125_Left_279 VGND VGND VPWR VPWR sky130_fd_sc_hd__decap_3
XFILLER_135_573 VPWR VGND VPWR VGND sky130_ef_sc_hd__decap_12
XTAP_TAPCELL_ROW_75_1535 VGND VPWR sky130_fd_sc_hd__tapvpwrvgnd_1
XTAP_TAPCELL_ROW_75_1524 VGND VPWR sky130_fd_sc_hd__tapvpwrvgnd_1
XFILLER_122_245 VGND VGND VPWR VPWR sky130_fd_sc_hd__decap_6
XFILLER_3_27 VPWR VGND VPWR VGND sky130_ef_sc_hd__decap_12
XFILLER_1_553 VGND VGND VPWR VPWR sky130_fd_sc_hd__decap_6
XFILLER_150_587 VGND VGND VPWR VPWR sky130_fd_sc_hd__fill_1
XFILLER_122_289 VPWR VGND VPWR VGND sky130_ef_sc_hd__decap_12
XFILLER_107_81 VPWR VGND VPWR VGND sky130_ef_sc_hd__decap_12
XFILLER_89_671 VGND VGND VPWR VPWR sky130_fd_sc_hd__fill_1
XFILLER_77_833 VGND VGND VPWR VPWR sky130_fd_sc_hd__decap_6
XFILLER_88_181 VPWR VGND VPWR VGND sky130_ef_sc_hd__decap_12
XFILLER_1_597 VPWR VGND VPWR VGND sky130_ef_sc_hd__decap_12
XPHY_EDGE_ROW_134_Left_288 VGND VGND VPWR VPWR sky130_fd_sc_hd__decap_3
XFILLER_92_825 VPWR VGND VPWR VGND sky130_ef_sc_hd__decap_12
XFILLER_77_877 VPWR VGND VPWR VGND sky130_ef_sc_hd__decap_12
XFILLER_76_365 VPWR VGND VPWR VGND sky130_ef_sc_hd__decap_12
XTAP_TAPCELL_ROW_106_2034 VGND VPWR sky130_fd_sc_hd__tapvpwrvgnd_1
XTAP_TAPCELL_ROW_106_2023 VGND VPWR sky130_fd_sc_hd__tapvpwrvgnd_1
XFILLER_92_869 VPWR VGND VPWR VGND sky130_ef_sc_hd__decap_12
XFILLER_91_335 VGND VGND VPWR VPWR sky130_fd_sc_hd__fill_1
XANTENNA__2618__A1 _0187_ VGND VGND VPWR VPWR sky130_fd_sc_hd__diode_2
XTAP_TAPCELL_ROW_4_391 VGND VPWR sky130_fd_sc_hd__tapvpwrvgnd_1
XFILLER_29_281 VPWR VGND VPWR VGND sky130_ef_sc_hd__decap_12
XFILLER_45_741 VPWR VGND VPWR VGND sky130_ef_sc_hd__decap_12
XFILLER_32_413 VGND VGND VPWR VPWR sky130_fd_sc_hd__decap_6
XFILLER_44_251 VGND VGND VPWR VPWR sky130_fd_sc_hd__fill_1
XFILLER_45_785 VPWR VGND VPWR VGND sky130_ef_sc_hd__decap_12
XFILLER_60_755 VGND VGND VPWR VPWR sky130_fd_sc_hd__fill_1
XFILLER_32_457 VPWR VGND VPWR VGND sky130_ef_sc_hd__decap_12
XANTENNA__1841__A2 _0911_ VGND VGND VPWR VPWR sky130_fd_sc_hd__diode_2
XFILLER_13_671 VGND VGND VPWR VPWR sky130_fd_sc_hd__fill_1
XFILLER_146_805 VGND VGND VPWR VPWR sky130_fd_sc_hd__decap_6
X_2720_ _0188_ _0450_ _0451_ _0459_ VGND VGND VPWR VPWR _0460_ sky130_fd_sc_hd__o31a_1
XANTENNA__3298__CLK clknet_3_2__leaf_clk VGND VGND VPWR VPWR sky130_fd_sc_hd__diode_2
XFILLER_9_653 VPWR VGND VPWR VGND sky130_ef_sc_hd__decap_12
XFILLER_146_849 VPWR VGND VPWR VGND sky130_ef_sc_hd__decap_12
XPHY_EDGE_ROW_143_Left_297 VGND VGND VPWR VPWR sky130_fd_sc_hd__decap_3
X_2651_ _0387_ _0389_ _0388_ VGND VGND VPWR VPWR _0391_ sky130_fd_sc_hd__a21o_1
XFILLER_8_141 VPWR VGND VPWR VGND sky130_ef_sc_hd__decap_12
XFILLER_145_337 VPWR VGND VPWR VGND sky130_ef_sc_hd__decap_12
XANTENNA__3176__S CRT_Start VGND VGND VPWR VPWR sky130_fd_sc_hd__diode_2
XFILLER_9_697 VPWR VGND VPWR VGND sky130_ef_sc_hd__decap_12
XTAP_TAPCELL_ROW_117_2196 VGND VPWR sky130_fd_sc_hd__tapvpwrvgnd_1
XFILLER_114_713 VPWR VGND VPWR VGND sky130_ef_sc_hd__decap_12
X_2582_ a_r2\[0\] a_r2\[1\] VGND VGND VPWR VPWR _0327_ sky130_fd_sc_hd__or2_1
XANTENNA__2554__B1 _0184_ VGND VGND VPWR VPWR sky130_fd_sc_hd__diode_2
XFILLER_113_223 VGND VGND VPWR VPWR sky130_fd_sc_hd__fill_1
XFILLER_114_757 VPWR VGND VPWR VGND sky130_ef_sc_hd__decap_12
XFILLER_68_811 VGND VGND VPWR VPWR sky130_fd_sc_hd__fill_1
X_3203_ _0854_ _0881_ _0879_ VGND VGND VPWR VPWR _0098_ sky130_fd_sc_hd__mux2_1
XFILLER_95_641 VPWR VGND VPWR VGND sky130_ef_sc_hd__decap_12
XANTENNA__2857__A1 B_reg\[7\] VGND VGND VPWR VPWR sky130_fd_sc_hd__diode_2
XFILLER_79_181 VPWR VGND VPWR VGND sky130_ef_sc_hd__decap_12
XFILLER_95_685 VPWR VGND VPWR VGND sky130_ef_sc_hd__decap_12
XFILLER_55_505 VGND VGND VPWR VPWR sky130_fd_sc_hd__decap_6
X_3134_ _0815_ _0817_ _0821_ VGND VGND VPWR VPWR _0822_ sky130_fd_sc_hd__o21ai_2
XFILLER_103_39 VPWR VGND VPWR VGND sky130_ef_sc_hd__decap_12
X_3065_ _0559_ _0752_ VGND VGND VPWR VPWR _0753_ sky130_fd_sc_hd__nand2_1
X_2016_ _1276_ _1277_ VGND VGND VPWR VPWR _1278_ sky130_fd_sc_hd__nand2_1
XFILLER_35_240 VPWR VGND VPWR VGND sky130_ef_sc_hd__decap_12
XTAP_TAPCELL_ROW_137_2517 VGND VPWR sky130_fd_sc_hd__tapvpwrvgnd_1
XFILLER_51_777 VGND VGND VPWR VPWR sky130_fd_sc_hd__decap_6
XFILLER_50_265 VPWR VGND VPWR VGND sky130_ef_sc_hd__decap_12
XFILLER_149_665 VGND VGND VPWR VPWR sky130_fd_sc_hd__decap_6
XTAP_TAPCELL_ROW_137_2528 VGND VPWR sky130_fd_sc_hd__tapvpwrvgnd_1
X_2918_ u_crt.r2\[2\] u_crt.r2\[0\] VGND VGND VPWR VPWR _0606_ sky130_fd_sc_hd__or2_1
XFILLER_148_153 VPWR VGND VPWR VGND sky130_ef_sc_hd__decap_12
XTAP_TAPCELL_ROW_21_669 VGND VPWR sky130_fd_sc_hd__tapvpwrvgnd_1
XTAP_TAPCELL_ROW_150_2728 VGND VPWR sky130_fd_sc_hd__tapvpwrvgnd_1
XFILLER_148_197 VPWR VGND VPWR VGND sky130_ef_sc_hd__decap_12
X_2849_ net7 A_reg\[15\] _0383_ VGND VGND VPWR VPWR _0072_ sky130_fd_sc_hd__mux2_1
XTAP_TAPCELL_ROW_150_2739 VGND VPWR sky130_fd_sc_hd__tapvpwrvgnd_1
XFILLER_151_329 VGND VGND VPWR VPWR sky130_fd_sc_hd__decap_6
XFILLER_117_573 VPWR VGND VPWR VGND sky130_ef_sc_hd__decap_12
XFILLER_88_29 VPWR VGND VPWR VGND sky130_ef_sc_hd__decap_12
XTAP_TAPCELL_ROW_57_1243 VGND VPWR sky130_fd_sc_hd__tapvpwrvgnd_1
XFILLER_104_245 VGND VGND VPWR VPWR sky130_fd_sc_hd__decap_6
XFILLER_132_587 VGND VGND VPWR VPWR sky130_fd_sc_hd__fill_1
XFILLER_104_289 VPWR VGND VPWR VGND sky130_ef_sc_hd__decap_12
XFILLER_120_749 VGND VGND VPWR VPWR sky130_fd_sc_hd__decap_6
XFILLER_86_641 VGND VGND VPWR VPWR sky130_fd_sc_hd__decap_3
XTAP_TAPCELL_ROW_70_1454 VGND VPWR sky130_fd_sc_hd__tapvpwrvgnd_1
XFILLER_58_321 VGND VGND VPWR VPWR sky130_fd_sc_hd__fill_1
XFILLER_85_151 VPWR VGND VPWR VGND sky130_ef_sc_hd__decap_12
XFILLER_74_825 VPWR VGND VPWR VGND sky130_ef_sc_hd__decap_12
XFILLER_59_877 VGND VGND VPWR VPWR sky130_fd_sc_hd__fill_1
XFILLER_58_365 VPWR VGND VPWR VGND sky130_ef_sc_hd__decap_12
XFILLER_46_516 VGND VGND VPWR VPWR sky130_fd_sc_hd__decap_3
XFILLER_100_495 VPWR VGND VPWR VGND sky130_ef_sc_hd__decap_12
XFILLER_85_173 VGND VGND VPWR VPWR sky130_fd_sc_hd__fill_1
XFILLER_73_335 VGND VGND VPWR VPWR sky130_fd_sc_hd__fill_1
XFILLER_37_55 VGND VGND VPWR VPWR sky130_fd_sc_hd__fill_1
XFILLER_74_869 VPWR VGND VPWR VGND sky130_ef_sc_hd__decap_12
XTAP_TAPCELL_ROW_1_350 VGND VPWR sky130_fd_sc_hd__tapvpwrvgnd_1
XFILLER_27_741 VPWR VGND VPWR VGND sky130_ef_sc_hd__decap_12
XFILLER_26_251 VGND VGND VPWR VPWR sky130_fd_sc_hd__fill_1
XFILLER_27_785 VPWR VGND VPWR VGND sky130_ef_sc_hd__decap_12
XFILLER_128_805 VGND VGND VPWR VPWR sky130_fd_sc_hd__decap_6
XFILLER_41_287 VGND VGND VPWR VPWR sky130_fd_sc_hd__fill_1
XTAP_TAPCELL_ROW_40_967 VGND VPWR sky130_fd_sc_hd__tapvpwrvgnd_1
XTAP_TAPCELL_ROW_40_978 VGND VPWR sky130_fd_sc_hd__tapvpwrvgnd_1
XFILLER_128_849 VPWR VGND VPWR VGND sky130_ef_sc_hd__decap_12
XFILLER_127_337 VPWR VGND VPWR VGND sky130_ef_sc_hd__decap_12
XFILLER_5_111 VGND VGND VPWR VPWR sky130_fd_sc_hd__fill_1
XFILLER_142_307 VGND VGND VPWR VPWR sky130_fd_sc_hd__fill_1
XFILLER_6_678 VPWR VGND VPWR VGND sky130_ef_sc_hd__decap_12
XFILLER_136_893 VPWR VGND VPWR VGND sky130_ef_sc_hd__decap_12
XANTENNA__3293__Q B_reg\[3\] VGND VGND VPWR VPWR sky130_fd_sc_hd__diode_2
XFILLER_151_841 VPWR VGND VPWR VGND sky130_ef_sc_hd__decap_12
XFILLER_111_727 VGND VGND VPWR VPWR sky130_fd_sc_hd__fill_1
XFILLER_68_118 VPWR VGND VPWR VGND sky130_ef_sc_hd__decap_12
XTAP_TAPCELL_ROW_9_483 VGND VPWR sky130_fd_sc_hd__tapvpwrvgnd_1
XTAP_TAPCELL_ROW_9_472 VGND VPWR sky130_fd_sc_hd__tapvpwrvgnd_1
XFILLER_1_361 VPWR VGND VPWR VGND sky130_ef_sc_hd__decap_12
XFILLER_77_641 VGND VGND VPWR VPWR sky130_fd_sc_hd__decap_3
XFILLER_49_365 VPWR VGND VPWR VGND sky130_ef_sc_hd__decap_12
XFILLER_37_505 VPWR VGND VPWR VGND sky130_ef_sc_hd__decap_12
XTAP_TAPCELL_ROW_88_1737 VGND VPWR sky130_fd_sc_hd__tapvpwrvgnd_1
XFILLER_91_132 VPWR VGND VPWR VGND sky130_ef_sc_hd__decap_12
XFILLER_76_195 VGND VGND VPWR VPWR sky130_fd_sc_hd__fill_1
XFILLER_92_699 VGND VGND VPWR VPWR sky130_fd_sc_hd__fill_1
XFILLER_91_187 VPWR VGND VPWR VGND sky130_ef_sc_hd__decap_12
XTAP_TAPCELL_ROW_28_780 VGND VPWR sky130_fd_sc_hd__tapvpwrvgnd_1
XPHY_EDGE_ROW_151_Left_305 VGND VGND VPWR VPWR sky130_fd_sc_hd__decap_3
XTAP_TAPCELL_ROW_119_2236 VGND VPWR sky130_fd_sc_hd__tapvpwrvgnd_1
XFILLER_32_298 VGND VGND VPWR VPWR sky130_fd_sc_hd__decap_8
XFILLER_146_613 VPWR VGND VPWR VGND sky130_ef_sc_hd__decap_12
XFILLER_146_657 VPWR VGND VPWR VGND sky130_ef_sc_hd__decap_12
X_2703_ _0428_ _0442_ VGND VGND VPWR VPWR _0443_ sky130_fd_sc_hd__nand2_1
XFILLER_9_472 VPWR VGND VPWR VGND sky130_ef_sc_hd__decap_12
XFILLER_145_167 VGND VGND VPWR VPWR sky130_fd_sc_hd__fill_1
XTAP_TAPCELL_ROW_132_2447 VGND VPWR sky130_fd_sc_hd__tapvpwrvgnd_1
XTAP_TAPCELL_ROW_132_2436 VGND VPWR sky130_fd_sc_hd__tapvpwrvgnd_1
X_2634_ _0184_ _0377_ _0378_ _0910_ u_crt.r2\[0\] VGND VGND VPWR VPWR _0032_ sky130_fd_sc_hd__a32o_1
XFILLER_133_329 VGND VGND VPWR VPWR sky130_fd_sc_hd__decap_6
X_2565_ b_r2\[0\] a_r2\[2\] _0306_ VGND VGND VPWR VPWR _0310_ sky130_fd_sc_hd__a21o_1
XFILLER_99_232 VGND VGND VPWR VPWR sky130_fd_sc_hd__decap_4
XFILLER_141_373 VPWR VGND VPWR VGND sky130_ef_sc_hd__decap_12
XFILLER_114_587 VGND VGND VPWR VPWR sky130_fd_sc_hd__fill_1
XFILLER_87_405 VPWR VGND VPWR VGND sky130_ef_sc_hd__decap_12
X_2496_ _0240_ _0242_ _0243_ VGND VGND VPWR VPWR _0244_ sky130_fd_sc_hd__a21oi_1
XANTENNA__3241__RESET_B net36 VGND VGND VPWR VPWR sky130_fd_sc_hd__diode_2
XANTENNA__3313__CLK clknet_3_7__leaf_clk VGND VGND VPWR VPWR sky130_fd_sc_hd__diode_2
XFILLER_102_749 VGND VGND VPWR VPWR sky130_fd_sc_hd__decap_6
XFILLER_101_237 VPWR VGND VPWR VGND sky130_ef_sc_hd__decap_12
XFILLER_87_449 VPWR VGND VPWR VGND sky130_ef_sc_hd__decap_12
XFILLER_87_438 VGND VGND VPWR VPWR sky130_fd_sc_hd__decap_8
XANTENNA_clkbuf_3_3__f_clk_X clknet_3_3__leaf_clk VGND VGND VPWR VPWR sky130_fd_sc_hd__diode_2
XFILLER_114_27 VGND VGND VPWR VPWR sky130_fd_sc_hd__fill_1
XTAP_TAPCELL_ROW_52_1162 VGND VPWR sky130_fd_sc_hd__tapvpwrvgnd_1
XTAP_TAPCELL_ROW_147_2690 VGND VPWR sky130_fd_sc_hd__tapvpwrvgnd_1
XFILLER_110_793 VPWR VGND VPWR VGND sky130_ef_sc_hd__decap_12
XFILLER_56_847 VPWR VGND VPWR VGND sky130_ef_sc_hd__decap_12
X_3117_ _0803_ _0804_ VGND VGND VPWR VPWR _0805_ sky130_fd_sc_hd__or2_1
XFILLER_56_869 VPWR VGND VPWR VGND sky130_ef_sc_hd__decap_12
XFILLER_130_15 VPWR VGND VPWR VGND sky130_ef_sc_hd__decap_12
XFILLER_82_165 VGND VGND VPWR VPWR sky130_fd_sc_hd__decap_4
XFILLER_71_839 VGND VGND VPWR VPWR sky130_fd_sc_hd__fill_1
X_3048_ _0733_ _0734_ VGND VGND VPWR VPWR _0736_ sky130_fd_sc_hd__xnor2_1
XFILLER_51_541 VPWR VGND VPWR VGND sky130_ef_sc_hd__decap_12
XFILLER_24_755 VGND VGND VPWR VPWR sky130_fd_sc_hd__fill_1
XFILLER_51_585 VPWR VGND VPWR VGND sky130_ef_sc_hd__decap_12
XFILLER_23_276 VGND VGND VPWR VPWR sky130_fd_sc_hd__decap_4
XFILLER_23_298 VPWR VGND VPWR VGND sky130_ef_sc_hd__decap_12
XFILLER_149_473 VPWR VGND VPWR VGND sky130_ef_sc_hd__decap_12
XFILLER_23_57 VPWR VGND VPWR VGND sky130_ef_sc_hd__decap_12
XFILLER_139_57 VPWR VGND VPWR VGND sky130_ef_sc_hd__decap_12
XFILLER_109_337 VPWR VGND VPWR VGND sky130_ef_sc_hd__decap_12
XFILLER_124_307 VGND VGND VPWR VPWR sky130_fd_sc_hd__fill_1
XFILLER_99_39 VPWR VGND VPWR VGND sky130_ef_sc_hd__decap_12
XFILLER_136_189 VGND VGND VPWR VPWR sky130_fd_sc_hd__decap_6
XFILLER_118_893 VPWR VGND VPWR VGND sky130_ef_sc_hd__decap_12
XFILLER_151_137 VPWR VGND VPWR VGND sky130_ef_sc_hd__decap_12
XFILLER_133_841 VPWR VGND VPWR VGND sky130_ef_sc_hd__decap_12
XFILLER_120_513 VPWR VGND VPWR VGND sky130_ef_sc_hd__decap_12
XTAP_TAPCELL_ROW_6_420 VGND VPWR sky130_fd_sc_hd__tapvpwrvgnd_1
XFILLER_94_909 VGND VGND VPWR VPWR sky130_fd_sc_hd__fill_1
XTAP_TAPCELL_ROW_6_431 VGND VPWR sky130_fd_sc_hd__tapvpwrvgnd_1
XFILLER_120_557 VPWR VGND VPWR VGND sky130_ef_sc_hd__decap_12
XFILLER_19_505 VPWR VGND VPWR VGND sky130_ef_sc_hd__decap_12
XFILLER_59_685 VGND VGND VPWR VPWR sky130_fd_sc_hd__decap_6
XFILLER_58_195 VGND VGND VPWR VPWR sky130_fd_sc_hd__fill_1
XFILLER_46_357 VGND VGND VPWR VPWR sky130_fd_sc_hd__decap_6
XFILLER_74_699 VGND VGND VPWR VPWR sky130_fd_sc_hd__fill_1
XFILLER_73_165 VGND VGND VPWR VPWR sky130_fd_sc_hd__decap_3
XFILLER_64_53 VPWR VGND VPWR VGND sky130_ef_sc_hd__decap_12
XTAP_TAPCELL_ROW_83_1656 VGND VPWR sky130_fd_sc_hd__tapvpwrvgnd_1
XFILLER_64_97 VPWR VGND VPWR VGND sky130_ef_sc_hd__decap_12
XFILLER_61_349 VPWR VGND VPWR VGND sky130_ef_sc_hd__decap_12
XFILLER_14_221 VPWR VGND VPWR VGND sky130_ef_sc_hd__decap_12
XTAP_TAPCELL_ROW_83_1667 VGND VPWR sky130_fd_sc_hd__tapvpwrvgnd_1
XFILLER_70_861 VGND VGND VPWR VPWR sky130_fd_sc_hd__decap_6
XFILLER_9_15 VPWR VGND VPWR VGND sky130_ef_sc_hd__decap_12
XFILLER_15_777 VGND VGND VPWR VPWR sky130_fd_sc_hd__decap_6
XFILLER_80_41 VPWR VGND VPWR VGND sky130_ef_sc_hd__decap_12
XFILLER_14_287 VPWR VGND VPWR VGND sky130_ef_sc_hd__decap_12
XFILLER_30_725 VPWR VGND VPWR VGND sky130_ef_sc_hd__decap_12
XFILLER_128_613 VPWR VGND VPWR VGND sky130_ef_sc_hd__decap_12
XFILLER_80_74 VGND VGND VPWR VPWR sky130_fd_sc_hd__fill_1
XFILLER_30_769 VPWR VGND VPWR VGND sky130_ef_sc_hd__decap_12
XFILLER_80_85 VGND VGND VPWR VPWR sky130_fd_sc_hd__fill_2
XFILLER_128_657 VPWR VGND VPWR VGND sky130_ef_sc_hd__decap_12
XFILLER_127_167 VGND VGND VPWR VPWR sky130_fd_sc_hd__fill_1
XFILLER_115_329 VGND VGND VPWR VPWR sky130_fd_sc_hd__decap_6
XTAP_TAPCELL_ROW_114_2155 VGND VPWR sky130_fd_sc_hd__tapvpwrvgnd_1
XANTENNA__1980__A1 B_reg\[1\] VGND VGND VPWR VPWR sky130_fd_sc_hd__diode_2
XFILLER_6_475 VGND VGND VPWR VPWR sky130_fd_sc_hd__fill_1
XFILLER_151_671 VGND VGND VPWR VPWR sky130_fd_sc_hd__fill_1
XFILLER_123_373 VPWR VGND VPWR VGND sky130_ef_sc_hd__decap_12
X_2350_ _0903_ _1595_ _1600_ VGND VGND VPWR VPWR _1603_ sky130_fd_sc_hd__and3_1
XFILLER_69_405 VGND VGND VPWR VPWR sky130_fd_sc_hd__decap_8
XFILLER_85_909 VGND VGND VPWR VPWR sky130_fd_sc_hd__fill_1
XFILLER_69_449 VPWR VGND VPWR VGND sky130_ef_sc_hd__decap_12
X_2281_ _1523_ _1529_ _1521_ VGND VGND VPWR VPWR _1538_ sky130_fd_sc_hd__mux2_1
XFILLER_2_681 VPWR VGND VPWR VGND sky130_ef_sc_hd__decap_12
XFILLER_84_419 VGND VGND VPWR VPWR sky130_fd_sc_hd__fill_1
XFILLER_38_825 VPWR VGND VPWR VGND sky130_ef_sc_hd__decap_12
XFILLER_64_121 VGND VGND VPWR VPWR sky130_fd_sc_hd__decap_8
XFILLER_53_839 VGND VGND VPWR VPWR sky130_fd_sc_hd__fill_1
XFILLER_37_379 VPWR VGND VPWR VGND sky130_ef_sc_hd__decap_12
XFILLER_80_669 VPWR VGND VPWR VGND sky130_ef_sc_hd__decap_12
XFILLER_46_891 VPWR VGND VPWR VGND sky130_ef_sc_hd__decap_12
XFILLER_61_872 VGND VGND VPWR VPWR sky130_fd_sc_hd__decap_8
XFILLER_100_29 VPWR VGND VPWR VGND sky130_ef_sc_hd__decap_12
XFILLER_61_894 VGND VGND VPWR VPWR sky130_fd_sc_hd__fill_2
X_1996_ _1176_ _1257_ B_reg\[12\] VGND VGND VPWR VPWR _1258_ sky130_fd_sc_hd__a21oi_1
XFILLER_146_421 VPWR VGND VPWR VGND sky130_ef_sc_hd__decap_12
XFILLER_109_27 VPWR VGND VPWR VGND sky130_ef_sc_hd__decap_12
XFILLER_118_189 VGND VGND VPWR VPWR sky130_fd_sc_hd__decap_6
XFILLER_106_307 VGND VGND VPWR VPWR sky130_fd_sc_hd__fill_1
XFILLER_133_137 VPWR VGND VPWR VGND sky130_ef_sc_hd__decap_12
XFILLER_115_841 VPWR VGND VPWR VGND sky130_ef_sc_hd__decap_12
X_2617_ _0187_ _0361_ VGND VGND VPWR VPWR _0362_ sky130_fd_sc_hd__nand2_1
XTAP_TAPCELL_ROW_54_1202 VGND VPWR sky130_fd_sc_hd__tapvpwrvgnd_1
XFILLER_130_811 VGND VGND VPWR VPWR sky130_fd_sc_hd__fill_1
XFILLER_125_15 VPWR VGND VPWR VGND sky130_ef_sc_hd__decap_12
XFILLER_88_725 VPWR VGND VPWR VGND sky130_ef_sc_hd__decap_12
X_2548_ _0294_ _0295_ VGND VGND VPWR VPWR _0296_ sky130_fd_sc_hd__nand2_1
XFILLER_0_629 VGND VGND VPWR VPWR sky130_fd_sc_hd__decap_4
XFILLER_142_693 VGND VGND VPWR VPWR sky130_fd_sc_hd__decap_6
XFILLER_141_181 VPWR VGND VPWR VGND sky130_ef_sc_hd__decap_12
XFILLER_88_769 VPWR VGND VPWR VGND sky130_ef_sc_hd__decap_12
XFILLER_76_909 VGND VGND VPWR VPWR sky130_fd_sc_hd__fill_1
XFILLER_102_568 VPWR VGND VPWR VGND sky130_ef_sc_hd__decap_12
XFILLER_102_557 VGND VGND VPWR VPWR sky130_fd_sc_hd__fill_1
XFILLER_87_279 VGND VGND VPWR VPWR sky130_fd_sc_hd__fill_1
X_2479_ a_r1\[0\] a_r1\[1\] VGND VGND VPWR VPWR _0227_ sky130_fd_sc_hd__xor2_1
XTAP_TAPCELL_ROW_145_2649 VGND VPWR sky130_fd_sc_hd__tapvpwrvgnd_1
XFILLER_28_313 VGND VGND VPWR VPWR sky130_fd_sc_hd__fill_1
XFILLER_83_441 VGND VGND VPWR VPWR sky130_fd_sc_hd__decap_6
XFILLER_55_110 VGND VGND VPWR VPWR sky130_fd_sc_hd__fill_2
XFILLER_28_335 VPWR VGND VPWR VGND sky130_ef_sc_hd__decap_12
XFILLER_141_69 VPWR VGND VPWR VGND sky130_ef_sc_hd__decap_12
XFILLER_56_699 VGND VGND VPWR VPWR sky130_fd_sc_hd__fill_1
XFILLER_43_316 VGND VGND VPWR VPWR sky130_fd_sc_hd__decap_8
XFILLER_71_669 VGND VGND VPWR VPWR sky130_fd_sc_hd__decap_3
XTAP_TAPCELL_ROW_65_1364 VGND VPWR sky130_fd_sc_hd__tapvpwrvgnd_1
XTAP_TAPCELL_ROW_65_1375 VGND VPWR sky130_fd_sc_hd__tapvpwrvgnd_1
XFILLER_12_725 VPWR VGND VPWR VGND sky130_ef_sc_hd__decap_12
XFILLER_51_393 VGND VGND VPWR VPWR sky130_fd_sc_hd__decap_6
XFILLER_12_769 VPWR VGND VPWR VGND sky130_ef_sc_hd__decap_12
XFILLER_149_281 VPWR VGND VPWR VGND sky130_ef_sc_hd__decap_12
XFILLER_126_3 VPWR VGND VPWR VGND sky130_ef_sc_hd__decap_12
Xclkload0 clknet_3_0__leaf_clk VGND VGND VPWR VPWR clkload0/Y sky130_fd_sc_hd__inv_8
XFILLER_7_217 VGND VGND VPWR VPWR sky130_fd_sc_hd__decap_6
XFILLER_152_413 VGND VGND VPWR VPWR sky130_fd_sc_hd__decap_6
XFILLER_109_167 VGND VGND VPWR VPWR sky130_fd_sc_hd__fill_1
XFILLER_152_457 VPWR VGND VPWR VGND sky130_ef_sc_hd__decap_12
XFILLER_3_423 VGND VGND VPWR VPWR sky130_fd_sc_hd__fill_2
XFILLER_133_671 VGND VGND VPWR VPWR sky130_fd_sc_hd__fill_1
XFILLER_121_833 VGND VGND VPWR VPWR sky130_fd_sc_hd__decap_6
XFILLER_120_321 VPWR VGND VPWR VGND sky130_ef_sc_hd__decap_12
XFILLER_105_373 VPWR VGND VPWR VGND sky130_ef_sc_hd__decap_12
XFILLER_79_758 VPWR VGND VPWR VGND sky130_ef_sc_hd__decap_12
XFILLER_67_909 VGND VGND VPWR VPWR sky130_fd_sc_hd__fill_1
XFILLER_121_877 VPWR VGND VPWR VGND sky130_ef_sc_hd__decap_12
XFILLER_120_365 VPWR VGND VPWR VGND sky130_ef_sc_hd__decap_12
XFILLER_115_81 VPWR VGND VPWR VGND sky130_ef_sc_hd__decap_12
XFILLER_93_205 VPWR VGND VPWR VGND sky130_ef_sc_hd__decap_12
XFILLER_93_249 VPWR VGND VPWR VGND sky130_ef_sc_hd__decap_12
XFILLER_19_335 VGND VGND VPWR VPWR sky130_fd_sc_hd__fill_1
XFILLER_46_121 VPWR VGND VPWR VGND sky130_ef_sc_hd__decap_12
XFILLER_35_817 VGND VGND VPWR VPWR sky130_fd_sc_hd__fill_1
XFILLER_46_165 VPWR VGND VPWR VGND sky130_ef_sc_hd__decap_12
XFILLER_61_113 VGND VGND VPWR VPWR sky130_fd_sc_hd__fill_2
XFILLER_50_809 VGND VGND VPWR VPWR sky130_fd_sc_hd__decap_3
XFILLER_15_541 VPWR VGND VPWR VGND sky130_ef_sc_hd__decap_12
XFILLER_27_390 VGND VGND VPWR VPWR sky130_fd_sc_hd__fill_2
XFILLER_15_585 VPWR VGND VPWR VGND sky130_ef_sc_hd__decap_12
X_1850_ _1113_ _1116_ A_reg\[11\] VGND VGND VPWR VPWR _1120_ sky130_fd_sc_hd__a21oi_1
XFILLER_128_421 VPWR VGND VPWR VGND sky130_ef_sc_hd__decap_12
X_1781_ _1047_ _1053_ A_reg\[7\] VGND VGND VPWR VPWR _1054_ sky130_fd_sc_hd__a21oi_1
XTAP_TAPCELL_ROW_96_1869 VGND VPWR sky130_fd_sc_hd__tapvpwrvgnd_1
XFILLER_115_137 VPWR VGND VPWR VGND sky130_ef_sc_hd__decap_12
XFILLER_112_811 VGND VGND VPWR VPWR sky130_fd_sc_hd__fill_1
X_2402_ _0151_ _0153_ _0146_ VGND VGND VPWR VPWR _0156_ sky130_fd_sc_hd__a21bo_1
XFILLER_41_3 VPWR VGND VPWR VGND sky130_ef_sc_hd__decap_12
XFILLER_124_693 VGND VGND VPWR VPWR sky130_fd_sc_hd__decap_6
XFILLER_123_181 VPWR VGND VPWR VGND sky130_ef_sc_hd__decap_12
X_2333_ _1575_ _1585_ VGND VGND VPWR VPWR _1586_ sky130_fd_sc_hd__xnor2_1
XFILLER_58_909 VGND VGND VPWR VPWR sky130_fd_sc_hd__fill_1
XPHY_EDGE_ROW_127_Right_127 VGND VGND VPWR VPWR sky130_fd_sc_hd__decap_3
X_2264_ _1513_ _1516_ _1520_ VGND VGND VPWR VPWR _1521_ sky130_fd_sc_hd__a21oi_1
XTAP_TAPCELL_ROW_127_2368 VGND VPWR sky130_fd_sc_hd__tapvpwrvgnd_1
XTAP_TAPCELL_ROW_127_2357 VGND VPWR sky130_fd_sc_hd__tapvpwrvgnd_1
XFILLER_84_249 VGND VGND VPWR VPWR sky130_fd_sc_hd__fill_1
XFILLER_65_441 VGND VGND VPWR VPWR sky130_fd_sc_hd__decap_6
X_2195_ _1447_ _1450_ _1451_ _1437_ VGND VGND VPWR VPWR _1452_ sky130_fd_sc_hd__a22o_1
XFILLER_93_783 VGND VGND VPWR VPWR sky130_fd_sc_hd__fill_1
XFILLER_53_603 VPWR VGND VPWR VGND sky130_ef_sc_hd__decap_12
XFILLER_25_305 VPWR VGND VPWR VGND sky130_ef_sc_hd__decap_12
XFILLER_38_699 VGND VGND VPWR VPWR sky130_fd_sc_hd__fill_1
XFILLER_80_433 VGND VGND VPWR VPWR sky130_fd_sc_hd__decap_8
XFILLER_1_93 VPWR VGND VPWR VGND sky130_ef_sc_hd__decap_12
XFILLER_25_349 VPWR VGND VPWR VGND sky130_ef_sc_hd__decap_12
XTAP_TAPCELL_ROW_140_2579 VGND VPWR sky130_fd_sc_hd__tapvpwrvgnd_1
XTAP_TAPCELL_ROW_140_2568 VGND VPWR sky130_fd_sc_hd__tapvpwrvgnd_1
XFILLER_111_39 VPWR VGND VPWR VGND sky130_ef_sc_hd__decap_12
XFILLER_34_861 VGND VGND VPWR VPWR sky130_fd_sc_hd__decap_6
XTAP_TAPCELL_ROW_47_1083 VGND VPWR sky130_fd_sc_hd__tapvpwrvgnd_1
XTAP_TAPCELL_ROW_16_580 VGND VPWR sky130_fd_sc_hd__tapvpwrvgnd_1
XTAP_TAPCELL_ROW_16_591 VGND VPWR sky130_fd_sc_hd__tapvpwrvgnd_1
XFILLER_33_393 VPWR VGND VPWR VGND sky130_ef_sc_hd__decap_12
XFILLER_147_741 VPWR VGND VPWR VGND sky130_ef_sc_hd__decap_12
X_1979_ B_reg\[1\] _1243_ VGND VGND VPWR VPWR _1244_ sky130_fd_sc_hd__nand2_1
XTAP_TAPCELL_ROW_60_1294 VGND VPWR sky130_fd_sc_hd__tapvpwrvgnd_1
XFILLER_147_785 VPWR VGND VPWR VGND sky130_ef_sc_hd__decap_12
XFILLER_146_251 VGND VGND VPWR VPWR sky130_fd_sc_hd__fill_1
XFILLER_134_413 VGND VGND VPWR VPWR sky130_fd_sc_hd__decap_6
XFILLER_4_209 VPWR VGND VPWR VGND sky130_ef_sc_hd__decap_12
XFILLER_134_457 VPWR VGND VPWR VGND sky130_ef_sc_hd__decap_12
XFILLER_105_8 VPWR VGND VPWR VGND sky130_ef_sc_hd__decap_12
XFILLER_115_671 VGND VGND VPWR VPWR sky130_fd_sc_hd__fill_1
XFILLER_103_833 VGND VGND VPWR VPWR sky130_fd_sc_hd__decap_6
XFILLER_102_321 VPWR VGND VPWR VGND sky130_ef_sc_hd__decap_12
XFILLER_96_29 VPWR VGND VPWR VGND sky130_ef_sc_hd__decap_12
XFILLER_88_533 VPWR VGND VPWR VGND sky130_ef_sc_hd__decap_12
XFILLER_103_877 VPWR VGND VPWR VGND sky130_ef_sc_hd__decap_12
XFILLER_102_365 VPWR VGND VPWR VGND sky130_ef_sc_hd__decap_12
XFILLER_75_205 VPWR VGND VPWR VGND sky130_ef_sc_hd__decap_12
XFILLER_91_709 VPWR VGND VPWR VGND sky130_ef_sc_hd__decap_12
XFILLER_75_249 VPWR VGND VPWR VGND sky130_ef_sc_hd__decap_12
XFILLER_28_121 VPWR VGND VPWR VGND sky130_ef_sc_hd__decap_12
XTAP_TAPCELL_ROW_67_1404 VGND VPWR sky130_fd_sc_hd__tapvpwrvgnd_1
XFILLER_17_839 VGND VGND VPWR VPWR sky130_fd_sc_hd__fill_1
XFILLER_28_165 VPWR VGND VPWR VGND sky130_ef_sc_hd__decap_12
XFILLER_83_293 VPWR VGND VPWR VGND sky130_ef_sc_hd__decap_12
XFILLER_43_113 VPWR VGND VPWR VGND sky130_ef_sc_hd__decap_12
XFILLER_45_55 VGND VGND VPWR VPWR sky130_fd_sc_hd__fill_1
XFILLER_44_669 VGND VGND VPWR VPWR sky130_fd_sc_hd__fill_1
XTAP_TAPCELL_ROW_80_1615 VGND VPWR sky130_fd_sc_hd__tapvpwrvgnd_1
XTAP_TAPCELL_ROW_80_1604 VGND VPWR sky130_fd_sc_hd__tapvpwrvgnd_1
XFILLER_61_43 VPWR VGND VPWR VGND sky130_ef_sc_hd__decap_12
XFILLER_12_533 VPWR VGND VPWR VGND sky130_ef_sc_hd__decap_12
XFILLER_40_831 VGND VGND VPWR VPWR sky130_fd_sc_hd__fill_1
XFILLER_137_273 VGND VGND VPWR VPWR sky130_fd_sc_hd__decap_6
XFILLER_6_27 VGND VGND VPWR VPWR sky130_fd_sc_hd__fill_1
XFILLER_152_221 VPWR VGND VPWR VGND sky130_ef_sc_hd__decap_12
XTAP_TAPCELL_ROW_111_2114 VGND VPWR sky130_fd_sc_hd__tapvpwrvgnd_1
XTAP_TAPCELL_ROW_111_2103 VGND VPWR sky130_fd_sc_hd__tapvpwrvgnd_1
XFILLER_99_809 VPWR VGND VPWR VGND sky130_ef_sc_hd__decap_12
XTAP_TAPCELL_ROW_78_1577 VGND VPWR sky130_fd_sc_hd__tapvpwrvgnd_1
XFILLER_152_265 VPWR VGND VPWR VGND sky130_ef_sc_hd__decap_12
XFILLER_106_693 VGND VGND VPWR VPWR sky130_fd_sc_hd__decap_6
XFILLER_121_641 VPWR VGND VPWR VGND sky130_ef_sc_hd__decap_12
XFILLER_105_181 VPWR VGND VPWR VGND sky130_ef_sc_hd__decap_12
XTAP_TAPCELL_ROW_91_1788 VGND VPWR sky130_fd_sc_hd__tapvpwrvgnd_1
XFILLER_121_685 VPWR VGND VPWR VGND sky130_ef_sc_hd__decap_12
XFILLER_94_525 VGND VGND VPWR VPWR sky130_fd_sc_hd__decap_6
XFILLER_79_588 VGND VGND VPWR VPWR sky130_fd_sc_hd__decap_3
XFILLER_66_227 VPWR VGND VPWR VGND sky130_ef_sc_hd__decap_12
XFILLER_120_195 VGND VGND VPWR VPWR sky130_fd_sc_hd__fill_1
XFILLER_82_709 VGND VGND VPWR VPWR sky130_fd_sc_hd__fill_2
XTAP_TAPCELL_ROW_109_2076 VGND VPWR sky130_fd_sc_hd__tapvpwrvgnd_1
XFILLER_62_433 VGND VGND VPWR VPWR sky130_fd_sc_hd__decap_8
XFILLER_62_411 VGND VGND VPWR VPWR sky130_fd_sc_hd__decap_8
XTAP_TAPCELL_ROW_122_2276 VGND VPWR sky130_fd_sc_hd__tapvpwrvgnd_1
XANTENNA__2872__A _0554_ VGND VGND VPWR VPWR sky130_fd_sc_hd__diode_2
XFILLER_16_861 VGND VGND VPWR VPWR sky130_fd_sc_hd__decap_6
XFILLER_23_809 VPWR VGND VPWR VGND sky130_ef_sc_hd__decap_12
XTAP_TAPCELL_ROW_122_2287 VGND VPWR sky130_fd_sc_hd__tapvpwrvgnd_1
X_2951_ _0637_ _0638_ VGND VGND VPWR VPWR _0639_ sky130_fd_sc_hd__or2_1
XFILLER_50_617 VGND VGND VPWR VPWR sky130_fd_sc_hd__fill_1
X_1902_ B_reg\[15\] B_reg\[14\] VGND VGND VPWR VPWR _1167_ sky130_fd_sc_hd__nand2_1
XFILLER_15_393 VPWR VGND VPWR VGND sky130_ef_sc_hd__decap_12
XTAP_TAPCELL_ROW_33_859 VGND VPWR sky130_fd_sc_hd__tapvpwrvgnd_1
XFILLER_89_3 VPWR VGND VPWR VGND sky130_ef_sc_hd__decap_12
X_2882_ _0567_ _0568_ _0569_ VGND VGND VPWR VPWR _0570_ sky130_fd_sc_hd__or3_4
XANTENNA_clkbuf_0_clk_A clk VGND VGND VPWR VPWR sky130_fd_sc_hd__diode_2
XFILLER_30_363 VGND VGND VPWR VPWR sky130_fd_sc_hd__fill_1
XFILLER_31_875 VGND VGND VPWR VPWR sky130_fd_sc_hd__decap_8
XFILLER_31_897 VPWR VGND VPWR VGND sky130_ef_sc_hd__decap_12
XFILLER_129_741 VPWR VGND VPWR VGND sky130_ef_sc_hd__decap_12
X_1833_ _1093_ _1095_ _1104_ _1105_ VGND VGND VPWR VPWR _1106_ sky130_fd_sc_hd__a211oi_1
XFILLER_129_785 VPWR VGND VPWR VGND sky130_ef_sc_hd__decap_12
XFILLER_128_251 VGND VGND VPWR VPWR sky130_fd_sc_hd__fill_1
XFILLER_116_413 VGND VGND VPWR VPWR sky130_fd_sc_hd__decap_6
X_1764_ _0890_ _1028_ _1029_ _1034_ _1035_ VGND VGND VPWR VPWR _1037_ sky130_fd_sc_hd__a311o_1
XFILLER_144_755 VGND VGND VPWR VPWR sky130_fd_sc_hd__fill_1
XFILLER_131_405 VPWR VGND VPWR VGND sky130_ef_sc_hd__decap_12
XFILLER_116_457 VPWR VGND VPWR VGND sky130_ef_sc_hd__decap_12
X_1695_ _0957_ _0970_ VGND VGND VPWR VPWR _0971_ sky130_fd_sc_hd__xnor2_1
XFILLER_131_449 VPWR VGND VPWR VGND sky130_ef_sc_hd__decap_12
XFILLER_100_825 VPWR VGND VPWR VGND sky130_ef_sc_hd__decap_12
XFILLER_97_385 VGND VGND VPWR VPWR sky130_fd_sc_hd__decap_6
X_3296_ clknet_3_2__leaf_clk _0079_ net36 VGND VGND VPWR VPWR B_reg\[6\] sky130_fd_sc_hd__dfrtp_4
XFILLER_85_503 VGND VGND VPWR VPWR sky130_fd_sc_hd__fill_1
X_2316_ _1565_ _1568_ _1559_ VGND VGND VPWR VPWR _1569_ sky130_fd_sc_hd__o21ai_1
XPHY_EDGE_ROW_29_Left_183 VGND VGND VPWR VPWR sky130_fd_sc_hd__decap_3
XTAP_TAPCELL_ROW_142_2608 VGND VPWR sky130_fd_sc_hd__tapvpwrvgnd_1
XFILLER_100_869 VPWR VGND VPWR VGND sky130_ef_sc_hd__decap_12
XFILLER_57_249 VPWR VGND VPWR VGND sky130_ef_sc_hd__decap_12
X_2247_ A_reg\[3\] _1500_ _1501_ _1502_ VGND VGND VPWR VPWR _1504_ sky130_fd_sc_hd__a211o_1
XFILLER_122_27 VGND VGND VPWR VPWR sky130_fd_sc_hd__fill_1
XFILLER_65_293 VGND VGND VPWR VPWR sky130_fd_sc_hd__decap_8
XTAP_TAPCELL_ROW_49_1123 VGND VPWR sky130_fd_sc_hd__tapvpwrvgnd_1
XTAP_TAPCELL_ROW_49_1112 VGND VPWR sky130_fd_sc_hd__tapvpwrvgnd_1
X_2178_ _1433_ _1434_ VGND VGND VPWR VPWR _1435_ sky130_fd_sc_hd__or2_1
XFILLER_25_113 VPWR VGND VPWR VGND sky130_ef_sc_hd__decap_12
XFILLER_26_625 VPWR VGND VPWR VGND sky130_ef_sc_hd__decap_12
XFILLER_81_753 VPWR VGND VPWR VGND sky130_ef_sc_hd__decap_12
XANTENNA__1862__B1 A_reg\[7\] VGND VGND VPWR VPWR sky130_fd_sc_hd__diode_2
XFILLER_26_669 VPWR VGND VPWR VGND sky130_ef_sc_hd__decap_12
XFILLER_81_797 VPWR VGND VPWR VGND sky130_ef_sc_hd__decap_12
XFILLER_53_488 VPWR VGND VPWR VGND sky130_ef_sc_hd__decap_12
XFILLER_41_617 VPWR VGND VPWR VGND sky130_ef_sc_hd__decap_12
XFILLER_139_505 VPWR VGND VPWR VGND sky130_ef_sc_hd__decap_12
XTAP_TAPCELL_ROW_62_1323 VGND VPWR sky130_fd_sc_hd__tapvpwrvgnd_1
XFILLER_15_69 VPWR VGND VPWR VGND sky130_ef_sc_hd__decap_12
XTAP_TAPCELL_ROW_11_509 VGND VPWR sky130_fd_sc_hd__tapvpwrvgnd_1
XPHY_EDGE_ROW_38_Left_192 VGND VGND VPWR VPWR sky130_fd_sc_hd__decap_3
XFILLER_21_385 VGND VGND VPWR VPWR sky130_fd_sc_hd__decap_6
XFILLER_119_273 VGND VGND VPWR VPWR sky130_fd_sc_hd__decap_6
XFILLER_5_529 VPWR VGND VPWR VGND sky130_ef_sc_hd__decap_12
XFILLER_31_57 VPWR VGND VPWR VGND sky130_ef_sc_hd__decap_12
XFILLER_147_57 VPWR VGND VPWR VGND sky130_ef_sc_hd__decap_12
XFILLER_134_221 VPWR VGND VPWR VGND sky130_ef_sc_hd__decap_12
XFILLER_107_435 VPWR VGND VPWR VGND sky130_ef_sc_hd__decap_12
XFILLER_135_777 VGND VGND VPWR VPWR sky130_fd_sc_hd__decap_6
XFILLER_134_265 VPWR VGND VPWR VGND sky130_ef_sc_hd__decap_12
XFILLER_150_725 VPWR VGND VPWR VGND sky130_ef_sc_hd__decap_12
Xoutput46 net46 VGND VGND VPWR VPWR X_out[2] sky130_fd_sc_hd__buf_1
XFILLER_150_769 VPWR VGND VPWR VGND sky130_ef_sc_hd__decap_12
XFILLER_103_641 VPWR VGND VPWR VGND sky130_ef_sc_hd__decap_12
XFILLER_89_853 VPWR VGND VPWR VGND sky130_ef_sc_hd__decap_12
XANTENNA__2957__A _0628_ VGND VGND VPWR VPWR sky130_fd_sc_hd__diode_2
XFILLER_0_245 VGND VGND VPWR VPWR sky130_fd_sc_hd__fill_1
XFILLER_103_685 VPWR VGND VPWR VGND sky130_ef_sc_hd__decap_12
XFILLER_89_897 VPWR VGND VPWR VGND sky130_ef_sc_hd__decap_12
XFILLER_88_363 VGND VGND VPWR VPWR sky130_fd_sc_hd__fill_1
XFILLER_76_525 VGND VGND VPWR VPWR sky130_fd_sc_hd__decap_6
XTAP_TAPCELL_ROW_73_1496 VGND VPWR sky130_fd_sc_hd__tapvpwrvgnd_1
XFILLER_102_195 VGND VGND VPWR VPWR sky130_fd_sc_hd__fill_1
XFILLER_76_569 VPWR VGND VPWR VGND sky130_ef_sc_hd__decap_12
XFILLER_91_517 VGND VGND VPWR VPWR sky130_fd_sc_hd__decap_3
XFILLER_29_441 VGND VGND VPWR VPWR sky130_fd_sc_hd__decap_6
XFILLER_57_794 VPWR VGND VPWR VGND sky130_ef_sc_hd__decap_12
XFILLER_29_485 VPWR VGND VPWR VGND sky130_ef_sc_hd__decap_12
XFILLER_44_411 VGND VGND VPWR VPWR sky130_fd_sc_hd__decap_8
XPHY_EDGE_ROW_19_Right_19 VGND VGND VPWR VPWR sky130_fd_sc_hd__decap_3
XFILLER_44_433 VPWR VGND VPWR VGND sky130_ef_sc_hd__decap_12
XFILLER_72_42 VPWR VGND VPWR VGND sky130_ef_sc_hd__decap_12
XFILLER_31_105 VGND VGND VPWR VPWR sky130_fd_sc_hd__decap_6
XFILLER_44_477 VGND VGND VPWR VPWR sky130_fd_sc_hd__decap_3
XFILLER_13_853 VPWR VGND VPWR VGND sky130_ef_sc_hd__decap_12
XFILLER_31_149 VPWR VGND VPWR VGND sky130_ef_sc_hd__decap_12
XFILLER_8_301 VGND VGND VPWR VPWR sky130_fd_sc_hd__decap_6
XFILLER_12_341 VPWR VGND VPWR VGND sky130_ef_sc_hd__decap_12
XTAP_TAPCELL_ROW_30_807 VGND VPWR sky130_fd_sc_hd__tapvpwrvgnd_1
XTAP_TAPCELL_ROW_30_818 VGND VPWR sky130_fd_sc_hd__tapvpwrvgnd_1
XANTENNA__3296__Q B_reg\[6\] VGND VGND VPWR VPWR sky130_fd_sc_hd__diode_2
XFILLER_13_897 VPWR VGND VPWR VGND sky130_ef_sc_hd__decap_12
Xclkbuf_3_1__f_clk clknet_0_clk VGND VGND VPWR VPWR clknet_3_1__leaf_clk sky130_fd_sc_hd__clkbuf_16
XFILLER_126_755 VGND VGND VPWR VPWR sky130_fd_sc_hd__fill_1
XTAP_TAPCELL_ROW_93_1817 VGND VPWR sky130_fd_sc_hd__tapvpwrvgnd_1
XFILLER_8_389 VGND VGND VPWR VPWR sky130_fd_sc_hd__decap_8
XFILLER_113_405 VPWR VGND VPWR VGND sky130_ef_sc_hd__decap_12
XFILLER_99_617 VPWR VGND VPWR VGND sky130_ef_sc_hd__decap_12
XFILLER_4_551 VGND VGND VPWR VPWR sky130_fd_sc_hd__decap_8
XPHY_EDGE_ROW_28_Right_28 VGND VGND VPWR VPWR sky130_fd_sc_hd__decap_3
XFILLER_4_573 VGND VGND VPWR VPWR sky130_fd_sc_hd__fill_1
XFILLER_113_449 VPWR VGND VPWR VGND sky130_ef_sc_hd__decap_12
XFILLER_79_330 VGND VGND VPWR VPWR sky130_fd_sc_hd__decap_6
XFILLER_67_503 VGND VGND VPWR VPWR sky130_fd_sc_hd__fill_1
XFILLER_39_205 VPWR VGND VPWR VGND sky130_ef_sc_hd__decap_12
X_3150_ _0790_ _0810_ _0827_ VGND VGND VPWR VPWR _0838_ sky130_fd_sc_hd__and3_1
XFILLER_79_396 VGND VGND VPWR VPWR sky130_fd_sc_hd__fill_1
X_3081_ _0656_ _0659_ _0767_ VGND VGND VPWR VPWR _0769_ sky130_fd_sc_hd__and3_1
X_2101_ _1359_ VGND VGND VPWR VPWR _1360_ sky130_fd_sc_hd__inv_2
XTAP_TAPCELL_ROW_124_2316 VGND VPWR sky130_fd_sc_hd__tapvpwrvgnd_1
XFILLER_95_889 VGND VGND VPWR VPWR sky130_fd_sc_hd__decap_6
X_2032_ _0903_ _1293_ VGND VGND VPWR VPWR _1294_ sky130_fd_sc_hd__nand2_1
XFILLER_82_539 VPWR VGND VPWR VGND sky130_ef_sc_hd__decap_12
XFILLER_48_783 VGND VGND VPWR VPWR sky130_fd_sc_hd__decap_8
XPHY_EDGE_ROW_37_Right_37 VGND VGND VPWR VPWR sky130_fd_sc_hd__decap_3
XTAP_TAPCELL_ROW_18_620 VGND VPWR sky130_fd_sc_hd__tapvpwrvgnd_1
XANTENNA__3266__RESET_B net36 VGND VGND VPWR VPWR sky130_fd_sc_hd__diode_2
XFILLER_47_293 VPWR VGND VPWR VGND sky130_ef_sc_hd__decap_12
XFILLER_63_797 VPWR VGND VPWR VGND sky130_ef_sc_hd__decap_12
XFILLER_23_617 VPWR VGND VPWR VGND sky130_ef_sc_hd__decap_12
XTAP_TAPCELL_ROW_102_1957 VGND VPWR sky130_fd_sc_hd__tapvpwrvgnd_1
XFILLER_62_296 VGND VGND VPWR VPWR sky130_fd_sc_hd__decap_4
XFILLER_50_447 VPWR VGND VPWR VGND sky130_ef_sc_hd__decap_12
XANTENNA__3210__B _0912_ VGND VGND VPWR VPWR sky130_fd_sc_hd__diode_2
XTAP_TAPCELL_ROW_44_1031 VGND VPWR sky130_fd_sc_hd__tapvpwrvgnd_1
XTAP_TAPCELL_ROW_102_1968 VGND VPWR sky130_fd_sc_hd__tapvpwrvgnd_1
X_2934_ u_crt.r1\[1\] _0556_ VGND VGND VPWR VPWR _0622_ sky130_fd_sc_hd__xnor2_1
XTAP_TAPCELL_ROW_44_1042 VGND VPWR sky130_fd_sc_hd__tapvpwrvgnd_1
XFILLER_148_357 VGND VGND VPWR VPWR sky130_fd_sc_hd__decap_6
X_2865_ net23 B_reg\[15\] _0383_ VGND VGND VPWR VPWR _0088_ sky130_fd_sc_hd__mux2_1
XPHY_EDGE_ROW_46_Right_46 VGND VGND VPWR VPWR sky130_fd_sc_hd__decap_3
X_1816_ _1071_ _1080_ VGND VGND VPWR VPWR _1089_ sky130_fd_sc_hd__or2_1
XTAP_TAPCELL_ROW_152_2770 VGND VPWR sky130_fd_sc_hd__tapvpwrvgnd_1
XTAP_TAPCELL_ROW_135_2489 VGND VPWR sky130_fd_sc_hd__tapvpwrvgnd_1
XFILLER_116_221 VPWR VGND VPWR VGND sky130_ef_sc_hd__decap_12
X_2796_ _0525_ _0532_ VGND VGND VPWR VPWR _0536_ sky130_fd_sc_hd__xnor2_1
XFILLER_7_81 VPWR VGND VPWR VGND sky130_ef_sc_hd__decap_12
XFILLER_117_777 VGND VGND VPWR VPWR sky130_fd_sc_hd__decap_6
XFILLER_117_27 VPWR VGND VPWR VGND sky130_ef_sc_hd__decap_12
X_1747_ _1015_ _1018_ _1016_ VGND VGND VPWR VPWR _1020_ sky130_fd_sc_hd__a21oi_1
XFILLER_132_725 VPWR VGND VPWR VGND sky130_ef_sc_hd__decap_12
XFILLER_116_265 VPWR VGND VPWR VGND sky130_ef_sc_hd__decap_12
X_1678_ _0892_ _0949_ _0953_ VGND VGND VPWR VPWR _0954_ sky130_fd_sc_hd__or3b_1
XFILLER_132_769 VPWR VGND VPWR VGND sky130_ef_sc_hd__decap_12
XFILLER_120_909 VGND VGND VPWR VPWR sky130_fd_sc_hd__fill_1
XFILLER_131_279 VGND VGND VPWR VPWR sky130_fd_sc_hd__fill_1
XFILLER_58_525 VGND VGND VPWR VPWR sky130_fd_sc_hd__decap_6
XFILLER_133_15 VPWR VGND VPWR VGND sky130_ef_sc_hd__decap_12
XFILLER_86_867 VGND VGND VPWR VPWR sky130_fd_sc_hd__fill_1
XPHY_EDGE_ROW_55_Right_55 VGND VGND VPWR VPWR sky130_fd_sc_hd__decap_3
XFILLER_39_772 VGND VGND VPWR VPWR sky130_fd_sc_hd__fill_2
X_3279_ clknet_3_0__leaf_clk _0062_ net36 VGND VGND VPWR VPWR A_reg\[5\] sky130_fd_sc_hd__dfrtp_4
XFILLER_100_699 VGND VGND VPWR VPWR sky130_fd_sc_hd__fill_1
XFILLER_54_731 VGND VGND VPWR VPWR sky130_fd_sc_hd__fill_1
XFILLER_26_433 VPWR VGND VPWR VGND sky130_ef_sc_hd__decap_12
XANTENNA__1835__B1 _0911_ VGND VGND VPWR VPWR sky130_fd_sc_hd__diode_2
XFILLER_81_561 VPWR VGND VPWR VGND sky130_ef_sc_hd__decap_12
XFILLER_13_105 VGND VGND VPWR VPWR sky130_fd_sc_hd__decap_6
XFILLER_26_477 VPWR VGND VPWR VGND sky130_ef_sc_hd__decap_12
XFILLER_13_149 VPWR VGND VPWR VGND sky130_ef_sc_hd__decap_12
XPHY_EDGE_ROW_46_Left_200 VGND VGND VPWR VPWR sky130_fd_sc_hd__decap_3
XFILLER_139_335 VGND VGND VPWR VPWR sky130_fd_sc_hd__fill_1
XPHY_EDGE_ROW_64_Right_64 VGND VGND VPWR VPWR sky130_fd_sc_hd__decap_3
XFILLER_10_867 VGND VGND VPWR VPWR sky130_fd_sc_hd__fill_1
XFILLER_6_805 VGND VGND VPWR VPWR sky130_fd_sc_hd__decap_6
XFILLER_21_193 VPWR VGND VPWR VGND sky130_ef_sc_hd__decap_12
XFILLER_6_849 VPWR VGND VPWR VGND sky130_ef_sc_hd__decap_12
XFILLER_135_541 VPWR VGND VPWR VGND sky130_ef_sc_hd__decap_12
XFILLER_108_755 VGND VGND VPWR VPWR sky130_fd_sc_hd__fill_1
XTAP_TAPCELL_ROW_75_1536 VGND VPWR sky130_fd_sc_hd__tapvpwrvgnd_1
XTAP_TAPCELL_ROW_75_1525 VGND VPWR sky130_fd_sc_hd__tapvpwrvgnd_1
XFILLER_135_585 VPWR VGND VPWR VGND sky130_ef_sc_hd__decap_12
XFILLER_150_533 VPWR VGND VPWR VGND sky130_ef_sc_hd__decap_12
XFILLER_111_909 VGND VGND VPWR VPWR sky130_fd_sc_hd__fill_1
XFILLER_110_419 VGND VGND VPWR VPWR sky130_fd_sc_hd__fill_1
XFILLER_107_93 VPWR VGND VPWR VGND sky130_ef_sc_hd__decap_12
XFILLER_49_503 VGND VGND VPWR VPWR sky130_fd_sc_hd__fill_1
XFILLER_3_39 VPWR VGND VPWR VGND sky130_ef_sc_hd__decap_12
XFILLER_88_193 VGND VGND VPWR VPWR sky130_fd_sc_hd__decap_3
XFILLER_88_171 VGND VGND VPWR VPWR sky130_fd_sc_hd__fill_1
XPHY_EDGE_ROW_73_Right_73 VGND VGND VPWR VPWR sky130_fd_sc_hd__decap_3
XFILLER_77_889 VGND VGND VPWR VPWR sky130_fd_sc_hd__decap_6
XFILLER_76_377 VPWR VGND VPWR VGND sky130_ef_sc_hd__decap_12
XFILLER_37_709 VPWR VGND VPWR VGND sky130_ef_sc_hd__decap_12
XTAP_TAPCELL_ROW_106_2035 VGND VPWR sky130_fd_sc_hd__tapvpwrvgnd_1
XTAP_TAPCELL_ROW_106_2024 VGND VPWR sky130_fd_sc_hd__tapvpwrvgnd_1
XFILLER_92_837 VPWR VGND VPWR VGND sky130_ef_sc_hd__decap_12
XFILLER_57_591 VGND VGND VPWR VPWR sky130_fd_sc_hd__fill_1
XTAP_TAPCELL_ROW_4_392 VGND VPWR sky130_fd_sc_hd__tapvpwrvgnd_1
XFILLER_123_81 VPWR VGND VPWR VGND sky130_ef_sc_hd__decap_12
XFILLER_72_550 VGND VGND VPWR VPWR sky130_fd_sc_hd__decap_6
XFILLER_29_293 VGND VGND VPWR VPWR sky130_fd_sc_hd__decap_8
XFILLER_45_753 VPWR VGND VPWR VGND sky130_ef_sc_hd__decap_12
XFILLER_60_701 VPWR VGND VPWR VGND sky130_ef_sc_hd__decap_12
XFILLER_45_797 VPWR VGND VPWR VGND sky130_ef_sc_hd__decap_12
XPHY_EDGE_ROW_82_Right_82 VGND VGND VPWR VPWR sky130_fd_sc_hd__decap_3
XFILLER_32_469 VGND VGND VPWR VPWR sky130_fd_sc_hd__decap_6
XFILLER_145_305 VPWR VGND VPWR VGND sky130_ef_sc_hd__decap_12
X_2650_ _0387_ _0389_ _0388_ VGND VGND VPWR VPWR _0390_ sky130_fd_sc_hd__a21oi_1
XFILLER_9_665 VGND VGND VPWR VPWR sky130_fd_sc_hd__decap_6
XFILLER_8_153 VPWR VGND VPWR VGND sky130_ef_sc_hd__decap_12
XANTENNA__1766__A A_reg\[9\] VGND VGND VPWR VPWR sky130_fd_sc_hd__diode_2
XFILLER_145_349 VPWR VGND VPWR VGND sky130_ef_sc_hd__decap_12
XFILLER_8_197 VPWR VGND VPWR VGND sky130_ef_sc_hd__decap_12
XTAP_TAPCELL_ROW_117_2197 VGND VPWR sky130_fd_sc_hd__tapvpwrvgnd_1
X_2581_ _0325_ _0187_ _0324_ VGND VGND VPWR VPWR _0326_ sky130_fd_sc_hd__and3b_1
XFILLER_114_725 VPWR VGND VPWR VGND sky130_ef_sc_hd__decap_12
XFILLER_153_393 VPWR VGND VPWR VGND sky130_ef_sc_hd__decap_12
XFILLER_114_769 VPWR VGND VPWR VGND sky130_ef_sc_hd__decap_12
XFILLER_102_909 VGND VGND VPWR VPWR sky130_fd_sc_hd__fill_1
XFILLER_99_447 VGND VGND VPWR VPWR sky130_fd_sc_hd__fill_1
XANTENNA__3192__S CRT_Start VGND VGND VPWR VPWR sky130_fd_sc_hd__diode_2
XFILLER_113_279 VGND VGND VPWR VPWR sky130_fd_sc_hd__fill_1
XPHY_EDGE_ROW_91_Right_91 VGND VGND VPWR VPWR sky130_fd_sc_hd__decap_3
X_3202_ _0912_ _0854_ _0880_ VGND VGND VPWR VPWR _0881_ sky130_fd_sc_hd__o21ai_1
XFILLER_79_193 VGND VGND VPWR VPWR sky130_fd_sc_hd__decap_3
XFILLER_68_867 VGND VGND VPWR VPWR sky130_fd_sc_hd__fill_1
XFILLER_95_653 VPWR VGND VPWR VGND sky130_ef_sc_hd__decap_12
X_3133_ _0818_ _0820_ VGND VGND VPWR VPWR _0821_ sky130_fd_sc_hd__nor2_1
XFILLER_95_697 VPWR VGND VPWR VGND sky130_ef_sc_hd__decap_12
X_3064_ _0688_ _0743_ VGND VGND VPWR VPWR _0752_ sky130_fd_sc_hd__xnor2_1
X_2015_ _1269_ _1272_ VGND VGND VPWR VPWR _1277_ sky130_fd_sc_hd__nand2_1
XFILLER_63_561 VPWR VGND VPWR VGND sky130_ef_sc_hd__decap_12
XFILLER_35_252 VPWR VGND VPWR VGND sky130_ef_sc_hd__decap_12
XFILLER_23_447 VGND VGND VPWR VPWR sky130_fd_sc_hd__fill_1
XANTENNA__3242__CLK clknet_3_6__leaf_clk VGND VGND VPWR VPWR sky130_fd_sc_hd__diode_2
XFILLER_148_121 VPWR VGND VPWR VGND sky130_ef_sc_hd__decap_12
XTAP_TAPCELL_ROW_137_2529 VGND VPWR sky130_fd_sc_hd__tapvpwrvgnd_1
XTAP_TAPCELL_ROW_137_2518 VGND VPWR sky130_fd_sc_hd__tapvpwrvgnd_1
X_2917_ _0554_ _0604_ VGND VGND VPWR VPWR _0605_ sky130_fd_sc_hd__nand2_1
XFILLER_50_277 VPWR VGND VPWR VGND sky130_ef_sc_hd__decap_12
XFILLER_148_165 VPWR VGND VPWR VGND sky130_ef_sc_hd__decap_12
XFILLER_137_839 VGND VGND VPWR VPWR sky130_fd_sc_hd__fill_1
XFILLER_12_15 VPWR VGND VPWR VGND sky130_ef_sc_hd__decap_12
XTAP_TAPCELL_ROW_150_2729 VGND VPWR sky130_fd_sc_hd__tapvpwrvgnd_1
XFILLER_128_15 VPWR VGND VPWR VGND sky130_ef_sc_hd__decap_12
X_2848_ net6 A_reg\[14\] _0383_ VGND VGND VPWR VPWR _0071_ sky130_fd_sc_hd__mux2_1
XFILLER_117_541 VPWR VGND VPWR VGND sky130_ef_sc_hd__decap_12
X_2779_ _0517_ _0518_ VGND VGND VPWR VPWR _0519_ sky130_fd_sc_hd__nand2b_1
XFILLER_117_585 VPWR VGND VPWR VGND sky130_ef_sc_hd__decap_12
XTAP_TAPCELL_ROW_57_1244 VGND VPWR sky130_fd_sc_hd__tapvpwrvgnd_1
XFILLER_132_533 VPWR VGND VPWR VGND sky130_ef_sc_hd__decap_12
XTAP_TAPCELL_ROW_70_1455 VGND VPWR sky130_fd_sc_hd__tapvpwrvgnd_1
XTAP_TAPCELL_ROW_70_1444 VGND VPWR sky130_fd_sc_hd__tapvpwrvgnd_1
XFILLER_59_889 VGND VGND VPWR VPWR sky130_fd_sc_hd__decap_6
XFILLER_19_709 VPWR VGND VPWR VGND sky130_ef_sc_hd__decap_12
XFILLER_85_163 VGND VGND VPWR VPWR sky130_fd_sc_hd__decap_4
XFILLER_74_837 VPWR VGND VPWR VGND sky130_ef_sc_hd__decap_12
XFILLER_58_377 VPWR VGND VPWR VGND sky130_ef_sc_hd__decap_12
XTAP_TAPCELL_ROW_1_340 VGND VPWR sky130_fd_sc_hd__tapvpwrvgnd_1
XTAP_TAPCELL_ROW_1_351 VGND VPWR sky130_fd_sc_hd__tapvpwrvgnd_1
XFILLER_27_753 VPWR VGND VPWR VGND sky130_ef_sc_hd__decap_12
XFILLER_82_881 VPWR VGND VPWR VGND sky130_ef_sc_hd__decap_12
XFILLER_27_797 VPWR VGND VPWR VGND sky130_ef_sc_hd__decap_12
XFILLER_42_701 VPWR VGND VPWR VGND sky130_ef_sc_hd__decap_12
XFILLER_26_285 VPWR VGND VPWR VGND sky130_ef_sc_hd__decap_12
XFILLER_127_305 VPWR VGND VPWR VGND sky130_ef_sc_hd__decap_12
XTAP_TAPCELL_ROW_40_968 VGND VPWR sky130_fd_sc_hd__tapvpwrvgnd_1
XTAP_TAPCELL_ROW_40_979 VGND VPWR sky130_fd_sc_hd__tapvpwrvgnd_1
XFILLER_127_349 VPWR VGND VPWR VGND sky130_ef_sc_hd__decap_12
XFILLER_143_809 VPWR VGND VPWR VGND sky130_ef_sc_hd__decap_12
XFILLER_136_861 VGND VGND VPWR VPWR sky130_fd_sc_hd__decap_6
XFILLER_5_167 VGND VGND VPWR VPWR sky130_fd_sc_hd__fill_1
XFILLER_151_853 VPWR VGND VPWR VGND sky130_ef_sc_hd__decap_12
XFILLER_135_393 VPWR VGND VPWR VGND sky130_ef_sc_hd__decap_12
XFILLER_69_609 VGND VGND VPWR VPWR sky130_fd_sc_hd__decap_6
XFILLER_151_897 VPWR VGND VPWR VGND sky130_ef_sc_hd__decap_12
XFILLER_150_363 VGND VGND VPWR VPWR sky130_fd_sc_hd__fill_1
XFILLER_78_85 VGND VGND VPWR VPWR sky130_fd_sc_hd__decap_4
XTAP_TAPCELL_ROW_9_473 VGND VPWR sky130_fd_sc_hd__tapvpwrvgnd_1
XANTENNA__2210__A A_reg\[6\] VGND VGND VPWR VPWR sky130_fd_sc_hd__diode_2
XFILLER_1_373 VPWR VGND VPWR VGND sky130_ef_sc_hd__decap_12
XFILLER_76_141 VPWR VGND VPWR VGND sky130_ef_sc_hd__decap_12
XTAP_TAPCELL_ROW_88_1738 VGND VPWR sky130_fd_sc_hd__tapvpwrvgnd_1
XFILLER_49_377 VPWR VGND VPWR VGND sky130_ef_sc_hd__decap_12
XFILLER_37_517 VPWR VGND VPWR VGND sky130_ef_sc_hd__decap_12
XFILLER_92_645 VPWR VGND VPWR VGND sky130_ef_sc_hd__decap_12
XFILLER_91_144 VPWR VGND VPWR VGND sky130_ef_sc_hd__decap_12
XANTENNA__3265__CLK clknet_3_7__leaf_clk VGND VGND VPWR VPWR sky130_fd_sc_hd__diode_2
XFILLER_91_199 VGND VGND VPWR VPWR sky130_fd_sc_hd__decap_6
XFILLER_60_531 VGND VGND VPWR VPWR sky130_fd_sc_hd__fill_1
XTAP_TAPCELL_ROW_28_781 VGND VPWR sky130_fd_sc_hd__tapvpwrvgnd_1
XFILLER_32_222 VPWR VGND VPWR VGND sky130_ef_sc_hd__decap_12
XFILLER_32_266 VPWR VGND VPWR VGND sky130_ef_sc_hd__decap_12
XTAP_TAPCELL_ROW_119_2237 VGND VPWR sky130_fd_sc_hd__tapvpwrvgnd_1
X_2702_ _0440_ _0441_ VGND VGND VPWR VPWR _0442_ sky130_fd_sc_hd__xnor2_1
XFILLER_146_625 VPWR VGND VPWR VGND sky130_ef_sc_hd__decap_12
XFILLER_145_113 VPWR VGND VPWR VGND sky130_ef_sc_hd__decap_12
XFILLER_119_839 VGND VGND VPWR VPWR sky130_fd_sc_hd__fill_1
XFILLER_71_3 VPWR VGND VPWR VGND sky130_ef_sc_hd__decap_12
XFILLER_9_484 VPWR VGND VPWR VGND sky130_ef_sc_hd__decap_12
XFILLER_146_669 VPWR VGND VPWR VGND sky130_ef_sc_hd__decap_12
XTAP_TAPCELL_ROW_132_2437 VGND VPWR sky130_fd_sc_hd__tapvpwrvgnd_1
X_2633_ _0375_ _0371_ VGND VGND VPWR VPWR _0378_ sky130_fd_sc_hd__nand2b_1
XTAP_TAPCELL_ROW_132_2448 VGND VPWR sky130_fd_sc_hd__tapvpwrvgnd_1
X_2564_ a_r2\[0\] b_r2\[2\] VGND VGND VPWR VPWR _0309_ sky130_fd_sc_hd__nand2_1
XANTENNA__2527__A1 _0185_ VGND VGND VPWR VPWR sky130_fd_sc_hd__diode_2
XFILLER_114_533 VPWR VGND VPWR VGND sky130_ef_sc_hd__decap_12
XFILLER_99_222 VGND VGND VPWR VPWR sky130_fd_sc_hd__fill_2
XFILLER_101_205 VPWR VGND VPWR VGND sky130_ef_sc_hd__decap_12
X_2495_ _0240_ _0242_ _0185_ VGND VGND VPWR VPWR _0243_ sky130_fd_sc_hd__o21ai_1
XFILLER_141_385 VGND VGND VPWR VPWR sky130_fd_sc_hd__decap_6
XANTENNA__2120__A B_reg\[7\] VGND VGND VPWR VPWR sky130_fd_sc_hd__diode_2
XFILLER_101_249 VPWR VGND VPWR VGND sky130_ef_sc_hd__decap_12
XTAP_TAPCELL_ROW_52_1163 VGND VPWR sky130_fd_sc_hd__tapvpwrvgnd_1
XTAP_TAPCELL_ROW_147_2691 VGND VPWR sky130_fd_sc_hd__tapvpwrvgnd_1
XTAP_TAPCELL_ROW_147_2680 VGND VPWR sky130_fd_sc_hd__tapvpwrvgnd_1
XFILLER_95_461 VPWR VGND VPWR VGND sky130_ef_sc_hd__decap_12
XFILLER_82_100 VPWR VGND VPWR VGND sky130_ef_sc_hd__decap_12
X_3116_ _0777_ _0799_ VGND VGND VPWR VPWR _0804_ sky130_fd_sc_hd__xor2_1
XANTENNA__3281__RESET_B net36 VGND VGND VPWR VPWR sky130_fd_sc_hd__diode_2
XFILLER_56_859 VGND VGND VPWR VPWR sky130_fd_sc_hd__decap_8
XFILLER_130_27 VGND VGND VPWR VPWR sky130_fd_sc_hd__fill_1
XFILLER_64_881 VPWR VGND VPWR VGND sky130_ef_sc_hd__decap_12
X_3047_ _0733_ _0734_ VGND VGND VPWR VPWR _0735_ sky130_fd_sc_hd__nand2_1
XFILLER_24_701 VPWR VGND VPWR VGND sky130_ef_sc_hd__decap_12
XFILLER_36_561 VGND VGND VPWR VPWR sky130_fd_sc_hd__fill_1
XFILLER_82_188 VGND VGND VPWR VPWR sky130_fd_sc_hd__decap_8
XFILLER_51_553 VGND VGND VPWR VPWR sky130_fd_sc_hd__decap_6
XFILLER_11_406 VPWR VGND VPWR VGND sky130_ef_sc_hd__decap_12
XFILLER_51_597 VPWR VGND VPWR VGND sky130_ef_sc_hd__decap_12
XFILLER_149_441 VGND VGND VPWR VPWR sky130_fd_sc_hd__decap_6
XFILLER_109_305 VPWR VGND VPWR VGND sky130_ef_sc_hd__decap_12
XFILLER_23_69 VPWR VGND VPWR VGND sky130_ef_sc_hd__decap_12
XFILLER_149_485 VPWR VGND VPWR VGND sky130_ef_sc_hd__decap_12
XFILLER_139_69 VPWR VGND VPWR VGND sky130_ef_sc_hd__decap_12
XFILLER_125_809 VPWR VGND VPWR VGND sky130_ef_sc_hd__decap_12
XFILLER_118_861 VGND VGND VPWR VPWR sky130_fd_sc_hd__decap_6
XFILLER_109_349 VPWR VGND VPWR VGND sky130_ef_sc_hd__decap_12
XFILLER_151_105 VGND VGND VPWR VPWR sky130_fd_sc_hd__decap_6
XFILLER_151_149 VPWR VGND VPWR VGND sky130_ef_sc_hd__decap_12
XFILLER_133_853 VPWR VGND VPWR VGND sky130_ef_sc_hd__decap_12
XFILLER_117_393 VPWR VGND VPWR VGND sky130_ef_sc_hd__decap_12
XFILLER_133_897 VPWR VGND VPWR VGND sky130_ef_sc_hd__decap_12
XFILLER_132_363 VGND VGND VPWR VPWR sky130_fd_sc_hd__fill_1
XFILLER_120_525 VGND VGND VPWR VPWR sky130_fd_sc_hd__decap_6
XTAP_TAPCELL_ROW_6_432 VGND VPWR sky130_fd_sc_hd__tapvpwrvgnd_1
XTAP_TAPCELL_ROW_6_421 VGND VPWR sky130_fd_sc_hd__tapvpwrvgnd_1
XFILLER_120_569 VPWR VGND VPWR VGND sky130_ef_sc_hd__decap_12
XFILLER_58_141 VPWR VGND VPWR VGND sky130_ef_sc_hd__decap_12
XANTENNA__3288__CLK clknet_3_5__leaf_clk VGND VGND VPWR VPWR sky130_fd_sc_hd__diode_2
XFILLER_101_783 VGND VGND VPWR VPWR sky130_fd_sc_hd__fill_1
XFILLER_19_517 VPWR VGND VPWR VGND sky130_ef_sc_hd__decap_12
XFILLER_74_645 VPWR VGND VPWR VGND sky130_ef_sc_hd__decap_12
XFILLER_0_29 VPWR VGND VPWR VGND sky130_ef_sc_hd__decap_12
XFILLER_104_83 VGND VGND VPWR VPWR sky130_fd_sc_hd__fill_1
XFILLER_27_561 VPWR VGND VPWR VGND sky130_ef_sc_hd__decap_12
XANTENNA__2454__B1 _0187_ VGND VGND VPWR VPWR sky130_fd_sc_hd__diode_2
XFILLER_64_65 VGND VGND VPWR VPWR sky130_fd_sc_hd__decap_8
XTAP_TAPCELL_ROW_83_1657 VGND VPWR sky130_fd_sc_hd__tapvpwrvgnd_1
XFILLER_9_27 VPWR VGND VPWR VGND sky130_ef_sc_hd__decap_12
XFILLER_14_233 VGND VGND VPWR VPWR sky130_fd_sc_hd__decap_6
XFILLER_30_737 VPWR VGND VPWR VGND sky130_ef_sc_hd__decap_12
XFILLER_80_53 VPWR VGND VPWR VGND sky130_ef_sc_hd__decap_12
XFILLER_14_299 VGND VGND VPWR VPWR sky130_fd_sc_hd__decap_8
XFILLER_128_625 VPWR VGND VPWR VGND sky130_ef_sc_hd__decap_12
XFILLER_127_113 VPWR VGND VPWR VGND sky130_ef_sc_hd__decap_12
XFILLER_128_669 VPWR VGND VPWR VGND sky130_ef_sc_hd__decap_12
XFILLER_6_421 VPWR VGND VPWR VGND sky130_ef_sc_hd__decap_12
XFILLER_143_617 VPWR VGND VPWR VGND sky130_ef_sc_hd__decap_12
XTAP_TAPCELL_ROW_114_2156 VGND VPWR sky130_fd_sc_hd__tapvpwrvgnd_1
XPHY_EDGE_ROW_108_Right_108 VGND VGND VPWR VPWR sky130_fd_sc_hd__decap_3
XFILLER_123_385 VGND VGND VPWR VPWR sky130_fd_sc_hd__decap_6
XFILLER_111_514 VPWR VGND VPWR VGND sky130_ef_sc_hd__decap_12
X_2280_ _1521_ _1526_ _1528_ _1536_ VGND VGND VPWR VPWR _1537_ sky130_fd_sc_hd__a31o_1
XFILLER_2_693 VGND VGND VPWR VPWR sky130_fd_sc_hd__decap_6
XFILLER_111_558 VGND VGND VPWR VPWR sky130_fd_sc_hd__fill_2
XFILLER_1_181 VPWR VGND VPWR VGND sky130_ef_sc_hd__decap_12
XFILLER_77_461 VPWR VGND VPWR VGND sky130_ef_sc_hd__decap_12
XFILLER_65_612 VGND VGND VPWR VPWR sky130_fd_sc_hd__decap_4
XFILLER_38_837 VGND VGND VPWR VPWR sky130_fd_sc_hd__decap_8
XFILLER_92_475 VGND VGND VPWR VPWR sky130_fd_sc_hd__fill_1
XFILLER_65_678 VPWR VGND VPWR VGND sky130_ef_sc_hd__decap_12
XFILLER_45_391 VGND VGND VPWR VPWR sky130_fd_sc_hd__fill_1
X_1995_ B_reg\[15\] B_reg\[14\] B_reg\[13\] VGND VGND VPWR VPWR _1257_ sky130_fd_sc_hd__a21o_1
XFILLER_146_433 VPWR VGND VPWR VGND sky130_ef_sc_hd__decap_12
XFILLER_107_809 VPWR VGND VPWR VGND sky130_ef_sc_hd__decap_12
XFILLER_9_281 VPWR VGND VPWR VGND sky130_ef_sc_hd__decap_12
XFILLER_146_477 VPWR VGND VPWR VGND sky130_ef_sc_hd__decap_12
XFILLER_133_105 VGND VGND VPWR VPWR sky130_fd_sc_hd__decap_6
XFILLER_109_39 VPWR VGND VPWR VGND sky130_ef_sc_hd__decap_12
X_2616_ b_r2\[0\] a_r2\[1\] b_r2\[1\] a_r2\[0\] VGND VGND VPWR VPWR _0361_ sky130_fd_sc_hd__a22o_1
XFILLER_133_149 VPWR VGND VPWR VGND sky130_ef_sc_hd__decap_12
XFILLER_115_853 VPWR VGND VPWR VGND sky130_ef_sc_hd__decap_12
XTAP_TAPCELL_ROW_54_1203 VGND VPWR sky130_fd_sc_hd__tapvpwrvgnd_1
XTAP_TAPCELL_ROW_149_2720 VGND VPWR sky130_fd_sc_hd__tapvpwrvgnd_1
XFILLER_114_363 VGND VGND VPWR VPWR sky130_fd_sc_hd__fill_1
XFILLER_87_203 VPWR VGND VPWR VGND sky130_ef_sc_hd__decap_12
X_2547_ _0284_ _0292_ VGND VGND VPWR VPWR _0295_ sky130_fd_sc_hd__xor2_1
XFILLER_125_27 VPWR VGND VPWR VGND sky130_ef_sc_hd__decap_12
XFILLER_115_897 VPWR VGND VPWR VGND sky130_ef_sc_hd__decap_12
XFILLER_88_737 VPWR VGND VPWR VGND sky130_ef_sc_hd__decap_12
XFILLER_87_225 VGND VGND VPWR VPWR sky130_fd_sc_hd__decap_8
X_2478_ _0188_ _0224_ _0225_ VGND VGND VPWR VPWR _0226_ sky130_fd_sc_hd__or3b_1
XPHY_EDGE_ROW_10_Left_164 VGND VGND VPWR VPWR sky130_fd_sc_hd__decap_3
XFILLER_141_193 VPWR VGND VPWR VGND sky130_ef_sc_hd__decap_12
XFILLER_130_867 VGND VGND VPWR VPWR sky130_fd_sc_hd__fill_1
XFILLER_96_781 VPWR VGND VPWR VGND sky130_ef_sc_hd__decap_12
XFILLER_56_601 VGND VGND VPWR VPWR sky130_fd_sc_hd__decap_8
XFILLER_141_15 VPWR VGND VPWR VGND sky130_ef_sc_hd__decap_12
XFILLER_56_645 VPWR VGND VPWR VGND sky130_ef_sc_hd__decap_12
XFILLER_28_347 VPWR VGND VPWR VGND sky130_ef_sc_hd__decap_12
XFILLER_83_486 VPWR VGND VPWR VGND sky130_ef_sc_hd__decap_12
XFILLER_71_637 VPWR VGND VPWR VGND sky130_ef_sc_hd__decap_12
XFILLER_55_177 VGND VGND VPWR VPWR sky130_fd_sc_hd__fill_1
XTAP_TAPCELL_ROW_65_1365 VGND VPWR sky130_fd_sc_hd__tapvpwrvgnd_1
XFILLER_24_531 VGND VGND VPWR VPWR sky130_fd_sc_hd__fill_1
XTAP_TAPCELL_ROW_65_1376 VGND VPWR sky130_fd_sc_hd__tapvpwrvgnd_1
XFILLER_12_737 VPWR VGND VPWR VGND sky130_ef_sc_hd__decap_12
XFILLER_11_225 VPWR VGND VPWR VGND sky130_ef_sc_hd__decap_12
XFILLER_109_113 VPWR VGND VPWR VGND sky130_ef_sc_hd__decap_12
Xclkload1 clknet_3_1__leaf_clk VGND VGND VPWR VPWR clkload1/Y sky130_fd_sc_hd__inv_12
XFILLER_149_293 VPWR VGND VPWR VGND sky130_ef_sc_hd__decap_12
XFILLER_20_781 VPWR VGND VPWR VGND sky130_ef_sc_hd__decap_12
XFILLER_125_617 VPWR VGND VPWR VGND sky130_ef_sc_hd__decap_12
XFILLER_119_3 VPWR VGND VPWR VGND sky130_ef_sc_hd__decap_12
XFILLER_59_10 VPWR VGND VPWR VGND sky130_ef_sc_hd__decap_12
XFILLER_152_469 VGND VGND VPWR VPWR sky130_fd_sc_hd__decap_6
XFILLER_1_3 VPWR VGND VPWR VGND sky130_ef_sc_hd__decap_12
XFILLER_105_385 VGND VGND VPWR VPWR sky130_fd_sc_hd__decap_6
XFILLER_59_54 VGND VGND VPWR VPWR sky130_fd_sc_hd__fill_2
XFILLER_120_333 VPWR VGND VPWR VGND sky130_ef_sc_hd__decap_12
XFILLER_78_247 VGND VGND VPWR VPWR sky130_fd_sc_hd__decap_4
XFILLER_121_889 VGND VGND VPWR VPWR sky130_fd_sc_hd__decap_6
XFILLER_120_377 VPWR VGND VPWR VGND sky130_ef_sc_hd__decap_12
XFILLER_93_217 VGND VGND VPWR VPWR sky130_fd_sc_hd__decap_6
XFILLER_59_461 VPWR VGND VPWR VGND sky130_ef_sc_hd__decap_12
XFILLER_115_93 VPWR VGND VPWR VGND sky130_ef_sc_hd__decap_12
XFILLER_75_42 VPWR VGND VPWR VGND sky130_ef_sc_hd__decap_12
XFILLER_46_133 VGND VGND VPWR VPWR sky130_fd_sc_hd__decap_6
XFILLER_74_475 VGND VGND VPWR VPWR sky130_fd_sc_hd__fill_1
XFILLER_62_615 VPWR VGND VPWR VGND sky130_ef_sc_hd__decap_12
XFILLER_28_881 VPWR VGND VPWR VGND sky130_ef_sc_hd__decap_12
XFILLER_46_177 VPWR VGND VPWR VGND sky130_ef_sc_hd__decap_12
XFILLER_131_81 VPWR VGND VPWR VGND sky130_ef_sc_hd__decap_12
XFILLER_61_169 VPWR VGND VPWR VGND sky130_ef_sc_hd__decap_12
XFILLER_15_553 VGND VGND VPWR VPWR sky130_fd_sc_hd__decap_6
XFILLER_70_681 VPWR VGND VPWR VGND sky130_ef_sc_hd__decap_12
XFILLER_15_597 VPWR VGND VPWR VGND sky130_ef_sc_hd__decap_12
XFILLER_30_501 VPWR VGND VPWR VGND sky130_ef_sc_hd__decap_12
XFILLER_43_895 VGND VGND VPWR VPWR sky130_fd_sc_hd__fill_1
XANTENNA__3303__CLK clknet_3_0__leaf_clk VGND VGND VPWR VPWR sky130_fd_sc_hd__diode_2
X_1780_ _1048_ _1049_ _1051_ _0892_ VGND VGND VPWR VPWR _1053_ sky130_fd_sc_hd__a22o_1
XFILLER_30_589 VPWR VGND VPWR VGND sky130_ef_sc_hd__decap_12
XFILLER_128_433 VPWR VGND VPWR VGND sky130_ef_sc_hd__decap_12
XFILLER_7_741 VPWR VGND VPWR VGND sky130_ef_sc_hd__decap_12
XFILLER_128_477 VPWR VGND VPWR VGND sky130_ef_sc_hd__decap_12
XFILLER_115_105 VGND VGND VPWR VPWR sky130_fd_sc_hd__decap_6
XFILLER_7_785 VPWR VGND VPWR VGND sky130_ef_sc_hd__decap_12
XFILLER_143_447 VGND VGND VPWR VPWR sky130_fd_sc_hd__fill_1
XFILLER_115_149 VPWR VGND VPWR VGND sky130_ef_sc_hd__decap_12
XFILLER_131_609 VGND VGND VPWR VPWR sky130_fd_sc_hd__decap_6
X_2401_ _0151_ _0154_ VGND VGND VPWR VPWR _0155_ sky130_fd_sc_hd__nand2_1
XFILLER_69_225 VGND VGND VPWR VPWR sky130_fd_sc_hd__decap_6
X_2332_ _1570_ _1579_ _1574_ VGND VGND VPWR VPWR _1585_ sky130_fd_sc_hd__a21bo_1
XFILLER_34_3 VPWR VGND VPWR VGND sky130_ef_sc_hd__decap_12
XFILLER_123_193 VPWR VGND VPWR VGND sky130_ef_sc_hd__decap_12
XFILLER_112_867 VGND VGND VPWR VPWR sky130_fd_sc_hd__fill_1
XFILLER_57_409 VGND VGND VPWR VPWR sky130_fd_sc_hd__fill_2
XFILLER_85_729 VPWR VGND VPWR VGND sky130_ef_sc_hd__decap_12
XFILLER_78_781 VPWR VGND VPWR VGND sky130_ef_sc_hd__decap_12
X_2263_ _1513_ _1518_ _1516_ VGND VGND VPWR VPWR _1520_ sky130_fd_sc_hd__a21oi_1
XFILLER_38_601 VPWR VGND VPWR VGND sky130_ef_sc_hd__decap_12
XTAP_TAPCELL_ROW_127_2369 VGND VPWR sky130_fd_sc_hd__tapvpwrvgnd_1
XTAP_TAPCELL_ROW_127_2358 VGND VPWR sky130_fd_sc_hd__tapvpwrvgnd_1
X_2194_ _1436_ _1439_ _1430_ VGND VGND VPWR VPWR _1451_ sky130_fd_sc_hd__a21o_1
XFILLER_37_111 VGND VGND VPWR VPWR sky130_fd_sc_hd__fill_1
XFILLER_38_645 VPWR VGND VPWR VGND sky130_ef_sc_hd__decap_12
XFILLER_53_615 VGND VGND VPWR VPWR sky130_fd_sc_hd__fill_1
XFILLER_25_317 VGND VGND VPWR VPWR sky130_fd_sc_hd__decap_4
XTAP_TAPCELL_ROW_140_2569 VGND VPWR sky130_fd_sc_hd__tapvpwrvgnd_1
XFILLER_52_169 VPWR VGND VPWR VGND sky130_ef_sc_hd__decap_12
XTAP_TAPCELL_ROW_47_1084 VGND VPWR sky130_fd_sc_hd__tapvpwrvgnd_1
XFILLER_139_709 VPWR VGND VPWR VGND sky130_ef_sc_hd__decap_12
XTAP_TAPCELL_ROW_16_581 VGND VPWR sky130_fd_sc_hd__tapvpwrvgnd_1
XTAP_TAPCELL_ROW_16_592 VGND VPWR sky130_fd_sc_hd__tapvpwrvgnd_1
XFILLER_147_753 VPWR VGND VPWR VGND sky130_ef_sc_hd__decap_12
X_1978_ B_reg\[1\] _1234_ _1240_ _1242_ VGND VGND VPWR VPWR _1243_ sky130_fd_sc_hd__a31o_1
XTAP_TAPCELL_ROW_60_1295 VGND VPWR sky130_fd_sc_hd__tapvpwrvgnd_1
XTAP_TAPCELL_ROW_60_1284 VGND VPWR sky130_fd_sc_hd__tapvpwrvgnd_1
XFILLER_147_797 VPWR VGND VPWR VGND sky130_ef_sc_hd__decap_12
XFILLER_107_617 VPWR VGND VPWR VGND sky130_ef_sc_hd__decap_12
XFILLER_20_15 VPWR VGND VPWR VGND sky130_ef_sc_hd__decap_12
XFILLER_136_15 VPWR VGND VPWR VGND sky130_ef_sc_hd__decap_12
XFILLER_134_469 VGND VGND VPWR VPWR sky130_fd_sc_hd__decap_6
XFILLER_88_501 VPWR VGND VPWR VGND sky130_ef_sc_hd__decap_12
XFILLER_0_405 VPWR VGND VPWR VGND sky130_ef_sc_hd__decap_12
XFILLER_102_333 VPWR VGND VPWR VGND sky130_ef_sc_hd__decap_12
XFILLER_88_567 VPWR VGND VPWR VGND sky130_ef_sc_hd__decap_12
XFILLER_88_545 VGND VGND VPWR VPWR sky130_fd_sc_hd__decap_8
XFILLER_76_718 VPWR VGND VPWR VGND sky130_ef_sc_hd__decap_12
XFILLER_0_449 VPWR VGND VPWR VGND sky130_ef_sc_hd__decap_12
XFILLER_103_889 VGND VGND VPWR VPWR sky130_fd_sc_hd__decap_6
XFILLER_102_377 VGND VGND VPWR VPWR sky130_fd_sc_hd__fill_2
XFILLER_88_589 VGND VGND VPWR VPWR sky130_fd_sc_hd__decap_8
XFILLER_75_217 VGND VGND VPWR VPWR sky130_fd_sc_hd__decap_6
XFILLER_29_57 VPWR VGND VPWR VGND sky130_ef_sc_hd__decap_12
XTAP_TAPCELL_ROW_67_1405 VGND VPWR sky130_fd_sc_hd__tapvpwrvgnd_1
XFILLER_56_475 VGND VGND VPWR VPWR sky130_fd_sc_hd__fill_1
XFILLER_28_133 VGND VGND VPWR VPWR sky130_fd_sc_hd__decap_6
XFILLER_83_261 VPWR VGND VPWR VGND sky130_ef_sc_hd__decap_12
XFILLER_28_177 VPWR VGND VPWR VGND sky130_ef_sc_hd__decap_12
XFILLER_43_125 VPWR VGND VPWR VGND sky130_ef_sc_hd__decap_12
XFILLER_71_445 VGND VGND VPWR VPWR sky130_fd_sc_hd__decap_3
XANTENNA__1880__A1 A_reg\[3\] VGND VGND VPWR VPWR sky130_fd_sc_hd__diode_2
XFILLER_101_51 VGND VGND VPWR VPWR sky130_fd_sc_hd__decap_4
XTAP_TAPCELL_ROW_80_1616 VGND VPWR sky130_fd_sc_hd__tapvpwrvgnd_1
XTAP_TAPCELL_ROW_80_1605 VGND VPWR sky130_fd_sc_hd__tapvpwrvgnd_1
XFILLER_12_501 VPWR VGND VPWR VGND sky130_ef_sc_hd__decap_12
XFILLER_25_895 VGND VGND VPWR VPWR sky130_fd_sc_hd__fill_1
XFILLER_40_810 VGND VGND VPWR VPWR sky130_fd_sc_hd__fill_2
XFILLER_12_545 VPWR VGND VPWR VGND sky130_ef_sc_hd__decap_12
XTAP_TAPCELL_ROW_35_890 VGND VPWR sky130_fd_sc_hd__tapvpwrvgnd_1
XFILLER_61_55 VGND VGND VPWR VPWR sky130_fd_sc_hd__fill_1
XFILLER_153_701 VPWR VGND VPWR VGND sky130_ef_sc_hd__decap_12
XFILLER_152_233 VPWR VGND VPWR VGND sky130_ef_sc_hd__decap_12
XFILLER_125_447 VGND VGND VPWR VPWR sky130_fd_sc_hd__fill_1
XTAP_TAPCELL_ROW_111_2104 VGND VPWR sky130_fd_sc_hd__tapvpwrvgnd_1
XTAP_TAPCELL_ROW_78_1578 VGND VPWR sky130_fd_sc_hd__tapvpwrvgnd_1
XANTENNA__3313__RESET_B net36 VGND VGND VPWR VPWR sky130_fd_sc_hd__diode_2
XFILLER_113_609 VGND VGND VPWR VPWR sky130_fd_sc_hd__decap_6
XTAP_TAPCELL_ROW_111_2115 VGND VPWR sky130_fd_sc_hd__tapvpwrvgnd_1
XFILLER_4_755 VGND VGND VPWR VPWR sky130_fd_sc_hd__fill_1
XFILLER_152_277 VPWR VGND VPWR VGND sky130_ef_sc_hd__decap_12
XFILLER_121_653 VPWR VGND VPWR VGND sky130_ef_sc_hd__decap_12
XFILLER_105_193 VPWR VGND VPWR VGND sky130_ef_sc_hd__decap_12
XTAP_TAPCELL_ROW_91_1789 VGND VPWR sky130_fd_sc_hd__tapvpwrvgnd_1
XFILLER_121_697 VPWR VGND VPWR VGND sky130_ef_sc_hd__decap_12
XFILLER_120_141 VPWR VGND VPWR VGND sky130_ef_sc_hd__decap_12
XFILLER_86_41 VPWR VGND VPWR VGND sky130_ef_sc_hd__decap_12
XFILLER_67_729 VPWR VGND VPWR VGND sky130_ef_sc_hd__decap_12
XFILLER_86_85 VGND VGND VPWR VPWR sky130_fd_sc_hd__decap_8
XFILLER_66_239 VPWR VGND VPWR VGND sky130_ef_sc_hd__decap_12
XFILLER_19_111 VGND VGND VPWR VPWR sky130_fd_sc_hd__fill_1
XTAP_TAPCELL_ROW_109_2077 VGND VPWR sky130_fd_sc_hd__tapvpwrvgnd_1
XANTENNA_clkload4_A clknet_3_4__leaf_clk VGND VGND VPWR VPWR sky130_fd_sc_hd__diode_2
XFILLER_35_615 VGND VGND VPWR VPWR sky130_fd_sc_hd__fill_1
XTAP_TAPCELL_ROW_122_2277 VGND VPWR sky130_fd_sc_hd__tapvpwrvgnd_1
XFILLER_62_456 VGND VGND VPWR VPWR sky130_fd_sc_hd__decap_3
XTAP_TAPCELL_ROW_122_2288 VGND VPWR sky130_fd_sc_hd__tapvpwrvgnd_1
X_2950_ _0615_ _0636_ VGND VGND VPWR VPWR _0638_ sky130_fd_sc_hd__nor2_1
XFILLER_15_361 VPWR VGND VPWR VGND sky130_ef_sc_hd__decap_12
XFILLER_22_309 VPWR VGND VPWR VGND sky130_ef_sc_hd__decap_12
X_2881_ u_crt.r3\[3\] u_crt.r3\[2\] u_crt.r3\[0\] VGND VGND VPWR VPWR _0569_ sky130_fd_sc_hd__a21oi_1
X_1901_ ALU_EN _1163_ _1166_ CU_state_dbg\[2\] VGND VGND VPWR VPWR _0010_ sky130_fd_sc_hd__a22o_1
XTAP_TAPCELL_ROW_13_540 VGND VPWR sky130_fd_sc_hd__tapvpwrvgnd_1
X_1832_ _1096_ _1098_ VGND VGND VPWR VPWR _1105_ sky130_fd_sc_hd__and2_1
XFILLER_129_753 VPWR VGND VPWR VGND sky130_ef_sc_hd__decap_12
XFILLER_144_701 VPWR VGND VPWR VGND sky130_ef_sc_hd__decap_12
XFILLER_129_797 VPWR VGND VPWR VGND sky130_ef_sc_hd__decap_12
X_1763_ _1034_ _1035_ VGND VGND VPWR VPWR _1036_ sky130_fd_sc_hd__or2_1
X_1694_ _0961_ _0969_ _0962_ VGND VGND VPWR VPWR _0970_ sky130_fd_sc_hd__o21ba_1
XFILLER_116_469 VGND VGND VPWR VPWR sky130_fd_sc_hd__decap_6
XANTENNA__3208__B _0912_ VGND VGND VPWR VPWR sky130_fd_sc_hd__diode_2
XFILLER_131_417 VPWR VGND VPWR VGND sky130_ef_sc_hd__decap_12
XFILLER_106_29 VPWR VGND VPWR VGND sky130_ef_sc_hd__decap_12
X_3295_ clknet_3_2__leaf_clk _0078_ net36 VGND VGND VPWR VPWR B_reg\[5\] sky130_fd_sc_hd__dfrtp_4
X_2315_ _1554_ _1555_ _1567_ VGND VGND VPWR VPWR _1568_ sky130_fd_sc_hd__a21o_1
XTAP_TAPCELL_ROW_142_2609 VGND VPWR sky130_fd_sc_hd__tapvpwrvgnd_1
XFILLER_100_837 VPWR VGND VPWR VGND sky130_ef_sc_hd__decap_12
X_2246_ _1501_ _1502_ VGND VGND VPWR VPWR _1503_ sky130_fd_sc_hd__nor2_1
XFILLER_72_209 VPWR VGND VPWR VGND sky130_ef_sc_hd__decap_12
XFILLER_81_721 VGND VGND VPWR VPWR sky130_fd_sc_hd__decap_6
XTAP_TAPCELL_ROW_49_1113 VGND VPWR sky130_fd_sc_hd__tapvpwrvgnd_1
X_2177_ A_reg\[10\] _1428_ _1420_ VGND VGND VPWR VPWR _1434_ sky130_fd_sc_hd__a21oi_1
XFILLER_26_637 VGND VGND VPWR VPWR sky130_fd_sc_hd__decap_6
XFILLER_81_765 VPWR VGND VPWR VGND sky130_ef_sc_hd__decap_12
XFILLER_53_467 VGND VGND VPWR VPWR sky130_fd_sc_hd__fill_1
XFILLER_53_445 VGND VGND VPWR VPWR sky130_fd_sc_hd__fill_1
XFILLER_25_125 VPWR VGND VPWR VGND sky130_ef_sc_hd__decap_12
XFILLER_80_253 VPWR VGND VPWR VGND sky130_ef_sc_hd__decap_12
XFILLER_15_15 VPWR VGND VPWR VGND sky130_ef_sc_hd__decap_12
XFILLER_25_169 VPWR VGND VPWR VGND sky130_ef_sc_hd__decap_12
XFILLER_41_629 VPWR VGND VPWR VGND sky130_ef_sc_hd__decap_12
XTAP_TAPCELL_ROW_62_1324 VGND VPWR sky130_fd_sc_hd__tapvpwrvgnd_1
XFILLER_34_681 VPWR VGND VPWR VGND sky130_ef_sc_hd__decap_12
XFILLER_40_139 VGND VGND VPWR VPWR sky130_fd_sc_hd__fill_1
XFILLER_139_517 VPWR VGND VPWR VGND sky130_ef_sc_hd__decap_12
XFILLER_147_561 VPWR VGND VPWR VGND sky130_ef_sc_hd__decap_12
XFILLER_147_69 VPWR VGND VPWR VGND sky130_ef_sc_hd__decap_12
XFILLER_107_447 VGND VGND VPWR VPWR sky130_fd_sc_hd__fill_1
XFILLER_31_69 VPWR VGND VPWR VGND sky130_ef_sc_hd__decap_12
XFILLER_134_233 VPWR VGND VPWR VGND sky130_ef_sc_hd__decap_12
XFILLER_150_737 VPWR VGND VPWR VGND sky130_ef_sc_hd__decap_12
XFILLER_134_277 VPWR VGND VPWR VGND sky130_ef_sc_hd__decap_12
XFILLER_89_821 VPWR VGND VPWR VGND sky130_ef_sc_hd__decap_12
Xoutput47 net47 VGND VGND VPWR VPWR X_out[3] sky130_fd_sc_hd__buf_1
XFILLER_103_653 VPWR VGND VPWR VGND sky130_ef_sc_hd__decap_12
XFILLER_89_865 VPWR VGND VPWR VGND sky130_ef_sc_hd__decap_12
XFILLER_102_141 VPWR VGND VPWR VGND sky130_ef_sc_hd__decap_12
XTAP_TAPCELL_ROW_73_1497 VGND VPWR sky130_fd_sc_hd__tapvpwrvgnd_1
XFILLER_49_729 VGND VGND VPWR VPWR sky130_fd_sc_hd__decap_6
XFILLER_103_697 VPWR VGND VPWR VGND sky130_ef_sc_hd__decap_12
XFILLER_56_33 VGND VGND VPWR VPWR sky130_fd_sc_hd__fill_1
XFILLER_17_615 VGND VGND VPWR VPWR sky130_fd_sc_hd__fill_1
XFILLER_29_497 VGND VGND VPWR VPWR sky130_fd_sc_hd__decap_6
XFILLER_72_765 VPWR VGND VPWR VGND sky130_ef_sc_hd__decap_12
XANTENNA__1853__A1 A_reg\[10\] VGND VGND VPWR VPWR sky130_fd_sc_hd__diode_2
XFILLER_44_445 VPWR VGND VPWR VGND sky130_ef_sc_hd__decap_12
XFILLER_112_83 VGND VGND VPWR VPWR sky130_fd_sc_hd__fill_1
XFILLER_71_275 VGND VGND VPWR VPWR sky130_fd_sc_hd__decap_4
XFILLER_72_54 VPWR VGND VPWR VGND sky130_ef_sc_hd__decap_12
XFILLER_13_821 VPWR VGND VPWR VGND sky130_ef_sc_hd__decap_12
XFILLER_12_353 VGND VGND VPWR VPWR sky130_fd_sc_hd__decap_8
XFILLER_13_865 VPWR VGND VPWR VGND sky130_ef_sc_hd__decap_12
XTAP_TAPCELL_ROW_30_808 VGND VPWR sky130_fd_sc_hd__tapvpwrvgnd_1
XTAP_TAPCELL_ROW_30_819 VGND VPWR sky130_fd_sc_hd__tapvpwrvgnd_1
XFILLER_8_346 VGND VGND VPWR VPWR sky130_fd_sc_hd__fill_1
XFILLER_126_701 VPWR VGND VPWR VGND sky130_ef_sc_hd__decap_12
XFILLER_99_607 VGND VGND VPWR VPWR sky130_fd_sc_hd__decap_8
XTAP_TAPCELL_ROW_93_1818 VGND VPWR sky130_fd_sc_hd__tapvpwrvgnd_1
XFILLER_113_417 VPWR VGND VPWR VGND sky130_ef_sc_hd__decap_12
XFILLER_99_629 VPWR VGND VPWR VGND sky130_ef_sc_hd__decap_12
XFILLER_4_585 VGND VGND VPWR VPWR sky130_fd_sc_hd__decap_3
XFILLER_98_139 VGND VGND VPWR VPWR sky130_fd_sc_hd__fill_1
XFILLER_121_461 VPWR VGND VPWR VGND sky130_ef_sc_hd__decap_12
XFILLER_94_301 VGND VGND VPWR VPWR sky130_fd_sc_hd__decap_6
XFILLER_94_323 VGND VGND VPWR VPWR sky130_fd_sc_hd__fill_1
X_3080_ _0656_ _0659_ _0767_ VGND VGND VPWR VPWR _0768_ sky130_fd_sc_hd__a21oi_1
XFILLER_67_559 VGND VGND VPWR VPWR sky130_fd_sc_hd__fill_1
X_2100_ B_reg\[14\] _1176_ _1358_ VGND VGND VPWR VPWR _1359_ sky130_fd_sc_hd__o21ai_1
XFILLER_39_217 VGND VGND VPWR VPWR sky130_fd_sc_hd__decap_6
XTAP_TAPCELL_ROW_124_2317 VGND VPWR sky130_fd_sc_hd__tapvpwrvgnd_1
X_2031_ B_reg\[8\] _1290_ VGND VGND VPWR VPWR _1293_ sky130_fd_sc_hd__xnor2_1
XFILLER_54_209 VPWR VGND VPWR VGND sky130_ef_sc_hd__decap_12
XFILLER_63_721 VGND VGND VPWR VPWR sky130_fd_sc_hd__decap_6
XFILLER_47_261 VPWR VGND VPWR VGND sky130_ef_sc_hd__decap_12
XFILLER_63_754 VGND VGND VPWR VPWR sky130_fd_sc_hd__decap_6
XANTENNA__1844__A1 A_reg\[13\] VGND VGND VPWR VPWR sky130_fd_sc_hd__diode_2
XTAP_TAPCELL_ROW_18_621 VGND VPWR sky130_fd_sc_hd__tapvpwrvgnd_1
XFILLER_23_629 VPWR VGND VPWR VGND sky130_ef_sc_hd__decap_12
X_2933_ u_crt.r1\[1\] u_crt.r1\[0\] u_crt.r1\[2\] VGND VGND VPWR VPWR _0621_ sky130_fd_sc_hd__or3b_1
XFILLER_16_681 VPWR VGND VPWR VGND sky130_ef_sc_hd__decap_12
XFILLER_22_139 VGND VGND VPWR VPWR sky130_fd_sc_hd__fill_1
XTAP_TAPCELL_ROW_44_1032 VGND VPWR sky130_fd_sc_hd__tapvpwrvgnd_1
XTAP_TAPCELL_ROW_102_1969 VGND VPWR sky130_fd_sc_hd__tapvpwrvgnd_1
XTAP_TAPCELL_ROW_102_1958 VGND VPWR sky130_fd_sc_hd__tapvpwrvgnd_1
XANTENNA__2822__S _0553_ VGND VGND VPWR VPWR sky130_fd_sc_hd__diode_2
XFILLER_50_459 VPWR VGND VPWR VGND sky130_ef_sc_hd__decap_12
XTAP_TAPCELL_ROW_44_1043 VGND VPWR sky130_fd_sc_hd__tapvpwrvgnd_1
XTAP_TAPCELL_ROW_139_2560 VGND VPWR sky130_fd_sc_hd__tapvpwrvgnd_1
XANTENNA__3235__RESET_B net36 VGND VGND VPWR VPWR sky130_fd_sc_hd__diode_2
X_2864_ net22 B_reg\[14\] _0383_ VGND VGND VPWR VPWR _0087_ sky130_fd_sc_hd__mux2_1
XFILLER_31_673 VPWR VGND VPWR VGND sky130_ef_sc_hd__decap_12
XFILLER_129_561 VPWR VGND VPWR VGND sky130_ef_sc_hd__decap_12
X_2795_ _0391_ _0534_ VGND VGND VPWR VPWR _0535_ sky130_fd_sc_hd__and2_1
X_1815_ _1079_ _1084_ VGND VGND VPWR VPWR _1088_ sky130_fd_sc_hd__xnor2_1
XTAP_TAPCELL_ROW_152_2760 VGND VPWR sky130_fd_sc_hd__tapvpwrvgnd_1
XFILLER_144_531 VGND VGND VPWR VPWR sky130_fd_sc_hd__fill_1
X_1746_ _1015_ _1016_ _1018_ VGND VGND VPWR VPWR _1019_ sky130_fd_sc_hd__a21o_1
XTAP_TAPCELL_ROW_152_2771 VGND VPWR sky130_fd_sc_hd__tapvpwrvgnd_1
XFILLER_116_233 VPWR VGND VPWR VGND sky130_ef_sc_hd__decap_12
XFILLER_7_93 VPWR VGND VPWR VGND sky130_ef_sc_hd__decap_12
XFILLER_132_737 VPWR VGND VPWR VGND sky130_ef_sc_hd__decap_12
XFILLER_117_39 VPWR VGND VPWR VGND sky130_ef_sc_hd__decap_12
XFILLER_116_277 VPWR VGND VPWR VGND sky130_ef_sc_hd__decap_12
X_1677_ A_reg\[8\] _0950_ VGND VGND VPWR VPWR _0953_ sky130_fd_sc_hd__xnor2_2
XFILLER_131_225 VPWR VGND VPWR VGND sky130_ef_sc_hd__decap_12
XFILLER_100_601 VPWR VGND VPWR VGND sky130_ef_sc_hd__decap_12
XFILLER_97_161 VGND VGND VPWR VPWR sky130_fd_sc_hd__decap_6
XFILLER_86_813 VPWR VGND VPWR VGND sky130_ef_sc_hd__decap_12
XFILLER_140_781 VPWR VGND VPWR VGND sky130_ef_sc_hd__decap_12
XFILLER_133_27 VPWR VGND VPWR VGND sky130_ef_sc_hd__decap_12
XFILLER_100_645 VPWR VGND VPWR VGND sky130_ef_sc_hd__decap_12
XFILLER_97_194 VGND VGND VPWR VPWR sky130_fd_sc_hd__fill_2
XFILLER_85_334 VGND VGND VPWR VPWR sky130_fd_sc_hd__fill_2
X_3278_ clknet_3_0__leaf_clk _0061_ net36 VGND VGND VPWR VPWR A_reg\[4\] sky130_fd_sc_hd__dfrtp_4
XFILLER_66_581 VGND VGND VPWR VPWR sky130_fd_sc_hd__decap_6
XFILLER_54_721 VGND VGND VPWR VPWR sky130_fd_sc_hd__fill_1
X_2229_ _1481_ _1483_ _1485_ VGND VGND VPWR VPWR _1486_ sky130_fd_sc_hd__a21o_1
XFILLER_38_261 VGND VGND VPWR VPWR sky130_fd_sc_hd__fill_2
XFILLER_26_445 VPWR VGND VPWR VGND sky130_ef_sc_hd__decap_12
XANTENNA__1835__A1 A_reg\[0\] VGND VGND VPWR VPWR sky130_fd_sc_hd__diode_2
XTAP_TAPCELL_ROW_37_930 VGND VPWR sky130_fd_sc_hd__tapvpwrvgnd_1
XFILLER_42_905 VGND VGND VPWR VPWR sky130_fd_sc_hd__fill_2
XFILLER_81_573 VPWR VGND VPWR VGND sky130_ef_sc_hd__decap_12
XFILLER_53_242 VGND VGND VPWR VPWR sky130_fd_sc_hd__fill_1
XFILLER_26_489 VPWR VGND VPWR VGND sky130_ef_sc_hd__decap_12
XFILLER_10_813 VPWR VGND VPWR VGND sky130_ef_sc_hd__decap_12
XFILLER_21_161 VGND VGND VPWR VPWR sky130_fd_sc_hd__decap_6
XFILLER_108_701 VPWR VGND VPWR VGND sky130_ef_sc_hd__decap_12
XFILLER_148_881 VPWR VGND VPWR VGND sky130_ef_sc_hd__decap_12
XFILLER_5_316 VGND VGND VPWR VPWR sky130_fd_sc_hd__fill_1
XFILLER_147_391 VGND VGND VPWR VPWR sky130_fd_sc_hd__fill_1
XFILLER_135_553 VGND VGND VPWR VPWR sky130_fd_sc_hd__decap_6
XTAP_TAPCELL_ROW_75_1526 VGND VPWR sky130_fd_sc_hd__tapvpwrvgnd_1
XFILLER_150_501 VPWR VGND VPWR VGND sky130_ef_sc_hd__decap_12
XFILLER_135_597 VPWR VGND VPWR VGND sky130_ef_sc_hd__decap_12
XFILLER_101_3 VPWR VGND VPWR VGND sky130_ef_sc_hd__decap_12
XTAP_TAPCELL_ROW_75_1537 VGND VPWR sky130_fd_sc_hd__tapvpwrvgnd_1
XPHY_EDGE_ROW_2_Left_156 VGND VGND VPWR VPWR sky130_fd_sc_hd__decap_3
XFILLER_150_545 VPWR VGND VPWR VGND sky130_ef_sc_hd__decap_12
XFILLER_150_589 VPWR VGND VPWR VGND sky130_ef_sc_hd__decap_12
XFILLER_103_461 VPWR VGND VPWR VGND sky130_ef_sc_hd__decap_12
XFILLER_89_673 VPWR VGND VPWR VGND sky130_ef_sc_hd__decap_12
XFILLER_92_805 VGND VGND VPWR VPWR sky130_fd_sc_hd__decap_6
XFILLER_67_87 VPWR VGND VPWR VGND sky130_ef_sc_hd__decap_12
XANTENNA_input21_A B_in[13] VGND VGND VPWR VPWR sky130_fd_sc_hd__diode_2
XFILLER_49_559 VGND VGND VPWR VPWR sky130_fd_sc_hd__fill_1
XTAP_TAPCELL_ROW_106_2025 VGND VPWR sky130_fd_sc_hd__tapvpwrvgnd_1
XFILLER_92_849 VPWR VGND VPWR VGND sky130_ef_sc_hd__decap_12
XFILLER_76_389 VPWR VGND VPWR VGND sky130_ef_sc_hd__decap_12
XTAP_TAPCELL_ROW_4_393 VGND VPWR sky130_fd_sc_hd__tapvpwrvgnd_1
XFILLER_36_209 VGND VGND VPWR VPWR sky130_fd_sc_hd__decap_6
XFILLER_123_93 VPWR VGND VPWR VGND sky130_ef_sc_hd__decap_12
XFILLER_91_337 VGND VGND VPWR VPWR sky130_fd_sc_hd__decap_8
XFILLER_83_53 VGND VGND VPWR VPWR sky130_fd_sc_hd__decap_3
XFILLER_33_905 VGND VGND VPWR VPWR sky130_fd_sc_hd__decap_3
XFILLER_60_713 VPWR VGND VPWR VGND sky130_ef_sc_hd__decap_12
XFILLER_44_253 VPWR VGND VPWR VGND sky130_ef_sc_hd__decap_12
XFILLER_45_765 VGND VGND VPWR VPWR sky130_fd_sc_hd__decap_4
XFILLER_60_757 VPWR VGND VPWR VGND sky130_ef_sc_hd__decap_12
XANTENNA__2642__S _0383_ VGND VGND VPWR VPWR sky130_fd_sc_hd__diode_2
XFILLER_8_121 VPWR VGND VPWR VGND sky130_ef_sc_hd__decap_12
XFILLER_13_673 VPWR VGND VPWR VGND sky130_ef_sc_hd__decap_12
XFILLER_145_317 VPWR VGND VPWR VGND sky130_ef_sc_hd__decap_12
XFILLER_8_165 VPWR VGND VPWR VGND sky130_ef_sc_hd__decap_12
XFILLER_126_531 VGND VGND VPWR VPWR sky130_fd_sc_hd__fill_1
XTAP_TAPCELL_ROW_117_2198 VGND VPWR sky130_fd_sc_hd__tapvpwrvgnd_1
X_2580_ _0307_ _0313_ _0317_ VGND VGND VPWR VPWR _0325_ sky130_fd_sc_hd__and3_1
XANTENNA__2554__A2 _0910_ VGND VGND VPWR VPWR sky130_fd_sc_hd__diode_2
XFILLER_153_361 VGND VGND VPWR VPWR sky130_fd_sc_hd__decap_3
XFILLER_114_737 VPWR VGND VPWR VGND sky130_ef_sc_hd__decap_12
XFILLER_113_225 VPWR VGND VPWR VGND sky130_ef_sc_hd__decap_12
XFILLER_68_813 VPWR VGND VPWR VGND sky130_ef_sc_hd__decap_12
X_3201_ X_crt\[9\] _0912_ VGND VGND VPWR VPWR _0880_ sky130_fd_sc_hd__nand2_1
XFILLER_122_781 VPWR VGND VPWR VGND sky130_ef_sc_hd__decap_12
XFILLER_95_610 VGND VGND VPWR VPWR sky130_fd_sc_hd__decap_6
XFILLER_67_334 VGND VGND VPWR VPWR sky130_fd_sc_hd__fill_2
X_3132_ _0782_ _0819_ VGND VGND VPWR VPWR _0820_ sky130_fd_sc_hd__xnor2_1
XFILLER_95_665 VGND VGND VPWR VPWR sky130_fd_sc_hd__decap_6
X_3063_ _0749_ _0750_ VGND VGND VPWR VPWR _0751_ sky130_fd_sc_hd__or2_1
XFILLER_94_197 VPWR VGND VPWR VGND sky130_ef_sc_hd__decap_12
X_2014_ _1267_ _1268_ _1273_ B_reg\[10\] VGND VGND VPWR VPWR _1276_ sky130_fd_sc_hd__o2bb2ai_1
XFILLER_35_220 VGND VGND VPWR VPWR sky130_fd_sc_hd__decap_4
XFILLER_63_573 VPWR VGND VPWR VGND sky130_ef_sc_hd__decap_12
XFILLER_51_702 VPWR VGND VPWR VGND sky130_ef_sc_hd__decap_12
XFILLER_24_905 VGND VGND VPWR VPWR sky130_fd_sc_hd__decap_4
XFILLER_35_264 VPWR VGND VPWR VGND sky130_ef_sc_hd__decap_12
XFILLER_23_415 VPWR VGND VPWR VGND sky130_ef_sc_hd__decap_12
XFILLER_148_133 VGND VGND VPWR VPWR sky130_fd_sc_hd__decap_6
XTAP_TAPCELL_ROW_137_2519 VGND VPWR sky130_fd_sc_hd__tapvpwrvgnd_1
X_2916_ u_crt.r0\[0\] u_crt.r0\[1\] VGND VGND VPWR VPWR _0604_ sky130_fd_sc_hd__nand2b_4
XFILLER_50_289 VPWR VGND VPWR VGND sky130_ef_sc_hd__decap_12
XFILLER_10_109 VPWR VGND VPWR VGND sky130_ef_sc_hd__decap_12
X_2847_ net5 A_reg\[13\] _0383_ VGND VGND VPWR VPWR _0070_ sky130_fd_sc_hd__mux2_1
XFILLER_12_27 VGND VGND VPWR VPWR sky130_fd_sc_hd__fill_1
XFILLER_148_177 VPWR VGND VPWR VGND sky130_ef_sc_hd__decap_12
XFILLER_128_27 VGND VGND VPWR VPWR sky130_fd_sc_hd__fill_1
XFILLER_129_391 VGND VGND VPWR VPWR sky130_fd_sc_hd__fill_1
XFILLER_117_553 VGND VGND VPWR VPWR sky130_fd_sc_hd__decap_6
X_2778_ _0507_ _0499_ _0506_ VGND VGND VPWR VPWR _0518_ sky130_fd_sc_hd__mux2_1
XFILLER_3_809 VPWR VGND VPWR VGND sky130_ef_sc_hd__decap_12
XFILLER_145_895 VGND VGND VPWR VPWR sky130_fd_sc_hd__fill_1
XFILLER_132_501 VPWR VGND VPWR VGND sky130_ef_sc_hd__decap_12
XFILLER_117_597 VPWR VGND VPWR VGND sky130_ef_sc_hd__decap_12
XTAP_TAPCELL_ROW_57_1245 VGND VPWR sky130_fd_sc_hd__tapvpwrvgnd_1
X_1729_ _0996_ _1001_ Encode_EN VGND VGND VPWR VPWR _1004_ sky130_fd_sc_hd__o21a_1
XFILLER_144_15 VPWR VGND VPWR VGND sky130_ef_sc_hd__decap_12
XFILLER_132_545 VPWR VGND VPWR VGND sky130_ef_sc_hd__decap_12
XFILLER_132_589 VPWR VGND VPWR VGND sky130_ef_sc_hd__decap_12
XFILLER_77_109 VGND VGND VPWR VPWR sky130_fd_sc_hd__decap_3
XTAP_TAPCELL_ROW_70_1456 VGND VPWR sky130_fd_sc_hd__tapvpwrvgnd_1
XTAP_TAPCELL_ROW_70_1445 VGND VPWR sky130_fd_sc_hd__tapvpwrvgnd_1
XFILLER_74_849 VPWR VGND VPWR VGND sky130_ef_sc_hd__decap_12
XFILLER_58_389 VPWR VGND VPWR VGND sky130_ef_sc_hd__decap_12
XFILLER_18_209 VPWR VGND VPWR VGND sky130_ef_sc_hd__decap_12
XFILLER_27_721 VGND VGND VPWR VPWR sky130_fd_sc_hd__decap_6
XFILLER_37_57 VPWR VGND VPWR VGND sky130_ef_sc_hd__decap_12
XFILLER_73_337 VGND VGND VPWR VPWR sky130_fd_sc_hd__decap_3
XTAP_TAPCELL_ROW_1_341 VGND VPWR sky130_fd_sc_hd__tapvpwrvgnd_1
XTAP_TAPCELL_ROW_1_352 VGND VPWR sky130_fd_sc_hd__tapvpwrvgnd_1
XANTENNA__1808__A1 A_reg\[4\] VGND VGND VPWR VPWR sky130_fd_sc_hd__diode_2
XFILLER_26_253 VGND VGND VPWR VPWR sky130_fd_sc_hd__decap_8
XFILLER_27_765 VPWR VGND VPWR VGND sky130_ef_sc_hd__decap_12
XFILLER_42_713 VGND VGND VPWR VPWR sky130_fd_sc_hd__decap_8
XFILLER_82_893 VPWR VGND VPWR VGND sky130_ef_sc_hd__decap_12
XFILLER_26_297 VGND VGND VPWR VPWR sky130_fd_sc_hd__decap_8
XFILLER_149_3 VPWR VGND VPWR VGND sky130_ef_sc_hd__decap_12
XFILLER_41_234 VPWR VGND VPWR VGND sky130_ef_sc_hd__decap_12
XFILLER_42_757 VPWR VGND VPWR VGND sky130_ef_sc_hd__decap_12
XFILLER_139_111 VGND VGND VPWR VPWR sky130_fd_sc_hd__fill_1
XFILLER_41_278 VGND VGND VPWR VPWR sky130_fd_sc_hd__fill_2
XFILLER_10_643 VGND VGND VPWR VPWR sky130_fd_sc_hd__fill_1
XTAP_TAPCELL_ROW_40_969 VGND VPWR sky130_fd_sc_hd__tapvpwrvgnd_1
XFILLER_127_317 VPWR VGND VPWR VGND sky130_ef_sc_hd__decap_12
XFILLER_5_113 VPWR VGND VPWR VGND sky130_ef_sc_hd__decap_12
XFILLER_108_531 VGND VGND VPWR VPWR sky130_fd_sc_hd__fill_1
XFILLER_151_821 VPWR VGND VPWR VGND sky130_ef_sc_hd__decap_12
XFILLER_142_309 VPWR VGND VPWR VGND sky130_ef_sc_hd__decap_12
XFILLER_135_361 VPWR VGND VPWR VGND sky130_ef_sc_hd__decap_12
XANTENNA__2698__A a_r3\[0\] VGND VGND VPWR VPWR sky130_fd_sc_hd__diode_2
XFILLER_151_865 VPWR VGND VPWR VGND sky130_ef_sc_hd__decap_12
XFILLER_111_729 VPWR VGND VPWR VGND sky130_ef_sc_hd__decap_12
XFILLER_96_418 VGND VGND VPWR VPWR sky130_fd_sc_hd__fill_2
XTAP_TAPCELL_ROW_9_474 VGND VPWR sky130_fd_sc_hd__tapvpwrvgnd_1
XFILLER_104_781 VPWR VGND VPWR VGND sky130_ef_sc_hd__decap_12
XFILLER_1_385 VGND VGND VPWR VPWR sky130_fd_sc_hd__decap_6
XTAP_TAPCELL_ROW_88_1739 VGND VPWR sky130_fd_sc_hd__tapvpwrvgnd_1
XFILLER_77_698 VPWR VGND VPWR VGND sky130_ef_sc_hd__decap_12
XFILLER_76_153 VPWR VGND VPWR VGND sky130_ef_sc_hd__decap_12
XFILLER_49_389 VGND VGND VPWR VPWR sky130_fd_sc_hd__decap_3
XFILLER_37_529 VGND VGND VPWR VPWR sky130_fd_sc_hd__decap_8
XFILLER_94_85 VGND VGND VPWR VPWR sky130_fd_sc_hd__fill_1
XFILLER_92_657 VPWR VGND VPWR VGND sky130_ef_sc_hd__decap_12
XFILLER_76_197 VPWR VGND VPWR VGND sky130_ef_sc_hd__decap_12
XFILLER_91_156 VPWR VGND VPWR VGND sky130_ef_sc_hd__decap_12
XANTENNA__2472__A1 _0185_ VGND VGND VPWR VPWR sky130_fd_sc_hd__diode_2
XTAP_TAPCELL_ROW_28_782 VGND VPWR sky130_fd_sc_hd__tapvpwrvgnd_1
XFILLER_32_234 VPWR VGND VPWR VGND sky130_ef_sc_hd__decap_12
XFILLER_32_278 VGND VGND VPWR VPWR sky130_fd_sc_hd__decap_8
XTAP_TAPCELL_ROW_119_2238 VGND VPWR sky130_fd_sc_hd__tapvpwrvgnd_1
X_2701_ b_r3\[0\] a_r3\[3\] VGND VGND VPWR VPWR _0441_ sky130_fd_sc_hd__nand2_1
XFILLER_9_441 VGND VGND VPWR VPWR sky130_fd_sc_hd__decap_6
XFILLER_146_637 VGND VGND VPWR VPWR sky130_fd_sc_hd__decap_6
XFILLER_145_125 VPWR VGND VPWR VGND sky130_ef_sc_hd__decap_12
XPHY_EDGE_ROW_65_Left_219 VGND VGND VPWR VPWR sky130_fd_sc_hd__decap_3
XTAP_TAPCELL_ROW_132_2438 VGND VPWR sky130_fd_sc_hd__tapvpwrvgnd_1
X_2632_ _0371_ _0376_ VGND VGND VPWR VPWR _0377_ sky130_fd_sc_hd__or2_1
XFILLER_64_3 VPWR VGND VPWR VGND sky130_ef_sc_hd__decap_12
XFILLER_9_496 VGND VGND VPWR VPWR sky130_fd_sc_hd__decap_8
XFILLER_145_169 VPWR VGND VPWR VGND sky130_ef_sc_hd__decap_12
XTAP_TAPCELL_ROW_132_2449 VGND VPWR sky130_fd_sc_hd__tapvpwrvgnd_1
XFILLER_127_895 VGND VGND VPWR VPWR sky130_fd_sc_hd__fill_1
XFILLER_114_501 VPWR VGND VPWR VGND sky130_ef_sc_hd__decap_12
X_2563_ b_r2\[0\] a_r2\[2\] _0306_ VGND VGND VPWR VPWR _0308_ sky130_fd_sc_hd__and3_1
XFILLER_114_545 VPWR VGND VPWR VGND sky130_ef_sc_hd__decap_12
X_2494_ _0216_ _0223_ _0241_ VGND VGND VPWR VPWR _0242_ sky130_fd_sc_hd__a21o_1
XFILLER_114_589 VPWR VGND VPWR VGND sky130_ef_sc_hd__decap_12
XFILLER_101_217 VGND VGND VPWR VPWR sky130_fd_sc_hd__decap_6
XFILLER_4_83 VGND VGND VPWR VPWR sky130_fd_sc_hd__fill_1
XFILLER_114_29 VPWR VGND VPWR VGND sky130_ef_sc_hd__decap_12
XPHY_EDGE_ROW_74_Left_228 VGND VGND VPWR VPWR sky130_fd_sc_hd__decap_3
XTAP_TAPCELL_ROW_52_1164 VGND VPWR sky130_fd_sc_hd__tapvpwrvgnd_1
XTAP_TAPCELL_ROW_147_2681 VGND VPWR sky130_fd_sc_hd__tapvpwrvgnd_1
XFILLER_95_473 VPWR VGND VPWR VGND sky130_ef_sc_hd__decap_12
X_3115_ _0753_ _0802_ VGND VGND VPWR VPWR _0803_ sky130_fd_sc_hd__nand2_1
XFILLER_82_112 VPWR VGND VPWR VGND sky130_ef_sc_hd__decap_12
XFILLER_55_337 VPWR VGND VPWR VGND sky130_ef_sc_hd__decap_12
X_3046_ _0622_ _0722_ VGND VGND VPWR VPWR _0734_ sky130_fd_sc_hd__xor2_1
XFILLER_24_713 VPWR VGND VPWR VGND sky130_ef_sc_hd__decap_12
XFILLER_64_893 VPWR VGND VPWR VGND sky130_ef_sc_hd__decap_12
XFILLER_23_223 VGND VGND VPWR VPWR sky130_fd_sc_hd__fill_1
XANTENNA__3250__RESET_B net36 VGND VGND VPWR VPWR sky130_fd_sc_hd__diode_2
XFILLER_23_256 VPWR VGND VPWR VGND sky130_ef_sc_hd__decap_12
XFILLER_24_757 VPWR VGND VPWR VGND sky130_ef_sc_hd__decap_12
XFILLER_11_418 VPWR VGND VPWR VGND sky130_ef_sc_hd__decap_12
XFILLER_23_15 VPWR VGND VPWR VGND sky130_ef_sc_hd__decap_12
XFILLER_139_15 VPWR VGND VPWR VGND sky130_ef_sc_hd__decap_12
XPHY_EDGE_ROW_83_Left_237 VGND VGND VPWR VPWR sky130_fd_sc_hd__decap_3
XFILLER_149_497 VGND VGND VPWR VPWR sky130_fd_sc_hd__decap_6
XFILLER_137_615 VGND VGND VPWR VPWR sky130_fd_sc_hd__fill_1
XFILLER_109_317 VPWR VGND VPWR VGND sky130_ef_sc_hd__decap_12
XFILLER_133_821 VPWR VGND VPWR VGND sky130_ef_sc_hd__decap_12
XFILLER_124_309 VPWR VGND VPWR VGND sky130_ef_sc_hd__decap_12
XFILLER_117_361 VPWR VGND VPWR VGND sky130_ef_sc_hd__decap_12
XFILLER_3_617 VGND VGND VPWR VPWR sky130_fd_sc_hd__fill_2
XANTENNA__3191__A2 CRT_Start VGND VGND VPWR VPWR sky130_fd_sc_hd__diode_2
XFILLER_133_865 VPWR VGND VPWR VGND sky130_ef_sc_hd__decap_12
XPHY_EDGE_ROW_92_Left_246 VGND VGND VPWR VPWR sky130_fd_sc_hd__decap_3
XFILLER_59_632 VPWR VGND VPWR VGND sky130_ef_sc_hd__decap_12
XTAP_TAPCELL_ROW_6_433 VGND VPWR sky130_fd_sc_hd__tapvpwrvgnd_1
XTAP_TAPCELL_ROW_6_422 VGND VPWR sky130_fd_sc_hd__tapvpwrvgnd_1
XFILLER_58_153 VPWR VGND VPWR VGND sky130_ef_sc_hd__decap_12
XFILLER_19_529 VPWR VGND VPWR VGND sky130_ef_sc_hd__decap_12
XFILLER_74_657 VPWR VGND VPWR VGND sky130_ef_sc_hd__decap_12
XFILLER_58_197 VPWR VGND VPWR VGND sky130_ef_sc_hd__decap_12
XFILLER_27_573 VPWR VGND VPWR VGND sky130_ef_sc_hd__decap_12
XTAP_TAPCELL_ROW_83_1658 VGND VPWR sky130_fd_sc_hd__tapvpwrvgnd_1
XTAP_TAPCELL_ROW_25_730 VGND VPWR sky130_fd_sc_hd__tapvpwrvgnd_1
XFILLER_120_83 VGND VGND VPWR VPWR sky130_fd_sc_hd__fill_1
XFILLER_9_39 VPWR VGND VPWR VGND sky130_ef_sc_hd__decap_12
XFILLER_42_587 VGND VGND VPWR VPWR sky130_fd_sc_hd__fill_1
XFILLER_30_749 VGND VGND VPWR VPWR sky130_fd_sc_hd__decap_6
XFILLER_128_637 VGND VGND VPWR VPWR sky130_fd_sc_hd__decap_6
XFILLER_127_125 VPWR VGND VPWR VGND sky130_ef_sc_hd__decap_12
XFILLER_10_473 VGND VGND VPWR VPWR sky130_fd_sc_hd__decap_3
XFILLER_6_433 VPWR VGND VPWR VGND sky130_ef_sc_hd__decap_12
XFILLER_13_81 VPWR VGND VPWR VGND sky130_ef_sc_hd__decap_12
XFILLER_143_629 VPWR VGND VPWR VGND sky130_ef_sc_hd__decap_12
XFILLER_129_81 VPWR VGND VPWR VGND sky130_ef_sc_hd__decap_12
XFILLER_127_169 VPWR VGND VPWR VGND sky130_ef_sc_hd__decap_12
XTAP_TAPCELL_ROW_114_2157 VGND VPWR sky130_fd_sc_hd__tapvpwrvgnd_1
XFILLER_6_477 VPWR VGND VPWR VGND sky130_ef_sc_hd__decap_12
XFILLER_142_139 VGND VGND VPWR VPWR sky130_fd_sc_hd__fill_1
XFILLER_136_681 VPWR VGND VPWR VGND sky130_ef_sc_hd__decap_12
XFILLER_109_895 VGND VGND VPWR VPWR sky130_fd_sc_hd__fill_1
XFILLER_151_673 VPWR VGND VPWR VGND sky130_ef_sc_hd__decap_12
XFILLER_97_727 VGND VGND VPWR VPWR sky130_fd_sc_hd__fill_1
XFILLER_111_526 VPWR VGND VPWR VGND sky130_ef_sc_hd__decap_12
XANTENNA__3232__CLK clknet_3_3__leaf_clk VGND VGND VPWR VPWR sky130_fd_sc_hd__diode_2
XFILLER_1_193 VPWR VGND VPWR VGND sky130_ef_sc_hd__decap_12
XFILLER_38_805 VGND VGND VPWR VPWR sky130_fd_sc_hd__decap_6
XFILLER_77_473 VPWR VGND VPWR VGND sky130_ef_sc_hd__decap_12
XFILLER_37_304 VPWR VGND VPWR VGND sky130_ef_sc_hd__decap_12
XANTENNA__2693__B2 _0185_ VGND VGND VPWR VPWR sky130_fd_sc_hd__diode_2
XANTENNA__2693__A1 _0187_ VGND VGND VPWR VPWR sky130_fd_sc_hd__diode_2
XFILLER_92_421 VPWR VGND VPWR VGND sky130_ef_sc_hd__decap_12
XFILLER_37_337 VGND VGND VPWR VPWR sky130_fd_sc_hd__decap_8
XFILLER_52_318 VPWR VGND VPWR VGND sky130_ef_sc_hd__decap_12
XFILLER_61_841 VGND VGND VPWR VPWR sky130_fd_sc_hd__decap_8
XANTENNA__1653__C1 A_reg\[11\] VGND VGND VPWR VPWR sky130_fd_sc_hd__diode_2
XFILLER_21_727 VGND VGND VPWR VPWR sky130_fd_sc_hd__fill_1
X_1994_ B_reg\[13\] _1167_ B_reg\[14\] VGND VGND VPWR VPWR _1256_ sky130_fd_sc_hd__o21ai_1
XFILLER_146_401 VPWR VGND VPWR VGND sky130_ef_sc_hd__decap_12
XFILLER_119_615 VGND VGND VPWR VPWR sky130_fd_sc_hd__fill_1
XFILLER_146_445 VPWR VGND VPWR VGND sky130_ef_sc_hd__decap_12
XFILLER_9_293 VPWR VGND VPWR VGND sky130_ef_sc_hd__decap_12
XANTENNA__2830__S _0553_ VGND VGND VPWR VPWR sky130_fd_sc_hd__diode_2
XFILLER_146_489 VPWR VGND VPWR VGND sky130_ef_sc_hd__decap_12
XFILLER_106_309 VPWR VGND VPWR VGND sky130_ef_sc_hd__decap_12
X_2615_ _0318_ _0333_ _0334_ _0341_ _0307_ VGND VGND VPWR VPWR _0360_ sky130_fd_sc_hd__a32o_1
XFILLER_115_821 VPWR VGND VPWR VGND sky130_ef_sc_hd__decap_12
XTAP_TAPCELL_ROW_149_2710 VGND VPWR sky130_fd_sc_hd__tapvpwrvgnd_1
XFILLER_130_813 VPWR VGND VPWR VGND sky130_ef_sc_hd__decap_12
XFILLER_115_865 VPWR VGND VPWR VGND sky130_ef_sc_hd__decap_12
X_2546_ _0220_ _0293_ VGND VGND VPWR VPWR _0294_ sky130_fd_sc_hd__or2_1
XTAP_TAPCELL_ROW_149_2721 VGND VPWR sky130_fd_sc_hd__tapvpwrvgnd_1
XFILLER_141_161 VGND VGND VPWR VPWR sky130_fd_sc_hd__decap_6
XFILLER_125_39 VPWR VGND VPWR VGND sky130_ef_sc_hd__decap_12
XFILLER_88_749 VGND VGND VPWR VPWR sky130_fd_sc_hd__decap_6
XFILLER_87_215 VGND VGND VPWR VPWR sky130_fd_sc_hd__decap_8
X_2477_ b_r1\[0\] a_r1\[1\] b_r1\[1\] a_r1\[0\] VGND VGND VPWR VPWR _0225_ sky130_fd_sc_hd__a22o_1
XFILLER_68_451 VPWR VGND VPWR VGND sky130_ef_sc_hd__decap_12
XFILLER_18_15 VPWR VGND VPWR VGND sky130_ef_sc_hd__decap_12
XFILLER_141_27 VPWR VGND VPWR VGND sky130_ef_sc_hd__decap_12
XFILLER_110_581 VGND VGND VPWR VPWR sky130_fd_sc_hd__decap_6
XFILLER_96_793 VPWR VGND VPWR VGND sky130_ef_sc_hd__decap_12
XFILLER_95_281 VPWR VGND VPWR VGND sky130_ef_sc_hd__decap_12
XFILLER_56_657 VPWR VGND VPWR VGND sky130_ef_sc_hd__decap_12
XFILLER_55_167 VGND VGND VPWR VPWR sky130_fd_sc_hd__fill_1
XFILLER_28_359 VGND VGND VPWR VPWR sky130_fd_sc_hd__decap_4
XFILLER_83_498 VGND VGND VPWR VPWR sky130_fd_sc_hd__decap_6
XFILLER_71_649 VPWR VGND VPWR VGND sky130_ef_sc_hd__decap_12
X_3029_ _0688_ _0692_ VGND VGND VPWR VPWR _0717_ sky130_fd_sc_hd__xnor2_1
XFILLER_70_148 VPWR VGND VPWR VGND sky130_ef_sc_hd__decap_12
XTAP_TAPCELL_ROW_65_1377 VGND VPWR sky130_fd_sc_hd__tapvpwrvgnd_1
XTAP_TAPCELL_ROW_65_1366 VGND VPWR sky130_fd_sc_hd__tapvpwrvgnd_1
XFILLER_24_587 VGND VGND VPWR VPWR sky130_fd_sc_hd__fill_1
XFILLER_11_237 VPWR VGND VPWR VGND sky130_ef_sc_hd__decap_12
XFILLER_12_749 VGND VGND VPWR VPWR sky130_fd_sc_hd__decap_6
XFILLER_149_261 VPWR VGND VPWR VGND sky130_ef_sc_hd__decap_12
Xclkload2 clknet_3_2__leaf_clk VGND VGND VPWR VPWR clkload2/Y sky130_fd_sc_hd__inv_8
XFILLER_109_125 VPWR VGND VPWR VGND sky130_ef_sc_hd__decap_12
XFILLER_20_793 VPWR VGND VPWR VGND sky130_ef_sc_hd__decap_12
XFILLER_125_629 VPWR VGND VPWR VGND sky130_ef_sc_hd__decap_12
XFILLER_109_169 VPWR VGND VPWR VGND sky130_ef_sc_hd__decap_12
XFILLER_124_139 VGND VGND VPWR VPWR sky130_fd_sc_hd__fill_1
XFILLER_118_681 VPWR VGND VPWR VGND sky130_ef_sc_hd__decap_12
XANTENNA__3255__CLK clknet_3_6__leaf_clk VGND VGND VPWR VPWR sky130_fd_sc_hd__diode_2
XFILLER_59_22 VPWR VGND VPWR VGND sky130_ef_sc_hd__decap_12
XFILLER_133_673 VPWR VGND VPWR VGND sky130_ef_sc_hd__decap_12
XFILLER_120_301 VGND VGND VPWR VPWR sky130_fd_sc_hd__decap_6
XFILLER_79_727 VGND VGND VPWR VPWR sky130_fd_sc_hd__fill_1
XFILLER_120_345 VPWR VGND VPWR VGND sky130_ef_sc_hd__decap_12
XFILLER_120_389 VPWR VGND VPWR VGND sky130_ef_sc_hd__decap_12
XFILLER_59_473 VPWR VGND VPWR VGND sky130_ef_sc_hd__decap_12
XANTENNA__2675__B2 a_r3\[0\] VGND VGND VPWR VPWR sky130_fd_sc_hd__diode_2
XFILLER_75_54 VGND VGND VPWR VPWR sky130_fd_sc_hd__fill_2
XFILLER_74_421 VPWR VGND VPWR VGND sky130_ef_sc_hd__decap_12
XFILLER_19_337 VPWR VGND VPWR VGND sky130_ef_sc_hd__decap_12
XFILLER_62_627 VPWR VGND VPWR VGND sky130_ef_sc_hd__decap_12
XFILLER_28_893 VPWR VGND VPWR VGND sky130_ef_sc_hd__decap_12
XFILLER_46_189 VGND VGND VPWR VPWR sky130_fd_sc_hd__decap_6
XPHY_EDGE_ROW_141_Right_141 VGND VGND VPWR VPWR sky130_fd_sc_hd__decap_3
XFILLER_131_93 VPWR VGND VPWR VGND sky130_ef_sc_hd__decap_12
XFILLER_91_31 VPWR VGND VPWR VGND sky130_ef_sc_hd__decap_12
XFILLER_27_381 VGND VGND VPWR VPWR sky130_fd_sc_hd__fill_2
XANTENNA_clkbuf_3_4__f_clk_A clknet_0_clk VGND VGND VPWR VPWR sky130_fd_sc_hd__diode_2
XFILLER_43_841 VPWR VGND VPWR VGND sky130_ef_sc_hd__decap_12
XFILLER_30_513 VPWR VGND VPWR VGND sky130_ef_sc_hd__decap_12
XFILLER_70_693 VGND VGND VPWR VPWR sky130_fd_sc_hd__decap_6
XFILLER_128_401 VPWR VGND VPWR VGND sky130_ef_sc_hd__decap_12
XFILLER_144_905 VGND VGND VPWR VPWR sky130_fd_sc_hd__decap_4
XFILLER_128_445 VPWR VGND VPWR VGND sky130_ef_sc_hd__decap_12
XFILLER_128_489 VPWR VGND VPWR VGND sky130_ef_sc_hd__decap_12
XFILLER_7_753 VPWR VGND VPWR VGND sky130_ef_sc_hd__decap_12
X_2400_ _0148_ _0153_ _0150_ VGND VGND VPWR VPWR _0154_ sky130_fd_sc_hd__o21ai_1
XFILLER_7_797 VPWR VGND VPWR VGND sky130_ef_sc_hd__decap_12
XFILLER_6_285 VGND VGND VPWR VPWR sky130_fd_sc_hd__fill_1
XFILLER_130_109 VPWR VGND VPWR VGND sky130_ef_sc_hd__decap_12
XFILLER_123_161 VGND VGND VPWR VPWR sky130_fd_sc_hd__decap_6
XFILLER_112_813 VPWR VGND VPWR VGND sky130_ef_sc_hd__decap_12
XFILLER_97_513 VGND VGND VPWR VPWR sky130_fd_sc_hd__fill_1
X_2331_ _1573_ _1580_ VGND VGND VPWR VPWR _1584_ sky130_fd_sc_hd__xnor2_1
X_2262_ _1513_ _1516_ _1518_ VGND VGND VPWR VPWR _1519_ sky130_fd_sc_hd__a21o_1
XFILLER_27_3 VPWR VGND VPWR VGND sky130_ef_sc_hd__decap_12
XFILLER_38_613 VPWR VGND VPWR VGND sky130_ef_sc_hd__decap_12
XTAP_TAPCELL_ROW_144_2640 VGND VPWR sky130_fd_sc_hd__tapvpwrvgnd_1
XTAP_TAPCELL_ROW_127_2359 VGND VPWR sky130_fd_sc_hd__tapvpwrvgnd_1
XFILLER_93_741 VPWR VGND VPWR VGND sky130_ef_sc_hd__decap_12
XFILLER_78_793 VPWR VGND VPWR VGND sky130_ef_sc_hd__decap_12
XFILLER_77_281 VGND VGND VPWR VPWR sky130_fd_sc_hd__fill_2
X_2193_ _1432_ _1435_ _1439_ _1449_ VGND VGND VPWR VPWR _1450_ sky130_fd_sc_hd__a31o_1
XPHY_EDGE_ROW_148_Left_302 VGND VGND VPWR VPWR sky130_fd_sc_hd__decap_3
XFILLER_92_251 VGND VGND VPWR VPWR sky130_fd_sc_hd__fill_1
XFILLER_1_51 VGND VGND VPWR VPWR sky130_fd_sc_hd__decap_4
XFILLER_38_657 VPWR VGND VPWR VGND sky130_ef_sc_hd__decap_12
XFILLER_93_785 VPWR VGND VPWR VGND sky130_ef_sc_hd__decap_12
XFILLER_65_476 VGND VGND VPWR VPWR sky130_fd_sc_hd__fill_2
XFILLER_53_649 VGND VGND VPWR VPWR sky130_fd_sc_hd__fill_1
XFILLER_52_104 VGND VGND VPWR VPWR sky130_fd_sc_hd__fill_1
XANTENNA__2825__S _0553_ VGND VGND VPWR VPWR sky130_fd_sc_hd__diode_2
XFILLER_37_167 VGND VGND VPWR VPWR sky130_fd_sc_hd__fill_1
XFILLER_80_479 VGND VGND VPWR VPWR sky130_fd_sc_hd__decap_8
XFILLER_61_671 VGND VGND VPWR VPWR sky130_fd_sc_hd__fill_1
XTAP_TAPCELL_ROW_47_1085 VGND VPWR sky130_fd_sc_hd__tapvpwrvgnd_1
XTAP_TAPCELL_ROW_16_582 VGND VPWR sky130_fd_sc_hd__tapvpwrvgnd_1
XTAP_TAPCELL_ROW_16_593 VGND VPWR sky130_fd_sc_hd__tapvpwrvgnd_1
XFILLER_147_721 VGND VGND VPWR VPWR sky130_fd_sc_hd__decap_6
XFILLER_138_209 VPWR VGND VPWR VGND sky130_ef_sc_hd__decap_12
X_1977_ _1229_ _1241_ VGND VGND VPWR VPWR _1242_ sky130_fd_sc_hd__xnor2_1
XTAP_TAPCELL_ROW_60_1285 VGND VPWR sky130_fd_sc_hd__tapvpwrvgnd_1
XANTENNA__3278__CLK clknet_3_0__leaf_clk VGND VGND VPWR VPWR sky130_fd_sc_hd__diode_2
XFILLER_147_765 VPWR VGND VPWR VGND sky130_ef_sc_hd__decap_12
XFILLER_146_253 VPWR VGND VPWR VGND sky130_ef_sc_hd__decap_12
XFILLER_107_629 VPWR VGND VPWR VGND sky130_ef_sc_hd__decap_12
XTAP_TAPCELL_ROW_60_1296 VGND VPWR sky130_fd_sc_hd__tapvpwrvgnd_1
XFILLER_106_139 VGND VGND VPWR VPWR sky130_fd_sc_hd__fill_1
XFILLER_20_27 VGND VGND VPWR VPWR sky130_fd_sc_hd__fill_1
XFILLER_136_27 VGND VGND VPWR VPWR sky130_fd_sc_hd__fill_1
XFILLER_115_673 VPWR VGND VPWR VGND sky130_ef_sc_hd__decap_12
XFILLER_102_301 VGND VGND VPWR VPWR sky130_fd_sc_hd__decap_6
XFILLER_88_513 VPWR VGND VPWR VGND sky130_ef_sc_hd__decap_12
XFILLER_0_417 VGND VGND VPWR VPWR sky130_fd_sc_hd__decap_3
X_2529_ _0275_ _0276_ VGND VGND VPWR VPWR _0277_ sky130_fd_sc_hd__or2_1
XFILLER_130_643 VGND VGND VPWR VPWR sky130_fd_sc_hd__fill_1
XFILLER_102_345 VPWR VGND VPWR VGND sky130_ef_sc_hd__decap_12
XFILLER_152_15 VPWR VGND VPWR VGND sky130_ef_sc_hd__decap_12
XFILLER_88_579 VGND VGND VPWR VPWR sky130_fd_sc_hd__decap_8
XFILLER_29_69 VPWR VGND VPWR VGND sky130_ef_sc_hd__decap_12
XTAP_TAPCELL_ROW_67_1406 VGND VPWR sky130_fd_sc_hd__tapvpwrvgnd_1
XFILLER_83_273 VGND VGND VPWR VPWR sky130_fd_sc_hd__decap_6
XFILLER_71_424 VGND VGND VPWR VPWR sky130_fd_sc_hd__fill_1
XFILLER_71_413 VGND VGND VPWR VPWR sky130_fd_sc_hd__fill_1
XFILLER_28_189 VGND VGND VPWR VPWR sky130_fd_sc_hd__decap_6
XFILLER_71_457 VGND VGND VPWR VPWR sky130_fd_sc_hd__fill_2
XFILLER_25_841 VPWR VGND VPWR VGND sky130_ef_sc_hd__decap_12
XFILLER_43_137 VPWR VGND VPWR VGND sky130_ef_sc_hd__decap_12
XFILLER_45_57 VPWR VGND VPWR VGND sky130_ef_sc_hd__decap_12
XTAP_TAPCELL_ROW_80_1617 VGND VPWR sky130_fd_sc_hd__tapvpwrvgnd_1
XTAP_TAPCELL_ROW_80_1606 VGND VPWR sky130_fd_sc_hd__tapvpwrvgnd_1
XFILLER_51_181 VPWR VGND VPWR VGND sky130_ef_sc_hd__decap_12
XFILLER_12_513 VPWR VGND VPWR VGND sky130_ef_sc_hd__decap_12
XTAP_TAPCELL_ROW_35_891 VGND VPWR sky130_fd_sc_hd__tapvpwrvgnd_1
XFILLER_131_3 VPWR VGND VPWR VGND sky130_ef_sc_hd__decap_12
XFILLER_12_557 VGND VGND VPWR VPWR sky130_fd_sc_hd__decap_8
XFILLER_40_866 VGND VGND VPWR VPWR sky130_fd_sc_hd__fill_2
XFILLER_40_877 VGND VGND VPWR VPWR sky130_fd_sc_hd__decap_3
XFILLER_153_713 VPWR VGND VPWR VGND sky130_ef_sc_hd__decap_12
XFILLER_126_905 VGND VGND VPWR VPWR sky130_fd_sc_hd__decap_4
XFILLER_6_29 VPWR VGND VPWR VGND sky130_ef_sc_hd__decap_12
XFILLER_4_701 VPWR VGND VPWR VGND sky130_ef_sc_hd__decap_12
XFILLER_153_757 VPWR VGND VPWR VGND sky130_ef_sc_hd__decap_12
XTAP_TAPCELL_ROW_111_2105 VGND VPWR sky130_fd_sc_hd__tapvpwrvgnd_1
XTAP_TAPCELL_ROW_78_1579 VGND VPWR sky130_fd_sc_hd__tapvpwrvgnd_1
XFILLER_152_245 VGND VGND VPWR VPWR sky130_fd_sc_hd__decap_6
XFILLER_3_233 VGND VGND VPWR VPWR sky130_fd_sc_hd__decap_3
XFILLER_152_289 VPWR VGND VPWR VGND sky130_ef_sc_hd__decap_12
XFILLER_112_109 VPWR VGND VPWR VGND sky130_ef_sc_hd__decap_12
XFILLER_105_161 VGND VGND VPWR VPWR sky130_fd_sc_hd__decap_6
XFILLER_121_665 VGND VGND VPWR VPWR sky130_fd_sc_hd__decap_6
XFILLER_120_153 VPWR VGND VPWR VGND sky130_ef_sc_hd__decap_12
XFILLER_86_53 VPWR VGND VPWR VGND sky130_ef_sc_hd__decap_12
XFILLER_120_197 VPWR VGND VPWR VGND sky130_ef_sc_hd__decap_12
XFILLER_75_741 VGND VGND VPWR VPWR sky130_fd_sc_hd__fill_1
XTAP_TAPCELL_ROW_109_2078 VGND VPWR sky130_fd_sc_hd__tapvpwrvgnd_1
XFILLER_75_785 VPWR VGND VPWR VGND sky130_ef_sc_hd__decap_12
XFILLER_74_251 VGND VGND VPWR VPWR sky130_fd_sc_hd__fill_1
XFILLER_19_167 VGND VGND VPWR VPWR sky130_fd_sc_hd__fill_1
XFILLER_90_755 VGND VGND VPWR VPWR sky130_fd_sc_hd__fill_1
XTAP_TAPCELL_ROW_122_2289 VGND VPWR sky130_fd_sc_hd__tapvpwrvgnd_1
XTAP_TAPCELL_ROW_122_2278 VGND VPWR sky130_fd_sc_hd__tapvpwrvgnd_1
XFILLER_62_468 VGND VGND VPWR VPWR sky130_fd_sc_hd__fill_1
X_2880_ u_crt.r3\[3\] u_crt.r3\[2\] u_crt.r3\[0\] VGND VGND VPWR VPWR _0568_ sky130_fd_sc_hd__and3_1
XFILLER_15_373 VGND VGND VPWR VPWR sky130_fd_sc_hd__decap_8
X_1900_ CU_state_dbg\[1\] _1163_ VGND VGND VPWR VPWR _1166_ sky130_fd_sc_hd__nand2_1
XFILLER_129_721 VGND VGND VPWR VPWR sky130_fd_sc_hd__decap_6
XTAP_TAPCELL_ROW_13_541 VGND VPWR sky130_fd_sc_hd__tapvpwrvgnd_1
X_1831_ _1102_ _1103_ VGND VGND VPWR VPWR _1104_ sky130_fd_sc_hd__and2b_1
XFILLER_30_365 VGND VGND VPWR VPWR sky130_fd_sc_hd__decap_6
XFILLER_144_713 VPWR VGND VPWR VGND sky130_ef_sc_hd__decap_12
XFILLER_129_765 VPWR VGND VPWR VGND sky130_ef_sc_hd__decap_12
XFILLER_128_253 VPWR VGND VPWR VGND sky130_ef_sc_hd__decap_12
X_1762_ _0889_ _1021_ _1022_ VGND VGND VPWR VPWR _1035_ sky130_fd_sc_hd__a21oi_1
XFILLER_143_223 VGND VGND VPWR VPWR sky130_fd_sc_hd__fill_1
XFILLER_7_561 VGND VGND VPWR VPWR sky130_fd_sc_hd__decap_8
X_1693_ _0966_ _0967_ _0894_ VGND VGND VPWR VPWR _0969_ sky130_fd_sc_hd__a21oi_1
XFILLER_144_757 VPWR VGND VPWR VGND sky130_ef_sc_hd__decap_12
XFILLER_131_429 VPWR VGND VPWR VGND sky130_ef_sc_hd__decap_12
XFILLER_98_811 VGND VGND VPWR VPWR sky130_fd_sc_hd__fill_1
XFILLER_112_643 VGND VGND VPWR VPWR sky130_fd_sc_hd__fill_1
XFILLER_97_321 VPWR VGND VPWR VGND sky130_ef_sc_hd__decap_12
XFILLER_58_708 VPWR VGND VPWR VGND sky130_ef_sc_hd__decap_12
XFILLER_100_805 VGND VGND VPWR VPWR sky130_fd_sc_hd__decap_6
X_3294_ clknet_3_2__leaf_clk _0077_ net36 VGND VGND VPWR VPWR B_reg\[4\] sky130_fd_sc_hd__dfrtp_4
X_2314_ _1550_ _1553_ _1556_ VGND VGND VPWR VPWR _1567_ sky130_fd_sc_hd__and3_1
XFILLER_100_849 VPWR VGND VPWR VGND sky130_ef_sc_hd__decap_12
XFILLER_66_730 VPWR VGND VPWR VGND sky130_ef_sc_hd__decap_12
XFILLER_38_421 VPWR VGND VPWR VGND sky130_ef_sc_hd__decap_12
X_2245_ A_reg\[4\] _1496_ _1488_ VGND VGND VPWR VPWR _1502_ sky130_fd_sc_hd__a21oi_1
XFILLER_122_29 VPWR VGND VPWR VGND sky130_ef_sc_hd__decap_12
XFILLER_65_240 VPWR VGND VPWR VGND sky130_ef_sc_hd__decap_12
X_2176_ A_reg\[10\] _1420_ _1428_ VGND VGND VPWR VPWR _1433_ sky130_fd_sc_hd__and3_1
XTAP_TAPCELL_ROW_49_1114 VGND VPWR sky130_fd_sc_hd__tapvpwrvgnd_1
XFILLER_53_457 VGND VGND VPWR VPWR sky130_fd_sc_hd__fill_1
XFILLER_25_137 VPWR VGND VPWR VGND sky130_ef_sc_hd__decap_12
XFILLER_81_777 VGND VGND VPWR VPWR sky130_fd_sc_hd__decap_6
XFILLER_80_265 VPWR VGND VPWR VGND sky130_ef_sc_hd__decap_12
XFILLER_15_27 VPWR VGND VPWR VGND sky130_ef_sc_hd__decap_12
XFILLER_22_811 VGND VGND VPWR VPWR sky130_fd_sc_hd__fill_1
XTAP_TAPCELL_ROW_62_1325 VGND VPWR sky130_fd_sc_hd__tapvpwrvgnd_1
XFILLER_33_181 VPWR VGND VPWR VGND sky130_ef_sc_hd__decap_12
XFILLER_34_693 VGND VGND VPWR VPWR sky130_fd_sc_hd__decap_6
XFILLER_139_529 VPWR VGND VPWR VGND sky130_ef_sc_hd__decap_12
XTAP_TAPCELL_ROW_32_850 VGND VPWR sky130_fd_sc_hd__tapvpwrvgnd_1
XFILLER_31_15 VPWR VGND VPWR VGND sky130_ef_sc_hd__decap_12
XFILLER_147_573 VPWR VGND VPWR VGND sky130_ef_sc_hd__decap_12
XFILLER_147_15 VPWR VGND VPWR VGND sky130_ef_sc_hd__decap_12
XFILLER_108_905 VGND VGND VPWR VPWR sky130_fd_sc_hd__decap_4
XFILLER_107_404 VPWR VGND VPWR VGND sky130_ef_sc_hd__decap_12
XFILLER_134_245 VGND VGND VPWR VPWR sky130_fd_sc_hd__decap_6
XFILLER_107_459 VGND VGND VPWR VPWR sky130_fd_sc_hd__decap_4
XPHY_EDGE_ROW_1_Right_1 VGND VGND VPWR VPWR sky130_fd_sc_hd__decap_3
XFILLER_134_289 VPWR VGND VPWR VGND sky130_ef_sc_hd__decap_12
XFILLER_89_833 VGND VGND VPWR VPWR sky130_fd_sc_hd__decap_6
Xoutput48 net48 VGND VGND VPWR VPWR X_out[4] sky130_fd_sc_hd__buf_1
Xoutput37 net37 VGND VGND VPWR VPWR Done sky130_fd_sc_hd__buf_1
XFILLER_150_749 VGND VGND VPWR VPWR sky130_fd_sc_hd__decap_6
XFILLER_88_321 VPWR VGND VPWR VGND sky130_ef_sc_hd__decap_12
XFILLER_0_225 VPWR VGND VPWR VGND sky130_ef_sc_hd__decap_12
XFILLER_103_665 VGND VGND VPWR VPWR sky130_fd_sc_hd__decap_6
XFILLER_102_153 VPWR VGND VPWR VGND sky130_ef_sc_hd__decap_12
XFILLER_89_877 VPWR VGND VPWR VGND sky130_ef_sc_hd__decap_12
XFILLER_88_365 VPWR VGND VPWR VGND sky130_ef_sc_hd__decap_12
XTAP_TAPCELL_ROW_73_1498 VGND VPWR sky130_fd_sc_hd__tapvpwrvgnd_1
XFILLER_49_719 VGND VGND VPWR VPWR sky130_fd_sc_hd__fill_1
XFILLER_0_258 VGND VGND VPWR VPWR sky130_fd_sc_hd__fill_2
XFILLER_102_197 VPWR VGND VPWR VGND sky130_ef_sc_hd__decap_12
XFILLER_57_741 VPWR VGND VPWR VGND sky130_ef_sc_hd__decap_12
XFILLER_56_251 VGND VGND VPWR VPWR sky130_fd_sc_hd__fill_1
XFILLER_71_221 VGND VGND VPWR VPWR sky130_fd_sc_hd__decap_3
XFILLER_44_457 VPWR VGND VPWR VGND sky130_ef_sc_hd__decap_12
XFILLER_72_777 VPWR VGND VPWR VGND sky130_ef_sc_hd__decap_12
XFILLER_71_265 VGND VGND VPWR VPWR sky130_fd_sc_hd__decap_8
XFILLER_25_671 VGND VGND VPWR VPWR sky130_fd_sc_hd__fill_1
XFILLER_72_66 VGND VGND VPWR VPWR sky130_fd_sc_hd__decap_8
XFILLER_12_321 VGND VGND VPWR VPWR sky130_fd_sc_hd__fill_2
XFILLER_13_833 VGND VGND VPWR VPWR sky130_fd_sc_hd__decap_6
XFILLER_13_877 VPWR VGND VPWR VGND sky130_ef_sc_hd__decap_12
XTAP_TAPCELL_ROW_30_809 VGND VPWR sky130_fd_sc_hd__tapvpwrvgnd_1
XFILLER_12_365 VPWR VGND VPWR VGND sky130_ef_sc_hd__decap_12
XFILLER_126_713 VPWR VGND VPWR VGND sky130_ef_sc_hd__decap_12
XFILLER_126_757 VPWR VGND VPWR VGND sky130_ef_sc_hd__decap_12
XFILLER_125_223 VGND VGND VPWR VPWR sky130_fd_sc_hd__fill_1
XTAP_TAPCELL_ROW_93_1819 VGND VPWR sky130_fd_sc_hd__tapvpwrvgnd_1
XFILLER_21_81 VPWR VGND VPWR VGND sky130_ef_sc_hd__decap_12
XFILLER_153_587 VGND VGND VPWR VPWR sky130_fd_sc_hd__fill_1
XFILLER_141_727 VGND VGND VPWR VPWR sky130_fd_sc_hd__fill_1
XFILLER_137_81 VPWR VGND VPWR VGND sky130_ef_sc_hd__decap_12
XFILLER_113_429 VPWR VGND VPWR VGND sky130_ef_sc_hd__decap_12
XFILLER_67_505 VPWR VGND VPWR VGND sky130_ef_sc_hd__decap_12
XFILLER_121_473 VPWR VGND VPWR VGND sky130_ef_sc_hd__decap_12
XFILLER_0_781 VGND VGND VPWR VPWR sky130_fd_sc_hd__decap_3
XTAP_TAPCELL_ROW_124_2318 VGND VPWR sky130_fd_sc_hd__tapvpwrvgnd_1
X_2030_ _1291_ _1286_ _1287_ VGND VGND VPWR VPWR _1292_ sky130_fd_sc_hd__mux2_1
XFILLER_47_273 VGND VGND VPWR VPWR sky130_fd_sc_hd__decap_6
XTAP_TAPCELL_ROW_18_622 VGND VPWR sky130_fd_sc_hd__tapvpwrvgnd_1
X_2932_ _0603_ _0619_ VGND VGND VPWR VPWR _0620_ sky130_fd_sc_hd__nand2b_1
XFILLER_16_693 VGND VGND VPWR VPWR sky130_fd_sc_hd__decap_6
XTAP_TAPCELL_ROW_102_1959 VGND VPWR sky130_fd_sc_hd__tapvpwrvgnd_1
XFILLER_94_3 VPWR VGND VPWR VGND sky130_ef_sc_hd__decap_12
XFILLER_15_181 VPWR VGND VPWR VGND sky130_ef_sc_hd__decap_12
XTAP_TAPCELL_ROW_44_1033 VGND VPWR sky130_fd_sc_hd__tapvpwrvgnd_1
XTAP_TAPCELL_ROW_139_2561 VGND VPWR sky130_fd_sc_hd__tapvpwrvgnd_1
XTAP_TAPCELL_ROW_139_2550 VGND VPWR sky130_fd_sc_hd__tapvpwrvgnd_1
X_2863_ net21 B_reg\[13\] _0383_ VGND VGND VPWR VPWR _0086_ sky130_fd_sc_hd__mux2_1
XFILLER_31_685 VPWR VGND VPWR VGND sky130_ef_sc_hd__decap_12
X_2794_ _0532_ _0533_ VGND VGND VPWR VPWR _0534_ sky130_fd_sc_hd__and2_1
XFILLER_30_195 VGND VGND VPWR VPWR sky130_fd_sc_hd__fill_1
X_1814_ _1086_ VGND VGND VPWR VPWR _1087_ sky130_fd_sc_hd__inv_2
XTAP_TAPCELL_ROW_152_2761 VGND VPWR sky130_fd_sc_hd__tapvpwrvgnd_1
XFILLER_129_573 VPWR VGND VPWR VGND sky130_ef_sc_hd__decap_12
XANTENNA__2557__B1 _0184_ VGND VGND VPWR VPWR sky130_fd_sc_hd__diode_2
XFILLER_8_881 VPWR VGND VPWR VGND sky130_ef_sc_hd__decap_12
X_1745_ A_reg\[12\] _1011_ _1017_ VGND VGND VPWR VPWR _1018_ sky130_fd_sc_hd__a21bo_1
XFILLER_116_245 VGND VGND VPWR VPWR sky130_fd_sc_hd__decap_6
XANTENNA__3275__RESET_B net36 VGND VGND VPWR VPWR sky130_fd_sc_hd__diode_2
XFILLER_144_587 VGND VGND VPWR VPWR sky130_fd_sc_hd__fill_1
XFILLER_116_289 VPWR VGND VPWR VGND sky130_ef_sc_hd__decap_12
XANTENNA__3316__CLK clknet_3_6__leaf_clk VGND VGND VPWR VPWR sky130_fd_sc_hd__diode_2
X_1676_ _0940_ _0951_ VGND VGND VPWR VPWR _0952_ sky130_fd_sc_hd__xnor2_2
XFILLER_132_749 VGND VGND VPWR VPWR sky130_fd_sc_hd__decap_6
XFILLER_131_237 VPWR VGND VPWR VGND sky130_ef_sc_hd__decap_12
XFILLER_86_825 VPWR VGND VPWR VGND sky130_ef_sc_hd__decap_12
XFILLER_140_793 VPWR VGND VPWR VGND sky130_ef_sc_hd__decap_12
XFILLER_133_39 VPWR VGND VPWR VGND sky130_ef_sc_hd__decap_12
XFILLER_100_613 VPWR VGND VPWR VGND sky130_ef_sc_hd__decap_12
XFILLER_100_657 VPWR VGND VPWR VGND sky130_ef_sc_hd__decap_12
XFILLER_86_869 VPWR VGND VPWR VGND sky130_ef_sc_hd__decap_12
X_3277_ clknet_3_0__leaf_clk _0060_ net36 VGND VGND VPWR VPWR A_reg\[3\] sky130_fd_sc_hd__dfrtp_4
XFILLER_26_15 VPWR VGND VPWR VGND sky130_ef_sc_hd__decap_12
X_2228_ _1466_ _1467_ _1470_ _1484_ VGND VGND VPWR VPWR _1485_ sky130_fd_sc_hd__a31o_1
XFILLER_38_251 VGND VGND VPWR VPWR sky130_fd_sc_hd__fill_1
XFILLER_39_785 VPWR VGND VPWR VGND sky130_ef_sc_hd__decap_12
XFILLER_93_390 VGND VGND VPWR VPWR sky130_fd_sc_hd__fill_2
XFILLER_54_755 VGND VGND VPWR VPWR sky130_fd_sc_hd__fill_1
X_2159_ _1415_ VGND VGND VPWR VPWR _1416_ sky130_fd_sc_hd__inv_2
XTAP_TAPCELL_ROW_37_920 VGND VPWR sky130_fd_sc_hd__tapvpwrvgnd_1
XTAP_TAPCELL_ROW_37_931 VGND VPWR sky130_fd_sc_hd__tapvpwrvgnd_1
XFILLER_26_457 VPWR VGND VPWR VGND sky130_ef_sc_hd__decap_12
XFILLER_81_585 VPWR VGND VPWR VGND sky130_ef_sc_hd__decap_12
XFILLER_41_449 VPWR VGND VPWR VGND sky130_ef_sc_hd__decap_12
XFILLER_139_337 VPWR VGND VPWR VGND sky130_ef_sc_hd__decap_12
XFILLER_10_825 VPWR VGND VPWR VGND sky130_ef_sc_hd__decap_12
XFILLER_10_869 VPWR VGND VPWR VGND sky130_ef_sc_hd__decap_12
XFILLER_148_893 VPWR VGND VPWR VGND sky130_ef_sc_hd__decap_12
XFILLER_108_713 VPWR VGND VPWR VGND sky130_ef_sc_hd__decap_12
XFILLER_108_757 VPWR VGND VPWR VGND sky130_ef_sc_hd__decap_12
XFILLER_107_223 VGND VGND VPWR VPWR sky130_fd_sc_hd__fill_1
XTAP_TAPCELL_ROW_75_1527 VGND VPWR sky130_fd_sc_hd__tapvpwrvgnd_1
XFILLER_150_513 VPWR VGND VPWR VGND sky130_ef_sc_hd__decap_12
XFILLER_123_727 VGND VGND VPWR VPWR sky130_fd_sc_hd__fill_1
XTAP_TAPCELL_ROW_75_1538 VGND VPWR sky130_fd_sc_hd__tapvpwrvgnd_1
XFILLER_150_557 VPWR VGND VPWR VGND sky130_ef_sc_hd__decap_12
XFILLER_89_641 VPWR VGND VPWR VGND sky130_ef_sc_hd__decap_12
XFILLER_107_51 VGND VGND VPWR VPWR sky130_fd_sc_hd__decap_4
XFILLER_49_505 VPWR VGND VPWR VGND sky130_ef_sc_hd__decap_12
XFILLER_103_473 VPWR VGND VPWR VGND sky130_ef_sc_hd__decap_12
XFILLER_89_685 VPWR VGND VPWR VGND sky130_ef_sc_hd__decap_12
XFILLER_67_99 VPWR VGND VPWR VGND sky130_ef_sc_hd__decap_12
XTAP_TAPCELL_ROW_106_2026 VGND VPWR sky130_fd_sc_hd__tapvpwrvgnd_1
XFILLER_91_305 VPWR VGND VPWR VGND sky130_ef_sc_hd__decap_12
XTAP_TAPCELL_ROW_4_394 VGND VPWR sky130_fd_sc_hd__tapvpwrvgnd_1
XFILLER_45_711 VPWR VGND VPWR VGND sky130_ef_sc_hd__decap_12
XANTENNA_input14_A A_in[7] VGND VGND VPWR VPWR sky130_fd_sc_hd__diode_2
XFILLER_44_221 VPWR VGND VPWR VGND sky130_ef_sc_hd__decap_12
XPHY_EDGE_ROW_103_Left_257 VGND VGND VPWR VPWR sky130_fd_sc_hd__decap_3
XFILLER_83_65 VPWR VGND VPWR VGND sky130_ef_sc_hd__decap_12
XFILLER_44_265 VPWR VGND VPWR VGND sky130_ef_sc_hd__decap_12
XFILLER_60_725 VPWR VGND VPWR VGND sky130_ef_sc_hd__decap_12
XFILLER_60_769 VPWR VGND VPWR VGND sky130_ef_sc_hd__decap_12
XFILLER_13_641 VPWR VGND VPWR VGND sky130_ef_sc_hd__decap_12
XFILLER_13_685 VPWR VGND VPWR VGND sky130_ef_sc_hd__decap_12
XFILLER_8_133 VGND VGND VPWR VPWR sky130_fd_sc_hd__decap_6
XFILLER_12_195 VGND VGND VPWR VPWR sky130_fd_sc_hd__fill_1
XFILLER_145_329 VGND VGND VPWR VPWR sky130_fd_sc_hd__decap_6
XFILLER_8_177 VPWR VGND VPWR VGND sky130_ef_sc_hd__decap_12
XTAP_TAPCELL_ROW_134_2480 VGND VPWR sky130_fd_sc_hd__tapvpwrvgnd_1
XTAP_TAPCELL_ROW_117_2199 VGND VPWR sky130_fd_sc_hd__tapvpwrvgnd_1
XFILLER_126_587 VGND VGND VPWR VPWR sky130_fd_sc_hd__fill_1
XPHY_EDGE_ROW_112_Left_266 VGND VGND VPWR VPWR sky130_fd_sc_hd__decap_3
XFILLER_99_405 VPWR VGND VPWR VGND sky130_ef_sc_hd__decap_12
XFILLER_114_749 VGND VGND VPWR VPWR sky130_fd_sc_hd__decap_6
XFILLER_113_237 VPWR VGND VPWR VGND sky130_ef_sc_hd__decap_12
XFILLER_99_449 VPWR VGND VPWR VGND sky130_ef_sc_hd__decap_12
XFILLER_5_895 VGND VGND VPWR VPWR sky130_fd_sc_hd__fill_1
XFILLER_4_383 VPWR VGND VPWR VGND sky130_ef_sc_hd__decap_12
XANTENNA__3055__A _0604_ VGND VGND VPWR VPWR sky130_fd_sc_hd__diode_2
X_3200_ X_crt\[8\] CRT_Start _0878_ _0879_ VGND VGND VPWR VPWR _0097_ sky130_fd_sc_hd__o22a_1
XFILLER_122_793 VPWR VGND VPWR VGND sky130_ef_sc_hd__decap_12
XFILLER_68_825 VPWR VGND VPWR VGND sky130_ef_sc_hd__decap_12
X_3131_ _0796_ _0799_ VGND VGND VPWR VPWR _0819_ sky130_fd_sc_hd__nor2_1
XFILLER_121_281 VPWR VGND VPWR VGND sky130_ef_sc_hd__decap_12
XFILLER_68_869 VPWR VGND VPWR VGND sky130_ef_sc_hd__decap_12
XFILLER_83_839 VGND VGND VPWR VPWR sky130_fd_sc_hd__fill_1
XFILLER_82_327 VGND VGND VPWR VPWR sky130_fd_sc_hd__fill_1
X_3062_ _0737_ _0738_ VGND VGND VPWR VPWR _0750_ sky130_fd_sc_hd__xor2_1
XPHY_EDGE_ROW_121_Left_275 VGND VGND VPWR VPWR sky130_fd_sc_hd__decap_3
XFILLER_82_338 VGND VGND VPWR VPWR sky130_fd_sc_hd__decap_3
X_2013_ _1269_ _1274_ _1270_ VGND VGND VPWR VPWR _1275_ sky130_fd_sc_hd__mux2_1
XFILLER_36_755 VGND VGND VPWR VPWR sky130_fd_sc_hd__fill_1
XFILLER_51_714 VPWR VGND VPWR VGND sky130_ef_sc_hd__decap_12
XFILLER_23_405 VGND VGND VPWR VPWR sky130_fd_sc_hd__fill_2
XFILLER_63_585 VPWR VGND VPWR VGND sky130_ef_sc_hd__decap_12
XFILLER_50_224 VPWR VGND VPWR VGND sky130_ef_sc_hd__decap_12
XANTENNA__2833__S _0553_ VGND VGND VPWR VPWR sky130_fd_sc_hd__diode_2
XFILLER_23_427 VPWR VGND VPWR VGND sky130_ef_sc_hd__decap_12
XFILLER_35_276 VGND VGND VPWR VPWR sky130_fd_sc_hd__decap_4
XFILLER_23_449 VPWR VGND VPWR VGND sky130_ef_sc_hd__decap_12
X_2915_ _0554_ _0602_ _0601_ VGND VGND VPWR VPWR _0603_ sky130_fd_sc_hd__o21ba_1
XFILLER_136_307 VGND VGND VPWR VPWR sky130_fd_sc_hd__fill_1
X_2846_ net4 A_reg\[12\] _0383_ VGND VGND VPWR VPWR _0069_ sky130_fd_sc_hd__mux2_1
XFILLER_148_189 VGND VGND VPWR VPWR sky130_fd_sc_hd__decap_6
XFILLER_145_841 VPWR VGND VPWR VGND sky130_ef_sc_hd__decap_12
XPHY_EDGE_ROW_130_Left_284 VGND VGND VPWR VPWR sky130_fd_sc_hd__decap_3
X_2777_ _0513_ _0514_ _0516_ VGND VGND VPWR VPWR _0517_ sky130_fd_sc_hd__o21a_1
XFILLER_132_513 VPWR VGND VPWR VGND sky130_ef_sc_hd__decap_12
XFILLER_105_727 VGND VGND VPWR VPWR sky130_fd_sc_hd__fill_1
XTAP_TAPCELL_ROW_57_1246 VGND VPWR sky130_fd_sc_hd__tapvpwrvgnd_1
X_1728_ _0996_ _1001_ VGND VGND VPWR VPWR _1003_ sky130_fd_sc_hd__nand2_1
XFILLER_2_309 VPWR VGND VPWR VGND sky130_ef_sc_hd__decap_12
X_1659_ A_reg\[10\] _0921_ _0933_ VGND VGND VPWR VPWR _0935_ sky130_fd_sc_hd__nand3_1
XFILLER_144_27 VGND VGND VPWR VPWR sky130_fd_sc_hd__fill_1
XFILLER_132_557 VPWR VGND VPWR VGND sky130_ef_sc_hd__decap_12
XFILLER_86_622 VGND VGND VPWR VPWR sky130_fd_sc_hd__fill_1
XTAP_TAPCELL_ROW_70_1457 VGND VPWR sky130_fd_sc_hd__tapvpwrvgnd_1
XTAP_TAPCELL_ROW_70_1446 VGND VPWR sky130_fd_sc_hd__tapvpwrvgnd_1
XANTENNA_input6_A A_in[14] VGND VGND VPWR VPWR sky130_fd_sc_hd__diode_2
XFILLER_100_421 VPWR VGND VPWR VGND sky130_ef_sc_hd__decap_12
XFILLER_100_454 VPWR VGND VPWR VGND sky130_ef_sc_hd__decap_12
XFILLER_73_305 VPWR VGND VPWR VGND sky130_ef_sc_hd__decap_12
XTAP_TAPCELL_ROW_1_342 VGND VPWR sky130_fd_sc_hd__tapvpwrvgnd_1
XFILLER_26_221 VGND VGND VPWR VPWR sky130_fd_sc_hd__decap_3
XFILLER_37_69 VPWR VGND VPWR VGND sky130_ef_sc_hd__decap_12
XFILLER_82_861 VGND VGND VPWR VPWR sky130_fd_sc_hd__decap_6
XFILLER_54_541 VGND VGND VPWR VPWR sky130_fd_sc_hd__decap_3
XTAP_TAPCELL_ROW_1_353 VGND VPWR sky130_fd_sc_hd__tapvpwrvgnd_1
XFILLER_27_777 VGND VGND VPWR VPWR sky130_fd_sc_hd__decap_6
XFILLER_41_213 VGND VGND VPWR VPWR sky130_fd_sc_hd__fill_1
XFILLER_81_393 VGND VGND VPWR VPWR sky130_fd_sc_hd__decap_4
XFILLER_53_57 VPWR VGND VPWR VGND sky130_ef_sc_hd__decap_12
XFILLER_14_449 VPWR VGND VPWR VGND sky130_ef_sc_hd__decap_12
XFILLER_41_246 VPWR VGND VPWR VGND sky130_ef_sc_hd__decap_12
XFILLER_22_460 VPWR VGND VPWR VGND sky130_ef_sc_hd__decap_12
XFILLER_139_167 VGND VGND VPWR VPWR sky130_fd_sc_hd__fill_1
XFILLER_127_329 VGND VGND VPWR VPWR sky130_fd_sc_hd__decap_6
XTAP_TAPCELL_ROW_20_650 VGND VPWR sky130_fd_sc_hd__tapvpwrvgnd_1
XFILLER_10_699 VGND VGND VPWR VPWR sky130_fd_sc_hd__fill_1
XFILLER_5_125 VPWR VGND VPWR VGND sky130_ef_sc_hd__decap_12
XANTENNA__2698__B a_r3\[1\] VGND VGND VPWR VPWR sky130_fd_sc_hd__diode_2
XFILLER_5_169 VPWR VGND VPWR VGND sky130_ef_sc_hd__decap_12
XFILLER_151_833 VGND VGND VPWR VPWR sky130_fd_sc_hd__decap_6
XFILLER_150_321 VPWR VGND VPWR VGND sky130_ef_sc_hd__decap_12
XFILLER_135_373 VPWR VGND VPWR VGND sky130_ef_sc_hd__decap_12
XFILLER_118_83 VGND VGND VPWR VPWR sky130_fd_sc_hd__fill_1
XFILLER_97_909 VGND VGND VPWR VPWR sky130_fd_sc_hd__fill_1
XFILLER_151_877 VPWR VGND VPWR VGND sky130_ef_sc_hd__decap_12
XFILLER_150_365 VPWR VGND VPWR VGND sky130_ef_sc_hd__decap_12
XFILLER_78_54 VPWR VGND VPWR VGND sky130_ef_sc_hd__decap_12
XTAP_TAPCELL_ROW_9_475 VGND VPWR sky130_fd_sc_hd__tapvpwrvgnd_1
XFILLER_104_793 VPWR VGND VPWR VGND sky130_ef_sc_hd__decap_12
XFILLER_78_98 VPWR VGND VPWR VGND sky130_ef_sc_hd__decap_12
XFILLER_103_281 VPWR VGND VPWR VGND sky130_ef_sc_hd__decap_12
XFILLER_49_335 VGND VGND VPWR VPWR sky130_fd_sc_hd__fill_1
XFILLER_91_102 VGND VGND VPWR VPWR sky130_fd_sc_hd__decap_4
XFILLER_76_165 VPWR VGND VPWR VGND sky130_ef_sc_hd__decap_12
XFILLER_65_839 VGND VGND VPWR VPWR sky130_fd_sc_hd__fill_1
XANTENNA_input17_X net17 VGND VGND VPWR VPWR sky130_fd_sc_hd__diode_2
XFILLER_92_669 VPWR VGND VPWR VGND sky130_ef_sc_hd__decap_12
XFILLER_18_755 VGND VGND VPWR VPWR sky130_fd_sc_hd__fill_1
XTAP_TAPCELL_ROW_28_772 VGND VPWR sky130_fd_sc_hd__tapvpwrvgnd_1
XTAP_TAPCELL_ROW_28_783 VGND VPWR sky130_fd_sc_hd__tapvpwrvgnd_1
XFILLER_60_533 VPWR VGND VPWR VGND sky130_ef_sc_hd__decap_12
XFILLER_21_909 VGND VGND VPWR VPWR sky130_fd_sc_hd__fill_1
XFILLER_32_246 VGND VGND VPWR VPWR sky130_fd_sc_hd__decap_6
XFILLER_20_419 VGND VGND VPWR VPWR sky130_fd_sc_hd__fill_1
XTAP_TAPCELL_ROW_119_2239 VGND VPWR sky130_fd_sc_hd__tapvpwrvgnd_1
XTAP_TAPCELL_ROW_119_2228 VGND VPWR sky130_fd_sc_hd__tapvpwrvgnd_1
X_2700_ _0438_ _0439_ VGND VGND VPWR VPWR _0440_ sky130_fd_sc_hd__and2b_1
XFILLER_9_453 VGND VGND VPWR VPWR sky130_fd_sc_hd__fill_1
XFILLER_118_307 VGND VGND VPWR VPWR sky130_fd_sc_hd__fill_1
XFILLER_145_137 VPWR VGND VPWR VGND sky130_ef_sc_hd__decap_12
XFILLER_127_841 VPWR VGND VPWR VGND sky130_ef_sc_hd__decap_12
X_2631_ _0373_ _0374_ _0375_ VGND VGND VPWR VPWR _0376_ sky130_fd_sc_hd__o21ba_1
XFILLER_142_811 VGND VGND VPWR VPWR sky130_fd_sc_hd__fill_1
XTAP_TAPCELL_ROW_132_2439 VGND VPWR sky130_fd_sc_hd__tapvpwrvgnd_1
XFILLER_99_202 VPWR VGND VPWR VGND sky130_ef_sc_hd__decap_12
X_2562_ a_r2\[1\] b_r2\[1\] VGND VGND VPWR VPWR _0307_ sky130_fd_sc_hd__nand2_1
XFILLER_153_181 VPWR VGND VPWR VGND sky130_ef_sc_hd__decap_12
XFILLER_114_513 VPWR VGND VPWR VGND sky130_ef_sc_hd__decap_12
XFILLER_88_909 VGND VGND VPWR VPWR sky130_fd_sc_hd__fill_1
XFILLER_114_557 VPWR VGND VPWR VGND sky130_ef_sc_hd__decap_12
X_2493_ a_r1\[1\] b_r1\[1\] VGND VGND VPWR VPWR _0241_ sky130_fd_sc_hd__nor2_1
XFILLER_99_279 VGND VGND VPWR VPWR sky130_fd_sc_hd__fill_1
XANTENNA__2828__S _0553_ VGND VGND VPWR VPWR sky130_fd_sc_hd__diode_2
XTAP_TAPCELL_ROW_52_1165 VGND VPWR sky130_fd_sc_hd__tapvpwrvgnd_1
XTAP_TAPCELL_ROW_147_2682 VGND VPWR sky130_fd_sc_hd__tapvpwrvgnd_1
XFILLER_95_485 VPWR VGND VPWR VGND sky130_ef_sc_hd__decap_12
XFILLER_68_699 VGND VGND VPWR VPWR sky130_fd_sc_hd__fill_1
XFILLER_55_305 VGND VGND VPWR VPWR sky130_fd_sc_hd__decap_8
X_3114_ _0559_ _0752_ VGND VGND VPWR VPWR _0802_ sky130_fd_sc_hd__or2_1
XFILLER_82_124 VPWR VGND VPWR VGND sky130_ef_sc_hd__decap_12
XFILLER_55_349 VGND VGND VPWR VPWR sky130_fd_sc_hd__decap_4
X_3045_ _0673_ _0732_ VGND VGND VPWR VPWR _0733_ sky130_fd_sc_hd__nor2_1
XFILLER_71_809 VPWR VGND VPWR VGND sky130_ef_sc_hd__decap_12
XFILLER_64_861 VGND VGND VPWR VPWR sky130_fd_sc_hd__decap_6
XFILLER_130_29 VPWR VGND VPWR VGND sky130_ef_sc_hd__decap_12
XANTENNA__1968__A B_reg\[3\] VGND VGND VPWR VPWR sky130_fd_sc_hd__diode_2
XFILLER_24_725 VPWR VGND VPWR VGND sky130_ef_sc_hd__decap_12
XFILLER_36_585 VGND VGND VPWR VPWR sky130_fd_sc_hd__decap_3
XFILLER_12_909 VGND VGND VPWR VPWR sky130_fd_sc_hd__fill_1
XFILLER_24_769 VPWR VGND VPWR VGND sky130_ef_sc_hd__decap_12
XFILLER_23_27 VPWR VGND VPWR VGND sky130_ef_sc_hd__decap_12
XFILLER_23_268 VGND VGND VPWR VPWR sky130_fd_sc_hd__decap_3
XFILLER_139_27 VPWR VGND VPWR VGND sky130_ef_sc_hd__decap_12
XANTENNA__3290__RESET_B net36 VGND VGND VPWR VPWR sky130_fd_sc_hd__diode_2
XFILLER_109_329 VGND VGND VPWR VPWR sky130_fd_sc_hd__decap_6
X_2829_ net40 X_crt\[11\] _0553_ VGND VGND VPWR VPWR _0052_ sky130_fd_sc_hd__mux2_1
XFILLER_145_671 VGND VGND VPWR VPWR sky130_fd_sc_hd__fill_1
XFILLER_133_833 VGND VGND VPWR VPWR sky130_fd_sc_hd__decap_6
XFILLER_132_321 VPWR VGND VPWR VGND sky130_ef_sc_hd__decap_12
XFILLER_117_373 VPWR VGND VPWR VGND sky130_ef_sc_hd__decap_12
XFILLER_133_877 VPWR VGND VPWR VGND sky130_ef_sc_hd__decap_12
XFILLER_105_557 VGND VGND VPWR VPWR sky130_fd_sc_hd__decap_3
XFILLER_79_909 VGND VGND VPWR VPWR sky130_fd_sc_hd__fill_1
XFILLER_2_139 VGND VGND VPWR VPWR sky130_fd_sc_hd__fill_1
XFILLER_132_365 VPWR VGND VPWR VGND sky130_ef_sc_hd__decap_12
XTAP_TAPCELL_ROW_6_434 VGND VPWR sky130_fd_sc_hd__tapvpwrvgnd_1
XTAP_TAPCELL_ROW_6_423 VGND VPWR sky130_fd_sc_hd__tapvpwrvgnd_1
XFILLER_101_741 VPWR VGND VPWR VGND sky130_ef_sc_hd__decap_12
XANTENNA_input9_X net9 VGND VGND VPWR VPWR sky130_fd_sc_hd__diode_2
XFILLER_59_644 VPWR VGND VPWR VGND sky130_ef_sc_hd__decap_12
XFILLER_48_35 VGND VGND VPWR VPWR sky130_fd_sc_hd__fill_1
XPHY_EDGE_ROW_122_Right_122 VGND VGND VPWR VPWR sky130_fd_sc_hd__decap_3
XFILLER_101_785 VPWR VGND VPWR VGND sky130_ef_sc_hd__decap_12
XFILLER_100_251 VGND VGND VPWR VPWR sky130_fd_sc_hd__fill_1
XFILLER_59_699 VPWR VGND VPWR VGND sky130_ef_sc_hd__decap_12
XFILLER_59_666 VGND VGND VPWR VPWR sky130_fd_sc_hd__decap_6
XFILLER_58_165 VPWR VGND VPWR VGND sky130_ef_sc_hd__decap_12
XFILLER_47_839 VGND VGND VPWR VPWR sky130_fd_sc_hd__fill_1
XANTENNA__2151__A1 A_reg\[15\] VGND VGND VPWR VPWR sky130_fd_sc_hd__diode_2
XFILLER_104_41 VPWR VGND VPWR VGND sky130_ef_sc_hd__decap_12
XFILLER_73_113 VPWR VGND VPWR VGND sky130_ef_sc_hd__decap_12
XFILLER_104_85 VPWR VGND VPWR VGND sky130_ef_sc_hd__decap_12
XFILLER_74_669 VGND VGND VPWR VPWR sky130_fd_sc_hd__decap_6
XFILLER_27_585 VPWR VGND VPWR VGND sky130_ef_sc_hd__decap_12
XTAP_TAPCELL_ROW_83_1659 VGND VPWR sky130_fd_sc_hd__tapvpwrvgnd_1
XTAP_TAPCELL_ROW_25_731 VGND VPWR sky130_fd_sc_hd__tapvpwrvgnd_1
XFILLER_42_533 VPWR VGND VPWR VGND sky130_ef_sc_hd__decap_12
XANTENNA__3307__RESET_B net36 VGND VGND VPWR VPWR sky130_fd_sc_hd__diode_2
XFILLER_80_99 VPWR VGND VPWR VGND sky130_ef_sc_hd__decap_12
XFILLER_127_137 VPWR VGND VPWR VGND sky130_ef_sc_hd__decap_12
XFILLER_109_841 VPWR VGND VPWR VGND sky130_ef_sc_hd__decap_12
XFILLER_6_445 VPWR VGND VPWR VGND sky130_ef_sc_hd__decap_12
XFILLER_13_93 VPWR VGND VPWR VGND sky130_ef_sc_hd__decap_12
XFILLER_129_93 VPWR VGND VPWR VGND sky130_ef_sc_hd__decap_12
XFILLER_124_811 VGND VGND VPWR VPWR sky130_fd_sc_hd__fill_1
XFILLER_136_693 VGND VGND VPWR VPWR sky130_fd_sc_hd__decap_6
XFILLER_135_181 VPWR VGND VPWR VGND sky130_ef_sc_hd__decap_12
XTAP_TAPCELL_ROW_114_2158 VGND VPWR sky130_fd_sc_hd__tapvpwrvgnd_1
XFILLER_6_489 VPWR VGND VPWR VGND sky130_ef_sc_hd__decap_12
XFILLER_151_641 VPWR VGND VPWR VGND sky130_ef_sc_hd__decap_12
XFILLER_151_685 VPWR VGND VPWR VGND sky130_ef_sc_hd__decap_12
XFILLER_145_81 VPWR VGND VPWR VGND sky130_ef_sc_hd__decap_12
XFILLER_111_538 VPWR VGND VPWR VGND sky130_ef_sc_hd__decap_12
XFILLER_1_161 VGND VGND VPWR VPWR sky130_fd_sc_hd__decap_6
XFILLER_150_195 VGND VGND VPWR VPWR sky130_fd_sc_hd__fill_1
XFILLER_77_441 VGND VGND VPWR VPWR sky130_fd_sc_hd__decap_6
XTAP_TAPCELL_ROW_129_2390 VGND VPWR sky130_fd_sc_hd__tapvpwrvgnd_1
XFILLER_92_433 VPWR VGND VPWR VGND sky130_ef_sc_hd__decap_12
XFILLER_77_485 VPWR VGND VPWR VGND sky130_ef_sc_hd__decap_12
XFILLER_65_625 VPWR VGND VPWR VGND sky130_ef_sc_hd__decap_12
XFILLER_37_316 VPWR VGND VPWR VGND sky130_ef_sc_hd__decap_12
XFILLER_80_606 VPWR VGND VPWR VGND sky130_ef_sc_hd__decap_12
XFILLER_65_669 VGND VGND VPWR VPWR sky130_fd_sc_hd__decap_3
XFILLER_53_809 VPWR VGND VPWR VGND sky130_ef_sc_hd__decap_12
Xclkbuf_3_7__f_clk clknet_0_clk VGND VGND VPWR VPWR clknet_3_7__leaf_clk sky130_fd_sc_hd__clkbuf_16
XFILLER_45_393 VPWR VGND VPWR VGND sky130_ef_sc_hd__decap_12
XFILLER_61_897 VGND VGND VPWR VPWR sky130_fd_sc_hd__decap_8
XFILLER_33_577 VPWR VGND VPWR VGND sky130_ef_sc_hd__decap_12
X_1993_ B_reg\[13\] _1177_ VGND VGND VPWR VPWR _1255_ sky130_fd_sc_hd__or2_1
XFILLER_146_413 VGND VGND VPWR VPWR sky130_fd_sc_hd__decap_6
XFILLER_9_261 VPWR VGND VPWR VGND sky130_ef_sc_hd__decap_12
XFILLER_146_457 VPWR VGND VPWR VGND sky130_ef_sc_hd__decap_12
X_2614_ a_r2\[0\] _0186_ VGND VGND VPWR VPWR _0359_ sky130_fd_sc_hd__nor2_1
XFILLER_127_671 VGND VGND VPWR VPWR sky130_fd_sc_hd__fill_1
XFILLER_115_833 VGND VGND VPWR VPWR sky130_fd_sc_hd__decap_6
XFILLER_114_321 VPWR VGND VPWR VGND sky130_ef_sc_hd__decap_12
XTAP_TAPCELL_ROW_149_2711 VGND VPWR sky130_fd_sc_hd__tapvpwrvgnd_1
XFILLER_115_877 VPWR VGND VPWR VGND sky130_ef_sc_hd__decap_12
X_2545_ _0237_ _0288_ _0290_ _0292_ VGND VGND VPWR VPWR _0293_ sky130_fd_sc_hd__a31o_1
XTAP_TAPCELL_ROW_149_2722 VGND VPWR sky130_fd_sc_hd__tapvpwrvgnd_1
XFILLER_130_825 VPWR VGND VPWR VGND sky130_ef_sc_hd__decap_12
XFILLER_114_365 VPWR VGND VPWR VGND sky130_ef_sc_hd__decap_12
X_2476_ _0216_ _0223_ VGND VGND VPWR VPWR _0224_ sky130_fd_sc_hd__nor2_1
XFILLER_130_869 VPWR VGND VPWR VGND sky130_ef_sc_hd__decap_12
XFILLER_68_463 VPWR VGND VPWR VGND sky130_ef_sc_hd__decap_12
XFILLER_95_293 VPWR VGND VPWR VGND sky130_ef_sc_hd__decap_12
XFILLER_55_113 VPWR VGND VPWR VGND sky130_ef_sc_hd__decap_12
XFILLER_55_102 VGND VGND VPWR VPWR sky130_fd_sc_hd__decap_8
XFILLER_18_27 VGND VGND VPWR VPWR sky130_fd_sc_hd__fill_1
XFILLER_29_839 VGND VGND VPWR VPWR sky130_fd_sc_hd__fill_1
XFILLER_141_39 VPWR VGND VPWR VGND sky130_ef_sc_hd__decap_12
XFILLER_71_617 VPWR VGND VPWR VGND sky130_ef_sc_hd__decap_12
XFILLER_70_105 VPWR VGND VPWR VGND sky130_ef_sc_hd__decap_12
X_3028_ _0558_ _0715_ VGND VGND VPWR VPWR _0716_ sky130_fd_sc_hd__nor2_1
XFILLER_24_533 VPWR VGND VPWR VGND sky130_ef_sc_hd__decap_12
XFILLER_34_15 VPWR VGND VPWR VGND sky130_ef_sc_hd__decap_12
XTAP_TAPCELL_ROW_65_1378 VGND VPWR sky130_fd_sc_hd__tapvpwrvgnd_1
XTAP_TAPCELL_ROW_65_1367 VGND VPWR sky130_fd_sc_hd__tapvpwrvgnd_1
XFILLER_11_205 VPWR VGND VPWR VGND sky130_ef_sc_hd__decap_12
XFILLER_149_273 VGND VGND VPWR VPWR sky130_fd_sc_hd__decap_6
Xclkload3 clknet_3_3__leaf_clk VGND VGND VPWR VPWR clkload3/Y sky130_fd_sc_hd__clkinvlp_4
XFILLER_11_249 VPWR VGND VPWR VGND sky130_ef_sc_hd__decap_12
XFILLER_109_137 VPWR VGND VPWR VGND sky130_ef_sc_hd__decap_12
XFILLER_4_905 VGND VGND VPWR VPWR sky130_fd_sc_hd__decap_4
XFILLER_118_693 VGND VGND VPWR VPWR sky130_fd_sc_hd__decap_6
XFILLER_106_811 VGND VGND VPWR VPWR sky130_fd_sc_hd__fill_1
XFILLER_133_641 VPWR VGND VPWR VGND sky130_ef_sc_hd__decap_12
XFILLER_117_181 VPWR VGND VPWR VGND sky130_ef_sc_hd__decap_12
XFILLER_59_34 VPWR VGND VPWR VGND sky130_ef_sc_hd__decap_12
XFILLER_133_685 VPWR VGND VPWR VGND sky130_ef_sc_hd__decap_12
XFILLER_132_195 VGND VGND VPWR VPWR sky130_fd_sc_hd__fill_1
XFILLER_120_357 VGND VGND VPWR VPWR sky130_fd_sc_hd__decap_6
XFILLER_115_51 VGND VGND VPWR VPWR sky130_fd_sc_hd__decap_4
XFILLER_87_783 VGND VGND VPWR VPWR sky130_fd_sc_hd__fill_1
XFILLER_59_441 VGND VGND VPWR VPWR sky130_fd_sc_hd__decap_6
XFILLER_19_305 VPWR VGND VPWR VGND sky130_ef_sc_hd__decap_12
XANTENNA__2675__A2 a_r3\[1\] VGND VGND VPWR VPWR sky130_fd_sc_hd__diode_2
XFILLER_86_271 VPWR VGND VPWR VGND sky130_ef_sc_hd__decap_12
XFILLER_74_433 VPWR VGND VPWR VGND sky130_ef_sc_hd__decap_12
XFILLER_59_485 VPWR VGND VPWR VGND sky130_ef_sc_hd__decap_12
XFILLER_47_669 VGND VGND VPWR VPWR sky130_fd_sc_hd__decap_3
XFILLER_28_861 VGND VGND VPWR VPWR sky130_fd_sc_hd__decap_6
XFILLER_35_809 VGND VGND VPWR VPWR sky130_fd_sc_hd__decap_8
XFILLER_74_477 VPWR VGND VPWR VGND sky130_ef_sc_hd__decap_12
XFILLER_62_639 VGND VGND VPWR VPWR sky130_fd_sc_hd__decap_4
XFILLER_43_853 VPWR VGND VPWR VGND sky130_ef_sc_hd__decap_12
XFILLER_91_43 VPWR VGND VPWR VGND sky130_ef_sc_hd__decap_12
XFILLER_43_897 VPWR VGND VPWR VGND sky130_ef_sc_hd__decap_12
XFILLER_30_525 VGND VGND VPWR VPWR sky130_fd_sc_hd__decap_6
XFILLER_128_413 VGND VGND VPWR VPWR sky130_fd_sc_hd__decap_6
XANTENNA__1938__A1 B_reg\[8\] VGND VGND VPWR VPWR sky130_fd_sc_hd__diode_2
XFILLER_7_721 VGND VGND VPWR VPWR sky130_fd_sc_hd__decap_6
XFILLER_11_783 VGND VGND VPWR VPWR sky130_fd_sc_hd__fill_1
XFILLER_143_405 VPWR VGND VPWR VGND sky130_ef_sc_hd__decap_12
XFILLER_128_457 VPWR VGND VPWR VGND sky130_ef_sc_hd__decap_12
XFILLER_7_765 VPWR VGND VPWR VGND sky130_ef_sc_hd__decap_12
XFILLER_6_253 VPWR VGND VPWR VGND sky130_ef_sc_hd__decap_12
XFILLER_143_449 VPWR VGND VPWR VGND sky130_ef_sc_hd__decap_12
XFILLER_109_671 VGND VGND VPWR VPWR sky130_fd_sc_hd__fill_1
XFILLER_112_825 VPWR VGND VPWR VGND sky130_ef_sc_hd__decap_12
XFILLER_97_503 VGND VGND VPWR VPWR sky130_fd_sc_hd__fill_1
XFILLER_69_205 VPWR VGND VPWR VGND sky130_ef_sc_hd__decap_12
X_2330_ _0902_ _1580_ _1581_ VGND VGND VPWR VPWR _1583_ sky130_fd_sc_hd__or3_2
XFILLER_112_869 VPWR VGND VPWR VGND sky130_ef_sc_hd__decap_12
XFILLER_111_335 VGND VGND VPWR VPWR sky130_fd_sc_hd__fill_1
XFILLER_97_536 VPWR VGND VPWR VGND sky130_ef_sc_hd__decap_12
X_2261_ _1499_ _1504_ _1517_ VGND VGND VPWR VPWR _1518_ sky130_fd_sc_hd__a21oi_1
XTAP_TAPCELL_ROW_144_2641 VGND VPWR sky130_fd_sc_hd__tapvpwrvgnd_1
XTAP_TAPCELL_ROW_144_2630 VGND VPWR sky130_fd_sc_hd__tapvpwrvgnd_1
X_2192_ _1432_ _1440_ _1435_ VGND VGND VPWR VPWR _1449_ sky130_fd_sc_hd__a21oi_1
XFILLER_37_113 VPWR VGND VPWR VGND sky130_ef_sc_hd__decap_12
XFILLER_38_625 VPWR VGND VPWR VGND sky130_ef_sc_hd__decap_12
XFILLER_93_753 VPWR VGND VPWR VGND sky130_ef_sc_hd__decap_12
XFILLER_38_669 VPWR VGND VPWR VGND sky130_ef_sc_hd__decap_12
XANTENNA__1874__B1 A_reg\[4\] VGND VGND VPWR VPWR sky130_fd_sc_hd__diode_2
XFILLER_93_797 VPWR VGND VPWR VGND sky130_ef_sc_hd__decap_12
XFILLER_65_488 VPWR VGND VPWR VGND sky130_ef_sc_hd__decap_12
XFILLER_53_617 VPWR VGND VPWR VGND sky130_ef_sc_hd__decap_12
XANTENNA__3229__RESET_B net36 VGND VGND VPWR VPWR sky130_fd_sc_hd__diode_2
XFILLER_80_447 VGND VGND VPWR VPWR sky130_fd_sc_hd__fill_1
XFILLER_52_138 VGND VGND VPWR VPWR sky130_fd_sc_hd__fill_2
XFILLER_61_661 VGND VGND VPWR VPWR sky130_fd_sc_hd__fill_1
XFILLER_21_503 VGND VGND VPWR VPWR sky130_fd_sc_hd__fill_1
XTAP_TAPCELL_ROW_47_1086 VGND VPWR sky130_fd_sc_hd__tapvpwrvgnd_1
XTAP_TAPCELL_ROW_16_583 VGND VPWR sky130_fd_sc_hd__tapvpwrvgnd_1
XTAP_TAPCELL_ROW_16_594 VGND VPWR sky130_fd_sc_hd__tapvpwrvgnd_1
X_1976_ _1232_ _1238_ _1233_ VGND VGND VPWR VPWR _1241_ sky130_fd_sc_hd__a21o_1
XANTENNA__2841__S _0383_ VGND VGND VPWR VPWR sky130_fd_sc_hd__diode_2
XFILLER_146_221 VPWR VGND VPWR VGND sky130_ef_sc_hd__decap_12
XTAP_TAPCELL_ROW_60_1286 VGND VPWR sky130_fd_sc_hd__tapvpwrvgnd_1
XFILLER_147_777 VGND VGND VPWR VPWR sky130_fd_sc_hd__decap_6
XFILLER_146_265 VPWR VGND VPWR VGND sky130_ef_sc_hd__decap_12
XTAP_TAPCELL_ROW_60_1297 VGND VPWR sky130_fd_sc_hd__tapvpwrvgnd_1
XFILLER_150_909 VGND VGND VPWR VPWR sky130_fd_sc_hd__fill_1
XFILLER_115_641 VPWR VGND VPWR VGND sky130_ef_sc_hd__decap_12
XFILLER_115_685 VPWR VGND VPWR VGND sky130_ef_sc_hd__decap_12
XFILLER_88_525 VGND VGND VPWR VPWR sky130_fd_sc_hd__decap_6
X_2528_ _0234_ _0261_ _0267_ _0188_ VGND VGND VPWR VPWR _0276_ sky130_fd_sc_hd__a31o_1
XFILLER_114_195 VGND VGND VPWR VPWR sky130_fd_sc_hd__fill_1
XFILLER_29_15 VPWR VGND VPWR VGND sky130_ef_sc_hd__decap_12
XFILLER_152_27 VGND VGND VPWR VPWR sky130_fd_sc_hd__fill_1
XFILLER_102_357 VGND VGND VPWR VPWR sky130_fd_sc_hd__decap_6
X_2459_ _0198_ _0208_ _0199_ _0185_ VGND VGND VPWR VPWR _0209_ sky130_fd_sc_hd__a2bb2o_1
XFILLER_29_603 VPWR VGND VPWR VGND sky130_ef_sc_hd__decap_12
XFILLER_130_699 VGND VGND VPWR VPWR sky130_fd_sc_hd__fill_1
XFILLER_69_783 VGND VGND VPWR VPWR sky130_fd_sc_hd__fill_1
XFILLER_56_400 VGND VGND VPWR VPWR sky130_fd_sc_hd__fill_1
XTAP_TAPCELL_ROW_67_1407 VGND VPWR sky130_fd_sc_hd__tapvpwrvgnd_1
XFILLER_17_809 VPWR VGND VPWR VGND sky130_ef_sc_hd__decap_12
XANTENNA__1865__B1 A_reg\[6\] VGND VGND VPWR VPWR sky130_fd_sc_hd__diode_2
XFILLER_56_477 VPWR VGND VPWR VGND sky130_ef_sc_hd__decap_12
XFILLER_43_105 VGND VGND VPWR VPWR sky130_fd_sc_hd__decap_6
XFILLER_25_853 VPWR VGND VPWR VGND sky130_ef_sc_hd__decap_12
XFILLER_43_149 VPWR VGND VPWR VGND sky130_ef_sc_hd__decap_12
XFILLER_45_69 VPWR VGND VPWR VGND sky130_ef_sc_hd__decap_12
XTAP_TAPCELL_ROW_80_1618 VGND VPWR sky130_fd_sc_hd__tapvpwrvgnd_1
XTAP_TAPCELL_ROW_80_1607 VGND VPWR sky130_fd_sc_hd__tapvpwrvgnd_1
XFILLER_24_363 VGND VGND VPWR VPWR sky130_fd_sc_hd__fill_1
XFILLER_12_525 VGND VGND VPWR VPWR sky130_fd_sc_hd__decap_6
XFILLER_25_897 VPWR VGND VPWR VGND sky130_ef_sc_hd__decap_12
XTAP_TAPCELL_ROW_35_892 VGND VPWR sky130_fd_sc_hd__tapvpwrvgnd_1
XFILLER_61_57 VPWR VGND VPWR VGND sky130_ef_sc_hd__decap_12
XANTENNA__3222__CLK clknet_3_4__leaf_clk VGND VGND VPWR VPWR sky130_fd_sc_hd__diode_2
XFILLER_138_755 VGND VGND VPWR VPWR sky130_fd_sc_hd__fill_1
XFILLER_125_405 VPWR VGND VPWR VGND sky130_ef_sc_hd__decap_12
XFILLER_124_3 VPWR VGND VPWR VGND sky130_ef_sc_hd__decap_12
XFILLER_153_725 VGND VGND VPWR VPWR sky130_fd_sc_hd__decap_3
XTAP_TAPCELL_ROW_95_1850 VGND VPWR sky130_fd_sc_hd__tapvpwrvgnd_1
XFILLER_4_713 VPWR VGND VPWR VGND sky130_ef_sc_hd__decap_12
XFILLER_153_769 VPWR VGND VPWR VGND sky130_ef_sc_hd__decap_12
XFILLER_141_909 VGND VGND VPWR VPWR sky130_fd_sc_hd__fill_1
XFILLER_125_449 VPWR VGND VPWR VGND sky130_ef_sc_hd__decap_12
XTAP_TAPCELL_ROW_111_2106 VGND VPWR sky130_fd_sc_hd__tapvpwrvgnd_1
XFILLER_4_757 VPWR VGND VPWR VGND sky130_ef_sc_hd__decap_12
XFILLER_3_223 VGND VGND VPWR VPWR sky130_fd_sc_hd__fill_1
XFILLER_140_419 VGND VGND VPWR VPWR sky130_fd_sc_hd__fill_1
XFILLER_79_503 VGND VGND VPWR VPWR sky130_fd_sc_hd__fill_1
XFILLER_120_121 VPWR VGND VPWR VGND sky130_ef_sc_hd__decap_12
XFILLER_10_83 VGND VGND VPWR VPWR sky130_fd_sc_hd__fill_1
XFILLER_126_83 VGND VGND VPWR VPWR sky130_fd_sc_hd__fill_1
XFILLER_86_65 VPWR VGND VPWR VGND sky130_ef_sc_hd__decap_12
XFILLER_120_165 VPWR VGND VPWR VGND sky130_ef_sc_hd__decap_12
XFILLER_75_720 VGND VGND VPWR VPWR sky130_fd_sc_hd__decap_8
XFILLER_19_113 VPWR VGND VPWR VGND sky130_ef_sc_hd__decap_12
XTAP_TAPCELL_ROW_109_2079 VGND VPWR sky130_fd_sc_hd__tapvpwrvgnd_1
XTAP_TAPCELL_ROW_109_2068 VGND VPWR sky130_fd_sc_hd__tapvpwrvgnd_1
XFILLER_19_81 VPWR VGND VPWR VGND sky130_ef_sc_hd__decap_12
XFILLER_90_701 VPWR VGND VPWR VGND sky130_ef_sc_hd__decap_12
XFILLER_75_797 VPWR VGND VPWR VGND sky130_ef_sc_hd__decap_12
XFILLER_35_617 VPWR VGND VPWR VGND sky130_ef_sc_hd__decap_12
XTAP_TAPCELL_ROW_122_2279 VGND VPWR sky130_fd_sc_hd__tapvpwrvgnd_1
XFILLER_43_650 VPWR VGND VPWR VGND sky130_ef_sc_hd__decap_12
XFILLER_70_491 VPWR VGND VPWR VGND sky130_ef_sc_hd__decap_12
XFILLER_30_311 VPWR VGND VPWR VGND sky130_ef_sc_hd__decap_12
XTAP_TAPCELL_ROW_104_1990 VGND VPWR sky130_fd_sc_hd__tapvpwrvgnd_1
XTAP_TAPCELL_ROW_13_542 VGND VPWR sky130_fd_sc_hd__tapvpwrvgnd_1
X_1830_ _1095_ _1098_ _1100_ _1094_ VGND VGND VPWR VPWR _1103_ sky130_fd_sc_hd__a22o_1
XFILLER_128_221 VPWR VGND VPWR VGND sky130_ef_sc_hd__decap_12
XFILLER_129_777 VGND VGND VPWR VPWR sky130_fd_sc_hd__decap_6
X_1761_ _1021_ _1026_ _1022_ _0889_ VGND VGND VPWR VPWR _1034_ sky130_fd_sc_hd__o211a_1
XFILLER_144_725 VPWR VGND VPWR VGND sky130_ef_sc_hd__decap_12
XFILLER_128_265 VPWR VGND VPWR VGND sky130_ef_sc_hd__decap_12
X_1692_ _0894_ _0966_ VGND VGND VPWR VPWR _0968_ sky130_fd_sc_hd__and2_1
XFILLER_144_769 VPWR VGND VPWR VGND sky130_ef_sc_hd__decap_12
XFILLER_132_909 VGND VGND VPWR VPWR sky130_fd_sc_hd__fill_1
XFILLER_143_279 VGND VGND VPWR VPWR sky130_fd_sc_hd__fill_1
XFILLER_98_867 VGND VGND VPWR VPWR sky130_fd_sc_hd__fill_1
XFILLER_97_333 VGND VGND VPWR VPWR sky130_fd_sc_hd__decap_3
X_2313_ _1563_ _1564_ _1559_ VGND VGND VPWR VPWR _1566_ sky130_fd_sc_hd__a21o_1
X_3293_ clknet_3_2__leaf_clk _0076_ net36 VGND VGND VPWR VPWR B_reg\[3\] sky130_fd_sc_hd__dfrtp_4
XFILLER_112_699 VGND VGND VPWR VPWR sky130_fd_sc_hd__fill_1
XFILLER_85_528 VPWR VGND VPWR VGND sky130_ef_sc_hd__decap_12
X_2244_ A_reg\[4\] _1488_ _1496_ VGND VGND VPWR VPWR _1501_ sky130_fd_sc_hd__and3_1
XANTENNA__2836__S _0383_ VGND VGND VPWR VPWR sky130_fd_sc_hd__diode_2
XFILLER_66_742 VPWR VGND VPWR VGND sky130_ef_sc_hd__decap_12
XFILLER_54_904 VGND VGND VPWR VPWR sky130_fd_sc_hd__decap_6
X_2175_ A_reg\[9\] _1431_ VGND VGND VPWR VPWR _1432_ sky130_fd_sc_hd__nand2_1
XFILLER_38_433 VGND VGND VPWR VPWR sky130_fd_sc_hd__decap_6
XFILLER_93_561 VPWR VGND VPWR VGND sky130_ef_sc_hd__decap_12
XFILLER_65_252 VPWR VGND VPWR VGND sky130_ef_sc_hd__decap_12
XTAP_TAPCELL_ROW_49_1115 VGND VPWR sky130_fd_sc_hd__tapvpwrvgnd_1
XFILLER_25_105 VGND VGND VPWR VPWR sky130_fd_sc_hd__decap_6
XFILLER_38_466 VGND VGND VPWR VPWR sky130_fd_sc_hd__fill_1
XANTENNA__3245__CLK clknet_3_6__leaf_clk VGND VGND VPWR VPWR sky130_fd_sc_hd__diode_2
XFILLER_25_149 VPWR VGND VPWR VGND sky130_ef_sc_hd__decap_12
XFILLER_15_39 VPWR VGND VPWR VGND sky130_ef_sc_hd__decap_12
XFILLER_41_609 VGND VGND VPWR VPWR sky130_fd_sc_hd__decap_6
XFILLER_80_277 VPWR VGND VPWR VGND sky130_ef_sc_hd__decap_12
XTAP_TAPCELL_ROW_62_1326 VGND VPWR sky130_fd_sc_hd__tapvpwrvgnd_1
XFILLER_22_867 VGND VGND VPWR VPWR sky130_fd_sc_hd__fill_1
XTAP_TAPCELL_ROW_32_840 VGND VPWR sky130_fd_sc_hd__tapvpwrvgnd_1
XTAP_TAPCELL_ROW_32_851 VGND VPWR sky130_fd_sc_hd__tapvpwrvgnd_1
XFILLER_33_193 VPWR VGND VPWR VGND sky130_ef_sc_hd__decap_12
XFILLER_147_541 VPWR VGND VPWR VGND sky130_ef_sc_hd__decap_12
X_1959_ _1215_ _1223_ VGND VGND VPWR VPWR _1224_ sky130_fd_sc_hd__and2_1
XFILLER_31_27 VPWR VGND VPWR VGND sky130_ef_sc_hd__decap_12
XFILLER_147_585 VPWR VGND VPWR VGND sky130_ef_sc_hd__decap_12
XFILLER_147_27 VPWR VGND VPWR VGND sky130_ef_sc_hd__decap_12
XFILLER_107_416 VGND VGND VPWR VPWR sky130_fd_sc_hd__decap_3
XFILLER_123_909 VGND VGND VPWR VPWR sky130_fd_sc_hd__fill_1
XFILLER_107_449 VGND VGND VPWR VPWR sky130_fd_sc_hd__fill_1
XFILLER_122_419 VGND VGND VPWR VPWR sky130_fd_sc_hd__fill_1
XFILLER_103_600 VPWR VGND VPWR VGND sky130_ef_sc_hd__decap_12
Xoutput38 net38 VGND VGND VPWR VPWR X_out[0] sky130_fd_sc_hd__buf_1
Xoutput49 net49 VGND VGND VPWR VPWR X_out[5] sky130_fd_sc_hd__buf_1
XFILLER_1_727 VGND VGND VPWR VPWR sky130_fd_sc_hd__fill_1
XFILLER_88_333 VPWR VGND VPWR VGND sky130_ef_sc_hd__decap_12
XFILLER_0_237 VGND VGND VPWR VPWR sky130_fd_sc_hd__decap_8
XFILLER_102_121 VPWR VGND VPWR VGND sky130_ef_sc_hd__decap_12
XFILLER_89_889 VGND VGND VPWR VPWR sky130_fd_sc_hd__decap_6
XFILLER_88_377 VGND VGND VPWR VPWR sky130_fd_sc_hd__decap_6
XTAP_TAPCELL_ROW_73_1499 VGND VPWR sky130_fd_sc_hd__tapvpwrvgnd_1
XFILLER_102_165 VPWR VGND VPWR VGND sky130_ef_sc_hd__decap_12
XFILLER_57_753 VPWR VGND VPWR VGND sky130_ef_sc_hd__decap_12
XFILLER_84_550 VPWR VGND VPWR VGND sky130_ef_sc_hd__decap_12
XFILLER_72_701 VPWR VGND VPWR VGND sky130_ef_sc_hd__decap_12
XPHY_EDGE_ROW_16_Left_170 VGND VGND VPWR VPWR sky130_fd_sc_hd__decap_3
XFILLER_17_617 VPWR VGND VPWR VGND sky130_ef_sc_hd__decap_12
XFILLER_112_41 VPWR VGND VPWR VGND sky130_ef_sc_hd__decap_12
XFILLER_112_85 VPWR VGND VPWR VGND sky130_ef_sc_hd__decap_12
XANTENNA__2047__A B_reg\[6\] VGND VGND VPWR VPWR sky130_fd_sc_hd__diode_2
XFILLER_72_789 VPWR VGND VPWR VGND sky130_ef_sc_hd__decap_12
XFILLER_44_469 VGND VGND VPWR VPWR sky130_fd_sc_hd__decap_6
XFILLER_12_377 VPWR VGND VPWR VGND sky130_ef_sc_hd__decap_12
XFILLER_13_889 VGND VGND VPWR VPWR sky130_fd_sc_hd__decap_6
XFILLER_40_664 VPWR VGND VPWR VGND sky130_ef_sc_hd__decap_12
XFILLER_126_725 VPWR VGND VPWR VGND sky130_ef_sc_hd__decap_12
XFILLER_153_533 VPWR VGND VPWR VGND sky130_ef_sc_hd__decap_12
XFILLER_126_769 VPWR VGND VPWR VGND sky130_ef_sc_hd__decap_12
XFILLER_114_909 VGND VGND VPWR VPWR sky130_fd_sc_hd__fill_1
XFILLER_125_279 VGND VGND VPWR VPWR sky130_fd_sc_hd__fill_1
XFILLER_97_20 VPWR VGND VPWR VGND sky130_ef_sc_hd__decap_12
XFILLER_21_93 VPWR VGND VPWR VGND sky130_ef_sc_hd__decap_12
XFILLER_137_93 VPWR VGND VPWR VGND sky130_ef_sc_hd__decap_12
XFILLER_121_441 VGND VGND VPWR VPWR sky130_fd_sc_hd__decap_6
XFILLER_121_485 VPWR VGND VPWR VGND sky130_ef_sc_hd__decap_12
XFILLER_67_517 VPWR VGND VPWR VGND sky130_ef_sc_hd__decap_12
XFILLER_153_81 VGND VGND VPWR VPWR sky130_fd_sc_hd__decap_3
XTAP_TAPCELL_ROW_124_2319 VGND VPWR sky130_fd_sc_hd__tapvpwrvgnd_1
XTAP_TAPCELL_ROW_124_2308 VGND VPWR sky130_fd_sc_hd__tapvpwrvgnd_1
XANTENNA__3268__CLK clknet_3_6__leaf_clk VGND VGND VPWR VPWR sky130_fd_sc_hd__diode_2
XFILLER_48_753 VGND VGND VPWR VPWR sky130_fd_sc_hd__decap_3
XFILLER_48_731 VGND VGND VPWR VPWR sky130_fd_sc_hd__fill_1
XFILLER_75_561 VPWR VGND VPWR VGND sky130_ef_sc_hd__decap_12
XFILLER_90_531 VGND VGND VPWR VPWR sky130_fd_sc_hd__fill_1
XTAP_TAPCELL_ROW_18_612 VGND VPWR sky130_fd_sc_hd__tapvpwrvgnd_1
XTAP_TAPCELL_ROW_18_623 VGND VPWR sky130_fd_sc_hd__tapvpwrvgnd_1
XFILLER_35_447 VGND VGND VPWR VPWR sky130_fd_sc_hd__fill_1
XFILLER_23_609 VGND VGND VPWR VPWR sky130_fd_sc_hd__decap_6
X_2931_ _0605_ _0617_ VGND VGND VPWR VPWR _0619_ sky130_fd_sc_hd__xnor2_1
XFILLER_149_839 VGND VGND VPWR VPWR sky130_fd_sc_hd__fill_1
Xclkbuf_0_clk clk VGND VGND VPWR VPWR clknet_0_clk sky130_fd_sc_hd__clkbuf_16
XFILLER_15_193 VPWR VGND VPWR VGND sky130_ef_sc_hd__decap_12
XFILLER_31_631 VPWR VGND VPWR VGND sky130_ef_sc_hd__decap_12
XFILLER_43_491 VGND VGND VPWR VPWR sky130_fd_sc_hd__fill_1
XTAP_TAPCELL_ROW_44_1034 VGND VPWR sky130_fd_sc_hd__tapvpwrvgnd_1
XTAP_TAPCELL_ROW_139_2562 VGND VPWR sky130_fd_sc_hd__tapvpwrvgnd_1
XTAP_TAPCELL_ROW_139_2551 VGND VPWR sky130_fd_sc_hd__tapvpwrvgnd_1
XFILLER_87_3 VPWR VGND VPWR VGND sky130_ef_sc_hd__decap_12
X_2862_ net20 B_reg\[12\] _0383_ VGND VGND VPWR VPWR _0085_ sky130_fd_sc_hd__mux2_1
XFILLER_30_141 VPWR VGND VPWR VGND sky130_ef_sc_hd__decap_12
XFILLER_31_697 VPWR VGND VPWR VGND sky130_ef_sc_hd__decap_12
XFILLER_129_541 VPWR VGND VPWR VGND sky130_ef_sc_hd__decap_12
X_2793_ _0420_ _0531_ VGND VGND VPWR VPWR _0533_ sky130_fd_sc_hd__or2_1
X_1813_ A_reg\[2\] _1085_ VGND VGND VPWR VPWR _1086_ sky130_fd_sc_hd__nor2_1
XFILLER_129_585 VPWR VGND VPWR VGND sky130_ef_sc_hd__decap_12
XFILLER_7_51 VGND VGND VPWR VPWR sky130_fd_sc_hd__decap_4
X_1744_ A_reg\[12\] _1007_ _1008_ VGND VGND VPWR VPWR _1017_ sky130_fd_sc_hd__or3_1
XTAP_TAPCELL_ROW_152_2762 VGND VPWR sky130_fd_sc_hd__tapvpwrvgnd_1
XFILLER_144_533 VPWR VGND VPWR VGND sky130_ef_sc_hd__decap_12
XFILLER_105_909 VGND VGND VPWR VPWR sky130_fd_sc_hd__fill_1
XFILLER_8_893 VPWR VGND VPWR VGND sky130_ef_sc_hd__decap_12
XFILLER_131_205 VPWR VGND VPWR VGND sky130_ef_sc_hd__decap_12
XFILLER_104_419 VGND VGND VPWR VPWR sky130_fd_sc_hd__fill_1
XFILLER_89_119 VGND VGND VPWR VPWR sky130_fd_sc_hd__decap_6
X_1675_ _0891_ _0949_ _0950_ _0945_ VGND VGND VPWR VPWR _0951_ sky130_fd_sc_hd__o31a_1
XPHY_EDGE_ROW_15_Right_15 VGND VGND VPWR VPWR sky130_fd_sc_hd__decap_3
XFILLER_131_249 VPWR VGND VPWR VGND sky130_ef_sc_hd__decap_12
XFILLER_100_625 VPWR VGND VPWR VGND sky130_ef_sc_hd__decap_12
XFILLER_86_837 VPWR VGND VPWR VGND sky130_ef_sc_hd__decap_12
X_3276_ clknet_3_0__leaf_clk _0059_ net36 VGND VGND VPWR VPWR A_reg\[2\] sky130_fd_sc_hd__dfrtp_4
XANTENNA_clkbuf_3_6__f_clk_X clknet_3_6__leaf_clk VGND VGND VPWR VPWR sky130_fd_sc_hd__diode_2
XANTENNA__3244__RESET_B net36 VGND VGND VPWR VPWR sky130_fd_sc_hd__diode_2
XFILLER_100_669 VPWR VGND VPWR VGND sky130_ef_sc_hd__decap_12
X_2227_ _1473_ _1471_ VGND VGND VPWR VPWR _1484_ sky130_fd_sc_hd__and2b_1
XFILLER_94_881 VPWR VGND VPWR VGND sky130_ef_sc_hd__decap_12
XFILLER_54_701 VPWR VGND VPWR VGND sky130_ef_sc_hd__decap_12
XFILLER_39_797 VPWR VGND VPWR VGND sky130_ef_sc_hd__decap_12
X_2158_ _0923_ _0925_ _1413_ _1414_ VGND VGND VPWR VPWR _1415_ sky130_fd_sc_hd__a2bb2o_2
XFILLER_26_27 VGND VGND VPWR VPWR sky130_fd_sc_hd__fill_1
XTAP_TAPCELL_ROW_37_921 VGND VPWR sky130_fd_sc_hd__tapvpwrvgnd_1
X_2089_ B_reg\[0\] _1349_ _0911_ VGND VGND VPWR VPWR _1351_ sky130_fd_sc_hd__a21oi_1
XFILLER_53_233 VGND VGND VPWR VPWR sky130_fd_sc_hd__fill_2
XPHY_EDGE_ROW_24_Right_24 VGND VGND VPWR VPWR sky130_fd_sc_hd__decap_3
XFILLER_26_469 VGND VGND VPWR VPWR sky130_fd_sc_hd__decap_6
XFILLER_81_597 VGND VGND VPWR VPWR sky130_fd_sc_hd__fill_2
XFILLER_139_305 VPWR VGND VPWR VGND sky130_ef_sc_hd__decap_12
XFILLER_42_15 VPWR VGND VPWR VGND sky130_ef_sc_hd__decap_12
XFILLER_148_861 VGND VGND VPWR VPWR sky130_fd_sc_hd__decap_6
XFILLER_139_349 VPWR VGND VPWR VGND sky130_ef_sc_hd__decap_12
XFILLER_10_837 VPWR VGND VPWR VGND sky130_ef_sc_hd__decap_12
XFILLER_108_725 VPWR VGND VPWR VGND sky130_ef_sc_hd__decap_12
XFILLER_147_393 VPWR VGND VPWR VGND sky130_ef_sc_hd__decap_12
XFILLER_108_769 VPWR VGND VPWR VGND sky130_ef_sc_hd__decap_12
XFILLER_107_279 VGND VGND VPWR VPWR sky130_fd_sc_hd__fill_1
XTAP_TAPCELL_ROW_75_1539 VGND VPWR sky130_fd_sc_hd__tapvpwrvgnd_1
XTAP_TAPCELL_ROW_75_1528 VGND VPWR sky130_fd_sc_hd__tapvpwrvgnd_1
XPHY_EDGE_ROW_33_Right_33 VGND VGND VPWR VPWR sky130_fd_sc_hd__decap_3
XFILLER_150_525 VGND VGND VPWR VPWR sky130_fd_sc_hd__decap_6
XFILLER_150_569 VPWR VGND VPWR VGND sky130_ef_sc_hd__decap_12
XFILLER_89_653 VPWR VGND VPWR VGND sky130_ef_sc_hd__decap_12
XFILLER_88_141 VPWR VGND VPWR VGND sky130_ef_sc_hd__decap_12
XFILLER_131_783 VGND VGND VPWR VPWR sky130_fd_sc_hd__fill_1
XFILLER_103_485 VPWR VGND VPWR VGND sky130_ef_sc_hd__decap_12
XANTENNA__2720__A1 _0188_ VGND VGND VPWR VPWR sky130_fd_sc_hd__diode_2
XFILLER_89_697 VPWR VGND VPWR VGND sky130_ef_sc_hd__decap_12
XFILLER_49_517 VPWR VGND VPWR VGND sky130_ef_sc_hd__decap_12
XFILLER_123_51 VGND VGND VPWR VPWR sky130_fd_sc_hd__decap_4
XTAP_TAPCELL_ROW_106_2027 VGND VPWR sky130_fd_sc_hd__tapvpwrvgnd_1
XFILLER_91_317 VPWR VGND VPWR VGND sky130_ef_sc_hd__decap_12
XFILLER_57_561 VPWR VGND VPWR VGND sky130_ef_sc_hd__decap_12
XTAP_TAPCELL_ROW_4_395 VGND VPWR sky130_fd_sc_hd__tapvpwrvgnd_1
XPHY_EDGE_ROW_42_Right_42 VGND VGND VPWR VPWR sky130_fd_sc_hd__decap_3
XFILLER_45_723 VGND VGND VPWR VPWR sky130_fd_sc_hd__decap_4
XFILLER_83_77 VPWR VGND VPWR VGND sky130_ef_sc_hd__decap_12
XFILLER_44_233 VPWR VGND VPWR VGND sky130_ef_sc_hd__decap_12
XFILLER_45_778 VGND VGND VPWR VPWR sky130_fd_sc_hd__decap_6
XFILLER_60_737 VPWR VGND VPWR VGND sky130_ef_sc_hd__decap_12
XFILLER_44_277 VPWR VGND VPWR VGND sky130_ef_sc_hd__decap_12
XFILLER_13_653 VPWR VGND VPWR VGND sky130_ef_sc_hd__decap_12
XFILLER_12_141 VPWR VGND VPWR VGND sky130_ef_sc_hd__decap_12
XFILLER_13_697 VPWR VGND VPWR VGND sky130_ef_sc_hd__decap_12
XTAP_TAPCELL_ROW_23_692 VGND VPWR sky130_fd_sc_hd__tapvpwrvgnd_1
XPHY_EDGE_ROW_51_Right_51 VGND VGND VPWR VPWR sky130_fd_sc_hd__decap_3
XTAP_TAPCELL_ROW_134_2470 VGND VPWR sky130_fd_sc_hd__tapvpwrvgnd_1
XFILLER_126_533 VPWR VGND VPWR VGND sky130_ef_sc_hd__decap_12
XFILLER_8_189 VGND VGND VPWR VPWR sky130_fd_sc_hd__decap_6
XFILLER_5_841 VPWR VGND VPWR VGND sky130_ef_sc_hd__decap_12
XANTENNA__3200__A2 CRT_Start VGND VGND VPWR VPWR sky130_fd_sc_hd__diode_2
XFILLER_141_503 VGND VGND VPWR VPWR sky130_fd_sc_hd__fill_1
XPHY_EDGE_ROW_136_Right_136 VGND VGND VPWR VPWR sky130_fd_sc_hd__decap_3
XTAP_TAPCELL_ROW_134_2481 VGND VPWR sky130_fd_sc_hd__tapvpwrvgnd_1
XFILLER_113_205 VPWR VGND VPWR VGND sky130_ef_sc_hd__decap_12
XFILLER_99_417 VPWR VGND VPWR VGND sky130_ef_sc_hd__decap_12
XFILLER_113_249 VPWR VGND VPWR VGND sky130_ef_sc_hd__decap_12
XFILLER_4_395 VPWR VGND VPWR VGND sky130_ef_sc_hd__decap_12
XFILLER_68_837 VPWR VGND VPWR VGND sky130_ef_sc_hd__decap_12
XFILLER_67_325 VGND VGND VPWR VPWR sky130_fd_sc_hd__fill_2
X_3130_ _0797_ _0799_ _0780_ VGND VGND VPWR VPWR _0818_ sky130_fd_sc_hd__o21a_1
XFILLER_121_293 VPWR VGND VPWR VGND sky130_ef_sc_hd__decap_12
XFILLER_76_881 VPWR VGND VPWR VGND sky130_ef_sc_hd__decap_12
XPHY_EDGE_ROW_60_Right_60 VGND VGND VPWR VPWR sky130_fd_sc_hd__decap_3
XFILLER_36_701 VPWR VGND VPWR VGND sky130_ef_sc_hd__decap_12
X_3061_ _0747_ _0748_ VGND VGND VPWR VPWR _0749_ sky130_fd_sc_hd__or2_1
XFILLER_94_188 VGND VGND VPWR VPWR sky130_fd_sc_hd__decap_8
XFILLER_75_391 VGND VGND VPWR VPWR sky130_fd_sc_hd__fill_1
X_2012_ _1269_ _1273_ VGND VGND VPWR VPWR _1274_ sky130_fd_sc_hd__nor2_1
XFILLER_63_542 VPWR VGND VPWR VGND sky130_ef_sc_hd__decap_12
XFILLER_91_895 VGND VGND VPWR VPWR sky130_fd_sc_hd__fill_1
XFILLER_63_597 VPWR VGND VPWR VGND sky130_ef_sc_hd__decap_12
XFILLER_51_726 VGND VGND VPWR VPWR sky130_fd_sc_hd__fill_2
XFILLER_23_439 VGND VGND VPWR VPWR sky130_fd_sc_hd__decap_8
XFILLER_90_394 VPWR VGND VPWR VGND sky130_ef_sc_hd__decap_12
XFILLER_50_236 VPWR VGND VPWR VGND sky130_ef_sc_hd__decap_12
X_2914_ _0587_ _0600_ VGND VGND VPWR VPWR _0602_ sky130_fd_sc_hd__xor2_1
XFILLER_31_461 VPWR VGND VPWR VGND sky130_ef_sc_hd__decap_12
XFILLER_137_809 VPWR VGND VPWR VGND sky130_ef_sc_hd__decap_12
X_2845_ net3 A_reg\[11\] _0383_ VGND VGND VPWR VPWR _0068_ sky130_fd_sc_hd__mux2_1
XFILLER_12_29 VPWR VGND VPWR VGND sky130_ef_sc_hd__decap_12
XFILLER_145_853 VPWR VGND VPWR VGND sky130_ef_sc_hd__decap_12
XFILLER_129_393 VPWR VGND VPWR VGND sky130_ef_sc_hd__decap_12
XFILLER_128_29 VPWR VGND VPWR VGND sky130_ef_sc_hd__decap_12
X_2776_ _0499_ _0506_ _0515_ VGND VGND VPWR VPWR _0516_ sky130_fd_sc_hd__o21ai_1
XFILLER_145_897 VPWR VGND VPWR VGND sky130_ef_sc_hd__decap_12
XFILLER_144_363 VGND VGND VPWR VPWR sky130_fd_sc_hd__fill_1
XPHY_EDGE_ROW_103_Right_103 VGND VGND VPWR VPWR sky130_fd_sc_hd__decap_3
X_1727_ a_r2\[0\] _0911_ _0999_ _1002_ VGND VGND VPWR VPWR _0000_ sky130_fd_sc_hd__a22o_1
XTAP_TAPCELL_ROW_57_1236 VGND VPWR sky130_fd_sc_hd__tapvpwrvgnd_1
XFILLER_132_525 VGND VGND VPWR VPWR sky130_fd_sc_hd__decap_6
XTAP_TAPCELL_ROW_57_1247 VGND VPWR sky130_fd_sc_hd__tapvpwrvgnd_1
X_1658_ _0933_ VGND VGND VPWR VPWR _0934_ sky130_fd_sc_hd__inv_2
XFILLER_132_569 VPWR VGND VPWR VGND sky130_ef_sc_hd__decap_12
XFILLER_113_783 VGND VGND VPWR VPWR sky130_fd_sc_hd__fill_1
XFILLER_100_411 VGND VGND VPWR VPWR sky130_fd_sc_hd__decap_8
XTAP_TAPCELL_ROW_70_1447 VGND VPWR sky130_fd_sc_hd__tapvpwrvgnd_1
XFILLER_100_433 VGND VGND VPWR VPWR sky130_fd_sc_hd__decap_3
XFILLER_86_645 VGND VGND VPWR VPWR sky130_fd_sc_hd__decap_6
XFILLER_85_111 VGND VGND VPWR VPWR sky130_fd_sc_hd__fill_1
XTAP_TAPCELL_ROW_70_1458 VGND VPWR sky130_fd_sc_hd__tapvpwrvgnd_1
XFILLER_37_15 VPWR VGND VPWR VGND sky130_ef_sc_hd__decap_12
XFILLER_100_466 VGND VGND VPWR VPWR sky130_fd_sc_hd__fill_1
XFILLER_73_317 VPWR VGND VPWR VGND sky130_ef_sc_hd__decap_12
X_3259_ clknet_3_7__leaf_clk _0042_ net36 VGND VGND VPWR VPWR net45 sky130_fd_sc_hd__dfrtp_1
XFILLER_39_561 VPWR VGND VPWR VGND sky130_ef_sc_hd__decap_12
XFILLER_85_188 VPWR VGND VPWR VGND sky130_ef_sc_hd__decap_12
XFILLER_54_531 VGND VGND VPWR VPWR sky130_fd_sc_hd__fill_1
XTAP_TAPCELL_ROW_1_343 VGND VPWR sky130_fd_sc_hd__tapvpwrvgnd_1
XFILLER_54_564 VPWR VGND VPWR VGND sky130_ef_sc_hd__decap_12
XTAP_TAPCELL_ROW_1_354 VGND VPWR sky130_fd_sc_hd__tapvpwrvgnd_1
XFILLER_81_361 VPWR VGND VPWR VGND sky130_ef_sc_hd__decap_12
XFILLER_42_726 VGND VGND VPWR VPWR sky130_fd_sc_hd__decap_4
XTAP_TAPCELL_ROW_85_1690 VGND VPWR sky130_fd_sc_hd__tapvpwrvgnd_1
XFILLER_53_69 VGND VGND VPWR VPWR sky130_fd_sc_hd__fill_2
XFILLER_139_113 VPWR VGND VPWR VGND sky130_ef_sc_hd__decap_12
XFILLER_10_601 VPWR VGND VPWR VGND sky130_ef_sc_hd__decap_12
XFILLER_41_258 VPWR VGND VPWR VGND sky130_ef_sc_hd__decap_12
XFILLER_50_781 VGND VGND VPWR VPWR sky130_fd_sc_hd__fill_2
XFILLER_10_645 VPWR VGND VPWR VGND sky130_ef_sc_hd__decap_12
XFILLER_22_472 VGND VGND VPWR VPWR sky130_fd_sc_hd__decap_4
XANTENNA__1992__A2 _0911_ VGND VGND VPWR VPWR sky130_fd_sc_hd__diode_2
XFILLER_6_605 VPWR VGND VPWR VGND sky130_ef_sc_hd__decap_12
XTAP_TAPCELL_ROW_20_651 VGND VPWR sky130_fd_sc_hd__tapvpwrvgnd_1
XFILLER_108_544 VPWR VGND VPWR VGND sky130_ef_sc_hd__decap_12
XFILLER_108_533 VGND VGND VPWR VPWR sky130_fd_sc_hd__fill_2
XFILLER_5_137 VPWR VGND VPWR VGND sky130_ef_sc_hd__decap_12
XFILLER_123_503 VGND VGND VPWR VPWR sky130_fd_sc_hd__fill_1
XANTENNA__2698__C b_r3\[3\] VGND VGND VPWR VPWR sky130_fd_sc_hd__diode_2
XFILLER_135_385 VGND VGND VPWR VPWR sky130_fd_sc_hd__decap_6
XFILLER_2_811 VGND VGND VPWR VPWR sky130_fd_sc_hd__fill_1
XFILLER_151_889 VGND VGND VPWR VPWR sky130_fd_sc_hd__decap_6
XFILLER_150_333 VPWR VGND VPWR VGND sky130_ef_sc_hd__decap_12
XFILLER_111_709 VPWR VGND VPWR VGND sky130_ef_sc_hd__decap_12
XFILLER_78_66 VPWR VGND VPWR VGND sky130_ef_sc_hd__decap_12
XTAP_TAPCELL_ROW_9_476 VGND VPWR sky130_fd_sc_hd__tapvpwrvgnd_1
XFILLER_150_377 VPWR VGND VPWR VGND sky130_ef_sc_hd__decap_12
XFILLER_89_461 VPWR VGND VPWR VGND sky130_ef_sc_hd__decap_12
XFILLER_103_293 VPWR VGND VPWR VGND sky130_ef_sc_hd__decap_12
XFILLER_134_83 VGND VGND VPWR VPWR sky130_fd_sc_hd__fill_1
XFILLER_18_701 VPWR VGND VPWR VGND sky130_ef_sc_hd__decap_12
XFILLER_76_177 VPWR VGND VPWR VGND sky130_ef_sc_hd__decap_12
XFILLER_58_881 VPWR VGND VPWR VGND sky130_ef_sc_hd__decap_12
XFILLER_57_391 VGND VGND VPWR VPWR sky130_fd_sc_hd__fill_1
XFILLER_27_81 VPWR VGND VPWR VGND sky130_ef_sc_hd__decap_12
XFILLER_73_895 VGND VGND VPWR VPWR sky130_fd_sc_hd__fill_1
XFILLER_60_501 VPWR VGND VPWR VGND sky130_ef_sc_hd__decap_12
XTAP_TAPCELL_ROW_28_773 VGND VPWR sky130_fd_sc_hd__tapvpwrvgnd_1
XTAP_TAPCELL_ROW_28_784 VGND VPWR sky130_fd_sc_hd__tapvpwrvgnd_1
XFILLER_45_575 VPWR VGND VPWR VGND sky130_ef_sc_hd__decap_12
XANTENNA__3306__CLK clknet_3_7__leaf_clk VGND VGND VPWR VPWR sky130_fd_sc_hd__diode_2
XFILLER_60_545 VPWR VGND VPWR VGND sky130_ef_sc_hd__decap_12
XFILLER_60_589 VPWR VGND VPWR VGND sky130_ef_sc_hd__decap_12
XTAP_TAPCELL_ROW_136_2510 VGND VPWR sky130_fd_sc_hd__tapvpwrvgnd_1
XFILLER_119_809 VPWR VGND VPWR VGND sky130_ef_sc_hd__decap_12
XTAP_TAPCELL_ROW_119_2229 VGND VPWR sky130_fd_sc_hd__tapvpwrvgnd_1
XFILLER_145_105 VGND VGND VPWR VPWR sky130_fd_sc_hd__decap_6
X_2630_ _0346_ _0355_ _0365_ _0353_ VGND VGND VPWR VPWR _0375_ sky130_fd_sc_hd__o211a_1
XFILLER_40_291 VGND VGND VPWR VPWR sky130_fd_sc_hd__fill_1
XFILLER_145_149 VPWR VGND VPWR VGND sky130_ef_sc_hd__decap_12
XFILLER_127_853 VPWR VGND VPWR VGND sky130_ef_sc_hd__decap_12
XFILLER_126_363 VGND VGND VPWR VPWR sky130_fd_sc_hd__fill_1
X_2561_ a_r2\[1\] b_r2\[1\] VGND VGND VPWR VPWR _0306_ sky130_fd_sc_hd__and2_1
XFILLER_127_897 VPWR VGND VPWR VGND sky130_ef_sc_hd__decap_12
XFILLER_114_525 VGND VGND VPWR VPWR sky130_fd_sc_hd__decap_6
XFILLER_99_214 VGND VGND VPWR VPWR sky130_fd_sc_hd__decap_8
X_2492_ _0238_ _0239_ VGND VGND VPWR VPWR _0240_ sky130_fd_sc_hd__nand2_1
XFILLER_5_671 VGND VGND VPWR VPWR sky130_fd_sc_hd__fill_1
XFILLER_153_193 VGND VGND VPWR VPWR sky130_fd_sc_hd__decap_3
XFILLER_142_867 VGND VGND VPWR VPWR sky130_fd_sc_hd__fill_1
XFILLER_114_569 VPWR VGND VPWR VGND sky130_ef_sc_hd__decap_12
XFILLER_99_269 VGND VGND VPWR VPWR sky130_fd_sc_hd__fill_1
XFILLER_4_41 VPWR VGND VPWR VGND sky130_ef_sc_hd__decap_12
XFILLER_68_601 VPWR VGND VPWR VGND sky130_ef_sc_hd__decap_12
XFILLER_4_85 VPWR VGND VPWR VGND sky130_ef_sc_hd__decap_12
XFILLER_68_645 VPWR VGND VPWR VGND sky130_ef_sc_hd__decap_12
XFILLER_67_111 VGND VGND VPWR VPWR sky130_fd_sc_hd__fill_1
XTAP_TAPCELL_ROW_52_1166 VGND VPWR sky130_fd_sc_hd__tapvpwrvgnd_1
XTAP_TAPCELL_ROW_147_2683 VGND VPWR sky130_fd_sc_hd__tapvpwrvgnd_1
XFILLER_83_615 VGND VGND VPWR VPWR sky130_fd_sc_hd__fill_1
X_3113_ _0775_ _0800_ VGND VGND VPWR VPWR _0801_ sky130_fd_sc_hd__xnor2_1
XFILLER_95_497 VGND VGND VPWR VPWR sky130_fd_sc_hd__decap_6
X_3044_ _0704_ _0705_ VGND VGND VPWR VPWR _0732_ sky130_fd_sc_hd__xnor2_1
XFILLER_82_169 VGND VGND VPWR VPWR sky130_fd_sc_hd__fill_1
XFILLER_82_136 VGND VGND VPWR VPWR sky130_fd_sc_hd__decap_4
XFILLER_70_309 VPWR VGND VPWR VGND sky130_ef_sc_hd__decap_12
XANTENNA__2844__S _0383_ VGND VGND VPWR VPWR sky130_fd_sc_hd__diode_2
XFILLER_63_361 VPWR VGND VPWR VGND sky130_ef_sc_hd__decap_12
XFILLER_51_501 VGND VGND VPWR VPWR sky130_fd_sc_hd__decap_3
XFILLER_24_737 VPWR VGND VPWR VGND sky130_ef_sc_hd__decap_12
XFILLER_23_225 VGND VGND VPWR VPWR sky130_fd_sc_hd__decap_3
XFILLER_23_39 VPWR VGND VPWR VGND sky130_ef_sc_hd__decap_12
XFILLER_139_39 VPWR VGND VPWR VGND sky130_ef_sc_hd__decap_12
XFILLER_137_617 VPWR VGND VPWR VGND sky130_ef_sc_hd__decap_12
XANTENNA__1984__A _0911_ VGND VGND VPWR VPWR sky130_fd_sc_hd__diode_2
X_2828_ net39 X_crt\[10\] _0553_ VGND VGND VPWR VPWR _0051_ sky130_fd_sc_hd__mux2_1
X_2759_ _0483_ _0498_ VGND VGND VPWR VPWR _0499_ sky130_fd_sc_hd__or2_1
XFILLER_105_503 VGND VGND VPWR VPWR sky130_fd_sc_hd__fill_1
XFILLER_117_385 VGND VGND VPWR VPWR sky130_fd_sc_hd__decap_6
XFILLER_132_333 VPWR VGND VPWR VGND sky130_ef_sc_hd__decap_12
XFILLER_133_889 VGND VGND VPWR VPWR sky130_fd_sc_hd__decap_6
XFILLER_132_377 VPWR VGND VPWR VGND sky130_ef_sc_hd__decap_12
XTAP_TAPCELL_ROW_6_435 VGND VPWR sky130_fd_sc_hd__tapvpwrvgnd_1
XTAP_TAPCELL_ROW_6_424 VGND VPWR sky130_fd_sc_hd__tapvpwrvgnd_1
XFILLER_59_656 VGND VGND VPWR VPWR sky130_fd_sc_hd__decap_3
XFILLER_101_753 VPWR VGND VPWR VGND sky130_ef_sc_hd__decap_12
XFILLER_86_475 VGND VGND VPWR VPWR sky130_fd_sc_hd__fill_1
XFILLER_46_306 VGND VGND VPWR VPWR sky130_fd_sc_hd__fill_2
XFILLER_104_53 VPWR VGND VPWR VGND sky130_ef_sc_hd__decap_12
XFILLER_101_797 VPWR VGND VPWR VGND sky130_ef_sc_hd__decap_12
XTAP_TAPCELL_ROW_87_1730 VGND VPWR sky130_fd_sc_hd__tapvpwrvgnd_1
XFILLER_73_125 VPWR VGND VPWR VGND sky130_ef_sc_hd__decap_12
XFILLER_58_177 VGND VGND VPWR VPWR sky130_fd_sc_hd__decap_3
XFILLER_104_97 VPWR VGND VPWR VGND sky130_ef_sc_hd__decap_12
XFILLER_39_391 VGND VGND VPWR VPWR sky130_fd_sc_hd__fill_1
XFILLER_82_681 VPWR VGND VPWR VGND sky130_ef_sc_hd__decap_12
XFILLER_73_169 VPWR VGND VPWR VGND sky130_ef_sc_hd__decap_12
XFILLER_55_895 VGND VGND VPWR VPWR sky130_fd_sc_hd__fill_1
XFILLER_42_501 VGND VGND VPWR VPWR sky130_fd_sc_hd__fill_2
XFILLER_120_41 VPWR VGND VPWR VGND sky130_ef_sc_hd__decap_12
XTAP_TAPCELL_ROW_25_732 VGND VPWR sky130_fd_sc_hd__tapvpwrvgnd_1
XFILLER_27_597 VPWR VGND VPWR VGND sky130_ef_sc_hd__decap_12
XFILLER_42_545 VPWR VGND VPWR VGND sky130_ef_sc_hd__decap_12
XFILLER_42_589 VPWR VGND VPWR VGND sky130_ef_sc_hd__decap_12
XFILLER_120_85 VPWR VGND VPWR VGND sky130_ef_sc_hd__decap_12
XFILLER_127_105 VGND VGND VPWR VPWR sky130_fd_sc_hd__decap_6
XFILLER_143_609 VGND VGND VPWR VPWR sky130_fd_sc_hd__decap_6
XFILLER_127_149 VPWR VGND VPWR VGND sky130_ef_sc_hd__decap_12
XTAP_TAPCELL_ROW_114_2148 VGND VPWR sky130_fd_sc_hd__tapvpwrvgnd_1
XFILLER_109_853 VPWR VGND VPWR VGND sky130_ef_sc_hd__decap_12
XTAP_TAPCELL_ROW_98_1892 VGND VPWR sky130_fd_sc_hd__tapvpwrvgnd_1
XFILLER_6_457 VPWR VGND VPWR VGND sky130_ef_sc_hd__decap_12
XTAP_TAPCELL_ROW_114_2159 VGND VPWR sky130_fd_sc_hd__tapvpwrvgnd_1
XFILLER_109_897 VPWR VGND VPWR VGND sky130_ef_sc_hd__decap_12
XFILLER_108_363 VGND VGND VPWR VPWR sky130_fd_sc_hd__fill_1
XFILLER_89_54 VGND VGND VPWR VPWR sky130_fd_sc_hd__fill_2
XFILLER_151_653 VPWR VGND VPWR VGND sky130_ef_sc_hd__decap_12
XFILLER_135_193 VPWR VGND VPWR VGND sky130_ef_sc_hd__decap_12
XFILLER_124_867 VGND VGND VPWR VPWR sky130_fd_sc_hd__fill_1
XFILLER_151_697 VPWR VGND VPWR VGND sky130_ef_sc_hd__decap_12
XFILLER_150_141 VPWR VGND VPWR VGND sky130_ef_sc_hd__decap_12
XFILLER_97_729 VPWR VGND VPWR VGND sky130_ef_sc_hd__decap_12
XFILLER_145_93 VPWR VGND VPWR VGND sky130_ef_sc_hd__decap_12
XFILLER_49_111 VGND VGND VPWR VPWR sky130_fd_sc_hd__fill_1
XPHY_EDGE_ROW_8_Left_162 VGND VGND VPWR VPWR sky130_fd_sc_hd__decap_3
XFILLER_65_604 VGND VGND VPWR VPWR sky130_fd_sc_hd__fill_1
XTAP_TAPCELL_ROW_129_2391 VGND VPWR sky130_fd_sc_hd__tapvpwrvgnd_1
XFILLER_77_497 VGND VGND VPWR VPWR sky130_fd_sc_hd__decap_6
XFILLER_65_637 VPWR VGND VPWR VGND sky130_ef_sc_hd__decap_12
XFILLER_37_328 VGND VGND VPWR VPWR sky130_fd_sc_hd__decap_8
XFILLER_92_445 VPWR VGND VPWR VGND sky130_ef_sc_hd__decap_12
XFILLER_46_851 VGND VGND VPWR VPWR sky130_fd_sc_hd__decap_4
XFILLER_18_531 VGND VGND VPWR VPWR sky130_fd_sc_hd__fill_1
XFILLER_80_618 VPWR VGND VPWR VGND sky130_ef_sc_hd__decap_12
XFILLER_61_821 VPWR VGND VPWR VGND sky130_ef_sc_hd__decap_12
XFILLER_45_361 VPWR VGND VPWR VGND sky130_ef_sc_hd__decap_12
XANTENNA__2850__A0 net17 VGND VGND VPWR VPWR sky130_fd_sc_hd__diode_2
XFILLER_21_729 VPWR VGND VPWR VGND sky130_ef_sc_hd__decap_12
XFILLER_33_589 VPWR VGND VPWR VGND sky130_ef_sc_hd__decap_12
X_1992_ b_r2\[2\] _0911_ _1249_ _1254_ VGND VGND VPWR VPWR _0013_ sky130_fd_sc_hd__a22o_1
XFILLER_14_781 VPWR VGND VPWR VGND sky130_ef_sc_hd__decap_12
XFILLER_119_617 VPWR VGND VPWR VGND sky130_ef_sc_hd__decap_12
XFILLER_9_273 VGND VGND VPWR VPWR sky130_fd_sc_hd__decap_6
XFILLER_146_469 VGND VGND VPWR VPWR sky130_fd_sc_hd__decap_6
X_2613_ _0357_ VGND VGND VPWR VPWR _0358_ sky130_fd_sc_hd__inv_2
X_2544_ _0237_ _0291_ VGND VGND VPWR VPWR _0292_ sky130_fd_sc_hd__nor2_1
XFILLER_114_333 VPWR VGND VPWR VGND sky130_ef_sc_hd__decap_12
XTAP_TAPCELL_ROW_149_2723 VGND VPWR sky130_fd_sc_hd__tapvpwrvgnd_1
XTAP_TAPCELL_ROW_149_2712 VGND VPWR sky130_fd_sc_hd__tapvpwrvgnd_1
XFILLER_130_837 VPWR VGND VPWR VGND sky130_ef_sc_hd__decap_12
XFILLER_115_889 VGND VGND VPWR VPWR sky130_fd_sc_hd__decap_6
XFILLER_114_377 VPWR VGND VPWR VGND sky130_ef_sc_hd__decap_12
XFILLER_102_506 VPWR VGND VPWR VGND sky130_ef_sc_hd__decap_12
X_2475_ a_r1\[1\] b_r1\[1\] VGND VGND VPWR VPWR _0223_ sky130_fd_sc_hd__nand2_1
XANTENNA__2839__S _0383_ VGND VGND VPWR VPWR sky130_fd_sc_hd__diode_2
XFILLER_95_261 VPWR VGND VPWR VGND sky130_ef_sc_hd__decap_12
XFILLER_68_475 VGND VGND VPWR VPWR sky130_fd_sc_hd__fill_1
XFILLER_55_125 VPWR VGND VPWR VGND sky130_ef_sc_hd__decap_12
XANTENNA__1979__A B_reg\[1\] VGND VGND VPWR VPWR sky130_fd_sc_hd__diode_2
XFILLER_71_629 VGND VGND VPWR VPWR sky130_fd_sc_hd__decap_3
XFILLER_70_117 VGND VGND VPWR VPWR sky130_fd_sc_hd__decap_6
XFILLER_64_681 VGND VGND VPWR VPWR sky130_fd_sc_hd__decap_6
X_3027_ _0712_ _0713_ VGND VGND VPWR VPWR _0715_ sky130_fd_sc_hd__xor2_1
XFILLER_55_169 VGND VGND VPWR VPWR sky130_fd_sc_hd__decap_8
XFILLER_52_821 VPWR VGND VPWR VGND sky130_ef_sc_hd__decap_12
XFILLER_52_810 VGND VGND VPWR VPWR sky130_fd_sc_hd__fill_2
XFILLER_24_501 VPWR VGND VPWR VGND sky130_ef_sc_hd__decap_12
XFILLER_36_361 VGND VGND VPWR VPWR sky130_fd_sc_hd__decap_3
XFILLER_37_895 VGND VGND VPWR VPWR sky130_fd_sc_hd__fill_1
XFILLER_51_320 VPWR VGND VPWR VGND sky130_ef_sc_hd__decap_12
XFILLER_24_545 VPWR VGND VPWR VGND sky130_ef_sc_hd__decap_12
XFILLER_34_27 VGND VGND VPWR VPWR sky130_fd_sc_hd__fill_1
XTAP_TAPCELL_ROW_65_1379 VGND VPWR sky130_fd_sc_hd__tapvpwrvgnd_1
XTAP_TAPCELL_ROW_65_1368 VGND VPWR sky130_fd_sc_hd__tapvpwrvgnd_1
XFILLER_52_865 VGND VGND VPWR VPWR sky130_fd_sc_hd__decap_3
XFILLER_11_217 VGND VGND VPWR VPWR sky130_fd_sc_hd__decap_6
XFILLER_24_589 VPWR VGND VPWR VGND sky130_ef_sc_hd__decap_12
XFILLER_109_105 VGND VGND VPWR VPWR sky130_fd_sc_hd__decap_6
XFILLER_50_15 VPWR VGND VPWR VGND sky130_ef_sc_hd__decap_12
Xclkload4 clknet_3_4__leaf_clk VGND VGND VPWR VPWR clkload4/Y sky130_fd_sc_hd__inv_8
XFILLER_137_447 VGND VGND VPWR VPWR sky130_fd_sc_hd__fill_1
XFILLER_50_37 VGND VGND VPWR VPWR sky130_fd_sc_hd__fill_2
XFILLER_125_609 VGND VGND VPWR VPWR sky130_fd_sc_hd__decap_6
XFILLER_109_149 VPWR VGND VPWR VGND sky130_ef_sc_hd__decap_12
XFILLER_133_653 VPWR VGND VPWR VGND sky130_ef_sc_hd__decap_12
XFILLER_117_193 VPWR VGND VPWR VGND sky130_ef_sc_hd__decap_12
XFILLER_106_867 VGND VGND VPWR VPWR sky130_fd_sc_hd__fill_1
XFILLER_132_141 VPWR VGND VPWR VGND sky130_ef_sc_hd__decap_12
XFILLER_78_217 VGND VGND VPWR VPWR sky130_fd_sc_hd__fill_1
XFILLER_59_57 VPWR VGND VPWR VGND sky130_ef_sc_hd__decap_12
XFILLER_59_46 VGND VGND VPWR VPWR sky130_fd_sc_hd__decap_8
XFILLER_133_697 VPWR VGND VPWR VGND sky130_ef_sc_hd__decap_12
XFILLER_75_12 VGND VGND VPWR VPWR sky130_fd_sc_hd__decap_3
XFILLER_86_283 VGND VGND VPWR VPWR sky130_fd_sc_hd__fill_2
XFILLER_59_497 VGND VGND VPWR VPWR sky130_fd_sc_hd__decap_6
XFILLER_47_615 VGND VGND VPWR VPWR sky130_fd_sc_hd__fill_1
XFILLER_19_317 VPWR VGND VPWR VGND sky130_ef_sc_hd__decap_12
XFILLER_90_905 VGND VGND VPWR VPWR sky130_fd_sc_hd__decap_4
XFILLER_74_445 VPWR VGND VPWR VGND sky130_ef_sc_hd__decap_12
XFILLER_131_51 VGND VGND VPWR VPWR sky130_fd_sc_hd__decap_4
XFILLER_74_489 VPWR VGND VPWR VGND sky130_ef_sc_hd__decap_12
XFILLER_27_361 VPWR VGND VPWR VGND sky130_ef_sc_hd__decap_12
XFILLER_34_309 VPWR VGND VPWR VGND sky130_ef_sc_hd__decap_12
XFILLER_43_821 VGND VGND VPWR VPWR sky130_fd_sc_hd__decap_4
XFILLER_91_55 VGND VGND VPWR VPWR sky130_fd_sc_hd__fill_1
XFILLER_43_865 VPWR VGND VPWR VGND sky130_ef_sc_hd__decap_12
XFILLER_91_77 VPWR VGND VPWR VGND sky130_ef_sc_hd__decap_12
XFILLER_42_386 VGND VGND VPWR VPWR sky130_fd_sc_hd__fill_1
XFILLER_128_469 VGND VGND VPWR VPWR sky130_fd_sc_hd__decap_6
XFILLER_7_777 VGND VGND VPWR VPWR sky130_fd_sc_hd__decap_6
XFILLER_6_221 VGND VGND VPWR VPWR sky130_fd_sc_hd__fill_2
XFILLER_143_417 VPWR VGND VPWR VGND sky130_ef_sc_hd__decap_12
XFILLER_6_265 VPWR VGND VPWR VGND sky130_ef_sc_hd__decap_12
XFILLER_151_461 VPWR VGND VPWR VGND sky130_ef_sc_hd__decap_12
XFILLER_69_217 VGND VGND VPWR VPWR sky130_fd_sc_hd__decap_6
XFILLER_112_837 VPWR VGND VPWR VGND sky130_ef_sc_hd__decap_12
XFILLER_97_548 VPWR VGND VPWR VGND sky130_ef_sc_hd__decap_12
XFILLER_2_471 VGND VGND VPWR VPWR sky130_fd_sc_hd__fill_1
X_2260_ _1504_ _1506_ _1499_ VGND VGND VPWR VPWR _1517_ sky130_fd_sc_hd__a21oi_1
XFILLER_84_209 VPWR VGND VPWR VGND sky130_ef_sc_hd__decap_12
XTAP_TAPCELL_ROW_144_2631 VGND VPWR sky130_fd_sc_hd__tapvpwrvgnd_1
XFILLER_120_881 VPWR VGND VPWR VGND sky130_ef_sc_hd__decap_12
XFILLER_93_721 VGND VGND VPWR VPWR sky130_fd_sc_hd__decap_6
X_2191_ _1447_ VGND VGND VPWR VPWR _1448_ sky130_fd_sc_hd__inv_2
XFILLER_38_637 VGND VGND VPWR VPWR sky130_fd_sc_hd__decap_6
XTAP_TAPCELL_ROW_144_2642 VGND VPWR sky130_fd_sc_hd__tapvpwrvgnd_1
XFILLER_93_765 VPWR VGND VPWR VGND sky130_ef_sc_hd__decap_12
XFILLER_65_456 VPWR VGND VPWR VGND sky130_ef_sc_hd__decap_12
XFILLER_37_125 VPWR VGND VPWR VGND sky130_ef_sc_hd__decap_12
XFILLER_92_253 VPWR VGND VPWR VGND sky130_ef_sc_hd__decap_12
XFILLER_80_415 VGND VGND VPWR VPWR sky130_fd_sc_hd__decap_4
XFILLER_53_629 VPWR VGND VPWR VGND sky130_ef_sc_hd__decap_12
XFILLER_46_670 VGND VGND VPWR VPWR sky130_fd_sc_hd__fill_1
XFILLER_37_169 VPWR VGND VPWR VGND sky130_ef_sc_hd__decap_12
XFILLER_19_895 VGND VGND VPWR VPWR sky130_fd_sc_hd__fill_1
XFILLER_61_673 VPWR VGND VPWR VGND sky130_ef_sc_hd__decap_12
XANTENNA__3269__RESET_B net36 VGND VGND VPWR VPWR sky130_fd_sc_hd__diode_2
XTAP_TAPCELL_ROW_47_1087 VGND VPWR sky130_fd_sc_hd__tapvpwrvgnd_1
XTAP_TAPCELL_ROW_16_584 VGND VPWR sky130_fd_sc_hd__tapvpwrvgnd_1
XTAP_TAPCELL_ROW_47_1076 VGND VPWR sky130_fd_sc_hd__tapvpwrvgnd_1
X_1975_ B_reg\[2\] _1236_ _1238_ VGND VGND VPWR VPWR _1240_ sky130_fd_sc_hd__o21a_1
XFILLER_60_194 VGND VGND VPWR VPWR sky130_fd_sc_hd__fill_2
XTAP_TAPCELL_ROW_16_595 VGND VPWR sky130_fd_sc_hd__tapvpwrvgnd_1
XFILLER_21_559 VGND VGND VPWR VPWR sky130_fd_sc_hd__fill_1
XFILLER_146_233 VPWR VGND VPWR VGND sky130_ef_sc_hd__decap_12
XFILLER_119_447 VGND VGND VPWR VPWR sky130_fd_sc_hd__fill_1
XFILLER_107_609 VGND VGND VPWR VPWR sky130_fd_sc_hd__decap_6
XTAP_TAPCELL_ROW_60_1298 VGND VPWR sky130_fd_sc_hd__tapvpwrvgnd_1
XTAP_TAPCELL_ROW_60_1287 VGND VPWR sky130_fd_sc_hd__tapvpwrvgnd_1
XFILLER_146_277 VPWR VGND VPWR VGND sky130_ef_sc_hd__decap_12
XFILLER_20_29 VPWR VGND VPWR VGND sky130_ef_sc_hd__decap_12
XFILLER_136_29 VPWR VGND VPWR VGND sky130_ef_sc_hd__decap_12
XFILLER_115_653 VPWR VGND VPWR VGND sky130_ef_sc_hd__decap_12
XFILLER_1_909 VGND VGND VPWR VPWR sky130_fd_sc_hd__fill_1
XFILLER_130_601 VPWR VGND VPWR VGND sky130_ef_sc_hd__decap_12
XFILLER_114_141 VPWR VGND VPWR VGND sky130_ef_sc_hd__decap_12
X_2527_ _0185_ _0273_ _0274_ _0234_ VGND VGND VPWR VPWR _0275_ sky130_fd_sc_hd__o211a_1
XFILLER_130_645 VPWR VGND VPWR VGND sky130_ef_sc_hd__decap_12
XFILLER_115_697 VPWR VGND VPWR VGND sky130_ef_sc_hd__decap_12
X_2458_ a_r0\[0\] b_r0\[0\] OpSel_reg\[1\] OpSel_reg\[0\] VGND VGND VPWR VPWR _0208_
+ sky130_fd_sc_hd__a31o_1
XPHY_EDGE_ROW_89_Right_89 VGND VGND VPWR VPWR sky130_fd_sc_hd__decap_3
XFILLER_29_27 VPWR VGND VPWR VGND sky130_ef_sc_hd__decap_12
X_2389_ _0141_ _0142_ _0907_ VGND VGND VPWR VPWR _0143_ sky130_fd_sc_hd__a21oi_2
XFILLER_84_732 VPWR VGND VPWR VGND sky130_ef_sc_hd__decap_12
XFILLER_56_423 VPWR VGND VPWR VGND sky130_ef_sc_hd__decap_12
XFILLER_29_615 VGND VGND VPWR VPWR sky130_fd_sc_hd__fill_1
XFILLER_72_905 VGND VGND VPWR VPWR sky130_fd_sc_hd__decap_4
XTAP_TAPCELL_ROW_67_1408 VGND VPWR sky130_fd_sc_hd__tapvpwrvgnd_1
XFILLER_56_489 VPWR VGND VPWR VGND sky130_ef_sc_hd__decap_12
XFILLER_44_629 VPWR VGND VPWR VGND sky130_ef_sc_hd__decap_12
XFILLER_45_15 VPWR VGND VPWR VGND sky130_ef_sc_hd__decap_12
XFILLER_25_821 VPWR VGND VPWR VGND sky130_ef_sc_hd__decap_12
XTAP_TAPCELL_ROW_80_1619 VGND VPWR sky130_fd_sc_hd__tapvpwrvgnd_1
XTAP_TAPCELL_ROW_80_1608 VGND VPWR sky130_fd_sc_hd__tapvpwrvgnd_1
XFILLER_24_331 VPWR VGND VPWR VGND sky130_ef_sc_hd__decap_12
XFILLER_25_865 VPWR VGND VPWR VGND sky130_ef_sc_hd__decap_12
XPHY_EDGE_ROW_98_Right_98 VGND VGND VPWR VPWR sky130_fd_sc_hd__decap_3
XANTENNA__2290__A1 A_reg\[0\] VGND VGND VPWR VPWR sky130_fd_sc_hd__diode_2
XTAP_TAPCELL_ROW_35_893 VGND VPWR sky130_fd_sc_hd__tapvpwrvgnd_1
XFILLER_40_813 VPWR VGND VPWR VGND sky130_ef_sc_hd__decap_12
XFILLER_40_846 VPWR VGND VPWR VGND sky130_ef_sc_hd__decap_12
XFILLER_138_701 VPWR VGND VPWR VGND sky130_ef_sc_hd__decap_12
XFILLER_61_69 VGND VGND VPWR VPWR sky130_fd_sc_hd__decap_6
XFILLER_20_581 VGND VGND VPWR VPWR sky130_fd_sc_hd__decap_6
XFILLER_125_417 VPWR VGND VPWR VGND sky130_ef_sc_hd__decap_12
XFILLER_117_3 VPWR VGND VPWR VGND sky130_ef_sc_hd__decap_12
XPHY_EDGE_ROW_89_Left_243 VGND VGND VPWR VPWR sky130_fd_sc_hd__decap_3
XFILLER_4_725 VPWR VGND VPWR VGND sky130_ef_sc_hd__decap_12
XTAP_TAPCELL_ROW_111_2107 VGND VPWR sky130_fd_sc_hd__tapvpwrvgnd_1
XTAP_TAPCELL_ROW_95_1851 VGND VPWR sky130_fd_sc_hd__tapvpwrvgnd_1
XFILLER_133_461 VPWR VGND VPWR VGND sky130_ef_sc_hd__decap_12
XFILLER_4_769 VPWR VGND VPWR VGND sky130_ef_sc_hd__decap_12
XFILLER_79_559 VGND VGND VPWR VPWR sky130_fd_sc_hd__fill_1
XFILLER_79_537 VGND VGND VPWR VPWR sky130_fd_sc_hd__fill_2
XFILLER_120_133 VGND VGND VPWR VPWR sky130_fd_sc_hd__decap_6
XFILLER_120_177 VPWR VGND VPWR VGND sky130_ef_sc_hd__decap_12
XFILLER_102_881 VPWR VGND VPWR VGND sky130_ef_sc_hd__decap_12
XFILLER_86_77 VGND VGND VPWR VPWR sky130_fd_sc_hd__decap_6
XFILLER_59_261 VGND VGND VPWR VPWR sky130_fd_sc_hd__decap_6
XTAP_TAPCELL_ROW_126_2350 VGND VPWR sky130_fd_sc_hd__tapvpwrvgnd_1
XTAP_TAPCELL_ROW_109_2069 VGND VPWR sky130_fd_sc_hd__tapvpwrvgnd_1
XFILLER_75_754 VPWR VGND VPWR VGND sky130_ef_sc_hd__decap_12
XFILLER_19_125 VPWR VGND VPWR VGND sky130_ef_sc_hd__decap_12
XANTENNA__1856__A1 A_reg\[9\] VGND VGND VPWR VPWR sky130_fd_sc_hd__diode_2
XFILLER_142_83 VGND VGND VPWR VPWR sky130_fd_sc_hd__fill_1
XPHY_EDGE_ROW_98_Left_252 VGND VGND VPWR VPWR sky130_fd_sc_hd__decap_3
XFILLER_90_713 VPWR VGND VPWR VGND sky130_ef_sc_hd__decap_12
XFILLER_74_253 VPWR VGND VPWR VGND sky130_ef_sc_hd__decap_12
XFILLER_19_93 VPWR VGND VPWR VGND sky130_ef_sc_hd__decap_12
XFILLER_19_169 VPWR VGND VPWR VGND sky130_ef_sc_hd__decap_12
XFILLER_35_607 VGND VGND VPWR VPWR sky130_fd_sc_hd__decap_8
XFILLER_35_629 VPWR VGND VPWR VGND sky130_ef_sc_hd__decap_12
XFILLER_90_757 VPWR VGND VPWR VGND sky130_ef_sc_hd__decap_12
XFILLER_28_681 VPWR VGND VPWR VGND sky130_ef_sc_hd__decap_12
XFILLER_34_139 VGND VGND VPWR VPWR sky130_fd_sc_hd__fill_1
XANTENNA__2805__B1 _0910_ VGND VGND VPWR VPWR sky130_fd_sc_hd__diode_2
XFILLER_15_386 VGND VGND VPWR VPWR sky130_fd_sc_hd__decap_6
XFILLER_30_301 VGND VGND VPWR VPWR sky130_fd_sc_hd__fill_1
XFILLER_35_81 VPWR VGND VPWR VGND sky130_ef_sc_hd__decap_12
XFILLER_42_172 VPWR VGND VPWR VGND sky130_ef_sc_hd__decap_12
XFILLER_43_673 VPWR VGND VPWR VGND sky130_ef_sc_hd__decap_12
XTAP_TAPCELL_ROW_104_1991 VGND VPWR sky130_fd_sc_hd__tapvpwrvgnd_1
XTAP_TAPCELL_ROW_13_532 VGND VPWR sky130_fd_sc_hd__tapvpwrvgnd_1
XTAP_TAPCELL_ROW_13_543 VGND VPWR sky130_fd_sc_hd__tapvpwrvgnd_1
XFILLER_30_323 VPWR VGND VPWR VGND sky130_ef_sc_hd__decap_12
X_1760_ _1027_ _1032_ VGND VGND VPWR VPWR _1033_ sky130_fd_sc_hd__or2_1
XANTENNA__2243__A A_reg\[4\] VGND VGND VPWR VPWR sky130_fd_sc_hd__diode_2
XFILLER_128_233 VPWR VGND VPWR VGND sky130_ef_sc_hd__decap_12
XFILLER_51_80 VGND VGND VPWR VPWR sky130_fd_sc_hd__decap_3
XFILLER_7_541 VPWR VGND VPWR VGND sky130_ef_sc_hd__decap_12
XFILLER_144_737 VPWR VGND VPWR VGND sky130_ef_sc_hd__decap_12
XFILLER_128_277 VPWR VGND VPWR VGND sky130_ef_sc_hd__decap_12
X_1691_ _0957_ _0961_ _0962_ VGND VGND VPWR VPWR _0967_ sky130_fd_sc_hd__or3_1
XFILLER_143_225 VPWR VGND VPWR VGND sky130_ef_sc_hd__decap_12
XFILLER_109_480 VPWR VGND VPWR VGND sky130_ef_sc_hd__decap_12
XFILLER_112_601 VPWR VGND VPWR VGND sky130_ef_sc_hd__decap_12
XFILLER_98_813 VPWR VGND VPWR VGND sky130_ef_sc_hd__decap_12
XFILLER_152_781 VPWR VGND VPWR VGND sky130_ef_sc_hd__decap_12
XFILLER_111_111 VGND VGND VPWR VPWR sky130_fd_sc_hd__fill_1
X_2312_ _1563_ _1564_ VGND VGND VPWR VPWR _1565_ sky130_fd_sc_hd__and2_1
XFILLER_32_3 VPWR VGND VPWR VGND sky130_ef_sc_hd__decap_12
XFILLER_112_645 VPWR VGND VPWR VGND sky130_ef_sc_hd__decap_12
X_3292_ clknet_3_2__leaf_clk _0075_ net36 VGND VGND VPWR VPWR B_reg\[2\] sky130_fd_sc_hd__dfrtp_4
XFILLER_2_290 VPWR VGND VPWR VGND sky130_ef_sc_hd__decap_12
XFILLER_38_401 VGND VGND VPWR VPWR sky130_fd_sc_hd__decap_8
X_2243_ A_reg\[4\] _1496_ VGND VGND VPWR VPWR _1500_ sky130_fd_sc_hd__xor2_1
XFILLER_66_754 VGND VGND VPWR VPWR sky130_fd_sc_hd__fill_2
X_2174_ _0889_ _1428_ VGND VGND VPWR VPWR _1431_ sky130_fd_sc_hd__xnor2_2
XFILLER_93_551 VGND VGND VPWR VPWR sky130_fd_sc_hd__decap_8
XFILLER_65_264 VPWR VGND VPWR VGND sky130_ef_sc_hd__decap_12
XTAP_TAPCELL_ROW_49_1116 VGND VPWR sky130_fd_sc_hd__tapvpwrvgnd_1
XANTENNA__2852__S _0383_ VGND VGND VPWR VPWR sky130_fd_sc_hd__diode_2
XFILLER_80_289 VPWR VGND VPWR VGND sky130_ef_sc_hd__decap_12
XTAP_TAPCELL_ROW_62_1327 VGND VPWR sky130_fd_sc_hd__tapvpwrvgnd_1
XTAP_TAPCELL_ROW_62_1316 VGND VPWR sky130_fd_sc_hd__tapvpwrvgnd_1
XANTENNA__2272__B2 A_reg\[1\] VGND VGND VPWR VPWR sky130_fd_sc_hd__diode_2
XFILLER_22_813 VPWR VGND VPWR VGND sky130_ef_sc_hd__decap_12
XFILLER_33_161 VGND VGND VPWR VPWR sky130_fd_sc_hd__decap_6
XFILLER_40_109 VPWR VGND VPWR VGND sky130_ef_sc_hd__decap_12
XFILLER_61_492 VPWR VGND VPWR VGND sky130_ef_sc_hd__decap_12
XFILLER_21_345 VGND VGND VPWR VPWR sky130_fd_sc_hd__decap_3
XTAP_TAPCELL_ROW_32_841 VGND VPWR sky130_fd_sc_hd__tapvpwrvgnd_1
XFILLER_147_553 VGND VGND VPWR VPWR sky130_fd_sc_hd__decap_6
X_1958_ B_reg\[5\] _1218_ _1220_ VGND VGND VPWR VPWR _1223_ sky130_fd_sc_hd__o21a_1
XFILLER_31_39 VPWR VGND VPWR VGND sky130_ef_sc_hd__decap_12
XFILLER_147_597 VPWR VGND VPWR VGND sky130_ef_sc_hd__decap_12
XFILLER_147_39 VPWR VGND VPWR VGND sky130_ef_sc_hd__decap_12
X_1889_ _0886_ _1155_ _1158_ VGND VGND VPWR VPWR _1159_ sky130_fd_sc_hd__a21oi_1
XFILLER_115_461 VPWR VGND VPWR VGND sky130_ef_sc_hd__decap_12
XTAP_TAPCELL_ROW_77_1570 VGND VPWR sky130_fd_sc_hd__tapvpwrvgnd_1
Xoutput39 net39 VGND VGND VPWR VPWR X_out[10] sky130_fd_sc_hd__buf_1
XFILLER_103_612 VGND VGND VPWR VPWR sky130_fd_sc_hd__decap_4
XFILLER_102_133 VGND VGND VPWR VPWR sky130_fd_sc_hd__decap_6
XTAP_TAPCELL_ROW_90_1770 VGND VPWR sky130_fd_sc_hd__tapvpwrvgnd_1
XFILLER_88_345 VPWR VGND VPWR VGND sky130_ef_sc_hd__decap_12
XFILLER_130_475 VGND VGND VPWR VPWR sky130_fd_sc_hd__fill_1
XFILLER_102_177 VPWR VGND VPWR VGND sky130_ef_sc_hd__decap_12
XFILLER_48_209 VPWR VGND VPWR VGND sky130_ef_sc_hd__decap_12
XFILLER_56_36 VPWR VGND VPWR VGND sky130_ef_sc_hd__decap_12
XFILLER_84_562 VPWR VGND VPWR VGND sky130_ef_sc_hd__decap_12
XFILLER_72_713 VPWR VGND VPWR VGND sky130_ef_sc_hd__decap_12
XFILLER_56_253 VPWR VGND VPWR VGND sky130_ef_sc_hd__decap_12
XFILLER_17_629 VPWR VGND VPWR VGND sky130_ef_sc_hd__decap_12
XFILLER_72_757 VGND VGND VPWR VPWR sky130_fd_sc_hd__decap_3
XFILLER_56_275 VPWR VGND VPWR VGND sky130_ef_sc_hd__decap_12
XFILLER_16_139 VGND VGND VPWR VPWR sky130_fd_sc_hd__fill_1
XFILLER_112_53 VPWR VGND VPWR VGND sky130_ef_sc_hd__decap_12
XFILLER_112_97 VPWR VGND VPWR VGND sky130_ef_sc_hd__decap_12
XFILLER_25_673 VPWR VGND VPWR VGND sky130_ef_sc_hd__decap_12
XFILLER_40_643 VGND VGND VPWR VPWR sky130_fd_sc_hd__fill_1
XPHY_EDGE_ROW_117_Right_117 VGND VGND VPWR VPWR sky130_fd_sc_hd__decap_3
XANTENNA__2063__A B_reg\[4\] VGND VGND VPWR VPWR sky130_fd_sc_hd__diode_2
XFILLER_9_839 VGND VGND VPWR VPWR sky130_fd_sc_hd__fill_1
XFILLER_8_316 VPWR VGND VPWR VGND sky130_ef_sc_hd__decap_12
XFILLER_40_676 VGND VGND VPWR VPWR sky130_fd_sc_hd__fill_1
XFILLER_138_531 VGND VGND VPWR VPWR sky130_fd_sc_hd__fill_1
XFILLER_12_389 VPWR VGND VPWR VGND sky130_ef_sc_hd__decap_12
XFILLER_153_501 VGND VGND VPWR VPWR sky130_fd_sc_hd__decap_3
XFILLER_126_737 VPWR VGND VPWR VGND sky130_ef_sc_hd__decap_12
XFILLER_153_545 VPWR VGND VPWR VGND sky130_ef_sc_hd__decap_12
XFILLER_125_225 VPWR VGND VPWR VGND sky130_ef_sc_hd__decap_12
XFILLER_153_589 VPWR VGND VPWR VGND sky130_ef_sc_hd__decap_12
XFILLER_141_729 VPWR VGND VPWR VGND sky130_ef_sc_hd__decap_12
XFILLER_106_461 VPWR VGND VPWR VGND sky130_ef_sc_hd__decap_12
XFILLER_98_109 VPWR VGND VPWR VGND sky130_ef_sc_hd__decap_12
XFILLER_97_32 VPWR VGND VPWR VGND sky130_ef_sc_hd__decap_12
XFILLER_134_781 VPWR VGND VPWR VGND sky130_ef_sc_hd__decap_12
XFILLER_67_529 VPWR VGND VPWR VGND sky130_ef_sc_hd__decap_12
XTAP_TAPCELL_ROW_124_2309 VGND VPWR sky130_fd_sc_hd__tapvpwrvgnd_1
XFILLER_121_497 VGND VGND VPWR VPWR sky130_fd_sc_hd__decap_6
XFILLER_75_573 VPWR VGND VPWR VGND sky130_ef_sc_hd__decap_12
XFILLER_36_905 VGND VGND VPWR VPWR sky130_fd_sc_hd__decap_4
XANTENNA_clkload2_A clknet_3_2__leaf_clk VGND VGND VPWR VPWR sky130_fd_sc_hd__diode_2
XFILLER_63_735 VGND VGND VPWR VPWR sky130_fd_sc_hd__decap_6
XTAP_TAPCELL_ROW_18_613 VGND VPWR sky130_fd_sc_hd__tapvpwrvgnd_1
XTAP_TAPCELL_ROW_18_624 VGND VPWR sky130_fd_sc_hd__tapvpwrvgnd_1
XFILLER_35_415 VGND VGND VPWR VPWR sky130_fd_sc_hd__fill_1
XFILLER_90_587 VGND VGND VPWR VPWR sky130_fd_sc_hd__fill_1
X_2930_ _0554_ _0604_ _0617_ VGND VGND VPWR VPWR _0618_ sky130_fd_sc_hd__a21o_1
XFILLER_15_161 VGND VGND VPWR VPWR sky130_fd_sc_hd__decap_6
XFILLER_22_109 VPWR VGND VPWR VGND sky130_ef_sc_hd__decap_12
XFILLER_31_643 VPWR VGND VPWR VGND sky130_ef_sc_hd__decap_12
XTAP_TAPCELL_ROW_44_1035 VGND VPWR sky130_fd_sc_hd__tapvpwrvgnd_1
XTAP_TAPCELL_ROW_139_2563 VGND VPWR sky130_fd_sc_hd__tapvpwrvgnd_1
XTAP_TAPCELL_ROW_139_2552 VGND VPWR sky130_fd_sc_hd__tapvpwrvgnd_1
X_2861_ net19 B_reg\[11\] _0383_ VGND VGND VPWR VPWR _0084_ sky130_fd_sc_hd__mux2_1
XFILLER_30_153 VPWR VGND VPWR VGND sky130_ef_sc_hd__decap_12
XFILLER_129_553 VGND VGND VPWR VPWR sky130_fd_sc_hd__decap_6
X_2792_ _0420_ _0531_ VGND VGND VPWR VPWR _0532_ sky130_fd_sc_hd__nand2_1
XFILLER_30_197 VPWR VGND VPWR VGND sky130_ef_sc_hd__decap_12
X_1812_ A_reg\[3\] _1083_ VGND VGND VPWR VPWR _1085_ sky130_fd_sc_hd__xnor2_1
XFILLER_144_501 VPWR VGND VPWR VGND sky130_ef_sc_hd__decap_12
XANTENNA__2557__A2 _0910_ VGND VGND VPWR VPWR sky130_fd_sc_hd__diode_2
XFILLER_8_861 VGND VGND VPWR VPWR sky130_fd_sc_hd__decap_6
X_1743_ A_reg\[12\] _1012_ _1013_ _1009_ VGND VGND VPWR VPWR _1016_ sky130_fd_sc_hd__o22ai_2
XTAP_TAPCELL_ROW_152_2763 VGND VPWR sky130_fd_sc_hd__tapvpwrvgnd_1
XFILLER_144_545 VPWR VGND VPWR VGND sky130_ef_sc_hd__decap_12
XFILLER_129_597 VPWR VGND VPWR VGND sky130_ef_sc_hd__decap_12
XFILLER_7_393 VGND VGND VPWR VPWR sky130_fd_sc_hd__fill_1
XANTENNA__1765__B1 A_reg\[9\] VGND VGND VPWR VPWR sky130_fd_sc_hd__diode_2
X_1674_ _0891_ _0940_ _0949_ _0948_ _0947_ VGND VGND VPWR VPWR _0950_ sky130_fd_sc_hd__o311a_1
XFILLER_144_589 VPWR VGND VPWR VGND sky130_ef_sc_hd__decap_12
XFILLER_89_109 VGND VGND VPWR VPWR sky130_fd_sc_hd__decap_3
XFILLER_131_217 VGND VGND VPWR VPWR sky130_fd_sc_hd__decap_6
XFILLER_98_643 VGND VGND VPWR VPWR sky130_fd_sc_hd__fill_1
XFILLER_86_805 VGND VGND VPWR VPWR sky130_fd_sc_hd__decap_6
XFILLER_112_475 VGND VGND VPWR VPWR sky130_fd_sc_hd__fill_1
XFILLER_97_186 VGND VGND VPWR VPWR sky130_fd_sc_hd__decap_8
XFILLER_86_849 VPWR VGND VPWR VGND sky130_ef_sc_hd__decap_12
X_3275_ clknet_3_0__leaf_clk _0058_ net36 VGND VGND VPWR VPWR A_reg\[1\] sky130_fd_sc_hd__dfrtp_4
XANTENNA__3212__CLK clknet_3_1__leaf_clk VGND VGND VPWR VPWR sky130_fd_sc_hd__diode_2
XANTENNA__2847__S _0383_ VGND VGND VPWR VPWR sky130_fd_sc_hd__diode_2
XFILLER_39_710 VPWR VGND VPWR VGND sky130_ef_sc_hd__decap_12
XFILLER_100_637 VGND VGND VPWR VPWR sky130_fd_sc_hd__decap_6
XFILLER_85_337 VPWR VGND VPWR VGND sky130_ef_sc_hd__decap_12
X_2226_ _1471_ _1473_ _1482_ VGND VGND VPWR VPWR _1483_ sky130_fd_sc_hd__o21ai_1
XFILLER_54_713 VGND VGND VPWR VPWR sky130_fd_sc_hd__decap_8
XANTENNA__3284__RESET_B net36 VGND VGND VPWR VPWR sky130_fd_sc_hd__diode_2
XFILLER_26_404 VPWR VGND VPWR VGND sky130_ef_sc_hd__decap_12
XFILLER_38_253 VGND VGND VPWR VPWR sky130_fd_sc_hd__decap_8
XFILLER_94_893 VPWR VGND VPWR VGND sky130_ef_sc_hd__decap_12
XFILLER_53_223 VGND VGND VPWR VPWR sky130_fd_sc_hd__fill_1
X_2157_ _0887_ _0925_ A_reg\[14\] VGND VGND VPWR VPWR _1414_ sky130_fd_sc_hd__o21a_1
XTAP_TAPCELL_ROW_37_922 VGND VPWR sky130_fd_sc_hd__tapvpwrvgnd_1
X_2088_ B_reg\[0\] _1349_ VGND VGND VPWR VPWR _1350_ sky130_fd_sc_hd__or2_1
XANTENNA__3213__RESET_B net36 VGND VGND VPWR VPWR sky130_fd_sc_hd__diode_2
XFILLER_54_757 VPWR VGND VPWR VGND sky130_ef_sc_hd__decap_12
XANTENNA__2245__A1 A_reg\[4\] VGND VGND VPWR VPWR sky130_fd_sc_hd__diode_2
XFILLER_22_643 VGND VGND VPWR VPWR sky130_fd_sc_hd__fill_1
XFILLER_139_317 VPWR VGND VPWR VGND sky130_ef_sc_hd__decap_12
XFILLER_10_805 VGND VGND VPWR VPWR sky130_fd_sc_hd__decap_6
XFILLER_42_27 VGND VGND VPWR VPWR sky130_fd_sc_hd__fill_1
XFILLER_10_849 VPWR VGND VPWR VGND sky130_ef_sc_hd__decap_12
XFILLER_147_361 VPWR VGND VPWR VGND sky130_ef_sc_hd__decap_12
XFILLER_5_319 VPWR VGND VPWR VGND sky130_ef_sc_hd__decap_12
XFILLER_108_737 VPWR VGND VPWR VGND sky130_ef_sc_hd__decap_12
XFILLER_107_225 VPWR VGND VPWR VGND sky130_ef_sc_hd__decap_12
XFILLER_123_729 VPWR VGND VPWR VGND sky130_ef_sc_hd__decap_12
XTAP_TAPCELL_ROW_92_1810 VGND VPWR sky130_fd_sc_hd__tapvpwrvgnd_1
XTAP_TAPCELL_ROW_75_1529 VGND VPWR sky130_fd_sc_hd__tapvpwrvgnd_1
XFILLER_116_781 VPWR VGND VPWR VGND sky130_ef_sc_hd__decap_12
XFILLER_1_503 VGND VGND VPWR VPWR sky130_fd_sc_hd__fill_1
XFILLER_89_665 VGND VGND VPWR VPWR sky130_fd_sc_hd__decap_6
XFILLER_88_153 VPWR VGND VPWR VGND sky130_ef_sc_hd__decap_12
XFILLER_67_57 VPWR VGND VPWR VGND sky130_ef_sc_hd__decap_12
XFILLER_49_529 VPWR VGND VPWR VGND sky130_ef_sc_hd__decap_12
XANTENNA__3215__Q a_r1\[0\] VGND VGND VPWR VPWR sky130_fd_sc_hd__diode_2
XFILLER_103_497 VGND VGND VPWR VPWR sky130_fd_sc_hd__decap_6
XFILLER_88_197 VPWR VGND VPWR VGND sky130_ef_sc_hd__decap_12
XTAP_TAPCELL_ROW_106_2028 VGND VPWR sky130_fd_sc_hd__tapvpwrvgnd_1
XFILLER_57_573 VPWR VGND VPWR VGND sky130_ef_sc_hd__decap_12
XFILLER_18_905 VGND VGND VPWR VPWR sky130_fd_sc_hd__decap_4
XFILLER_29_231 VPWR VGND VPWR VGND sky130_ef_sc_hd__decap_12
XFILLER_91_329 VGND VGND VPWR VPWR sky130_fd_sc_hd__decap_6
XTAP_TAPCELL_ROW_4_396 VGND VPWR sky130_fd_sc_hd__tapvpwrvgnd_1
XFILLER_83_45 VGND VGND VPWR VPWR sky130_fd_sc_hd__decap_8
XFILLER_44_245 VGND VGND VPWR VPWR sky130_fd_sc_hd__decap_6
XFILLER_83_89 VGND VGND VPWR VPWR sky130_fd_sc_hd__fill_1
XFILLER_72_587 VGND VGND VPWR VPWR sky130_fd_sc_hd__fill_1
XFILLER_44_289 VPWR VGND VPWR VGND sky130_ef_sc_hd__decap_12
XFILLER_60_749 VGND VGND VPWR VPWR sky130_fd_sc_hd__decap_6
XFILLER_16_83 VGND VGND VPWR VPWR sky130_fd_sc_hd__fill_1
XTAP_TAPCELL_ROW_101_1950 VGND VPWR sky130_fd_sc_hd__tapvpwrvgnd_1
XFILLER_12_153 VPWR VGND VPWR VGND sky130_ef_sc_hd__decap_12
XFILLER_13_665 VGND VGND VPWR VPWR sky130_fd_sc_hd__decap_6
XTAP_TAPCELL_ROW_23_693 VGND VPWR sky130_fd_sc_hd__tapvpwrvgnd_1
XFILLER_139_895 VGND VGND VPWR VPWR sky130_fd_sc_hd__fill_1
XFILLER_126_501 VPWR VGND VPWR VGND sky130_ef_sc_hd__decap_12
XFILLER_12_197 VPWR VGND VPWR VGND sky130_ef_sc_hd__decap_12
XFILLER_126_545 VPWR VGND VPWR VGND sky130_ef_sc_hd__decap_12
XTAP_TAPCELL_ROW_134_2482 VGND VPWR sky130_fd_sc_hd__tapvpwrvgnd_1
XTAP_TAPCELL_ROW_134_2471 VGND VPWR sky130_fd_sc_hd__tapvpwrvgnd_1
XFILLER_5_853 VPWR VGND VPWR VGND sky130_ef_sc_hd__decap_12
XFILLER_4_352 VGND VGND VPWR VPWR sky130_fd_sc_hd__fill_2
XFILLER_126_589 VPWR VGND VPWR VGND sky130_ef_sc_hd__decap_12
XFILLER_113_217 VGND VGND VPWR VPWR sky130_fd_sc_hd__decap_6
XFILLER_99_429 VPWR VGND VPWR VGND sky130_ef_sc_hd__decap_12
XANTENNA__3235__CLK clknet_3_1__leaf_clk VGND VGND VPWR VPWR sky130_fd_sc_hd__diode_2
XFILLER_5_897 VPWR VGND VPWR VGND sky130_ef_sc_hd__decap_12
XFILLER_4_363 VGND VGND VPWR VPWR sky130_fd_sc_hd__fill_1
XFILLER_141_559 VGND VGND VPWR VPWR sky130_fd_sc_hd__fill_1
XFILLER_68_805 VGND VGND VPWR VPWR sky130_fd_sc_hd__decap_6
XFILLER_121_261 VPWR VGND VPWR VGND sky130_ef_sc_hd__decap_12
XFILLER_68_849 VPWR VGND VPWR VGND sky130_ef_sc_hd__decap_12
XFILLER_67_337 VPWR VGND VPWR VGND sky130_ef_sc_hd__decap_12
X_3060_ _0623_ _0736_ VGND VGND VPWR VPWR _0748_ sky130_fd_sc_hd__xnor2_1
XFILLER_82_307 VGND VGND VPWR VPWR sky130_fd_sc_hd__fill_1
X_2011_ _1269_ _1270_ _1272_ VGND VGND VPWR VPWR _1273_ sky130_fd_sc_hd__o21ba_1
XFILLER_76_893 VPWR VGND VPWR VGND sky130_ef_sc_hd__decap_12
XFILLER_36_713 VPWR VGND VPWR VGND sky130_ef_sc_hd__decap_12
XFILLER_91_841 VPWR VGND VPWR VGND sky130_ef_sc_hd__decap_12
XFILLER_63_554 VGND VGND VPWR VPWR sky130_fd_sc_hd__decap_6
XFILLER_36_757 VPWR VGND VPWR VGND sky130_ef_sc_hd__decap_12
XFILLER_50_248 VGND VGND VPWR VPWR sky130_fd_sc_hd__decap_4
XPHY_EDGE_ROW_35_Left_189 VGND VGND VPWR VPWR sky130_fd_sc_hd__decap_3
XFILLER_149_615 VGND VGND VPWR VPWR sky130_fd_sc_hd__fill_1
X_2913_ _0578_ _0586_ _0600_ VGND VGND VPWR VPWR _0601_ sky130_fd_sc_hd__and3_1
X_2844_ net2 A_reg\[10\] _0383_ VGND VGND VPWR VPWR _0067_ sky130_fd_sc_hd__mux2_1
XFILLER_31_473 VPWR VGND VPWR VGND sky130_ef_sc_hd__decap_12
XFILLER_136_309 VPWR VGND VPWR VGND sky130_ef_sc_hd__decap_12
XFILLER_129_361 VPWR VGND VPWR VGND sky130_ef_sc_hd__decap_12
XFILLER_145_821 VPWR VGND VPWR VGND sky130_ef_sc_hd__decap_12
X_2775_ _0505_ _0509_ _0502_ VGND VGND VPWR VPWR _0515_ sky130_fd_sc_hd__a21o_1
XANTENNA__2431__A b_r3\[3\] VGND VGND VPWR VPWR sky130_fd_sc_hd__diode_2
XFILLER_145_865 VPWR VGND VPWR VGND sky130_ef_sc_hd__decap_12
XTAP_TAPCELL_ROW_57_1237 VGND VPWR sky130_fd_sc_hd__tapvpwrvgnd_1
X_1726_ _0911_ _1001_ VGND VGND VPWR VPWR _1002_ sky130_fd_sc_hd__nor2_1
XFILLER_105_729 VPWR VGND VPWR VGND sky130_ef_sc_hd__decap_12
XTAP_TAPCELL_ROW_57_1248 VGND VPWR sky130_fd_sc_hd__tapvpwrvgnd_1
X_1657_ A_reg\[11\] _0928_ _0930_ VGND VGND VPWR VPWR _0933_ sky130_fd_sc_hd__o21ba_1
XPHY_EDGE_ROW_44_Left_198 VGND VGND VPWR VPWR sky130_fd_sc_hd__decap_3
XFILLER_144_29 VPWR VGND VPWR VGND sky130_ef_sc_hd__decap_12
XFILLER_98_440 VPWR VGND VPWR VGND sky130_ef_sc_hd__decap_12
XFILLER_86_602 VGND VGND VPWR VPWR sky130_fd_sc_hd__decap_3
XTAP_TAPCELL_ROW_70_1448 VGND VPWR sky130_fd_sc_hd__tapvpwrvgnd_1
XFILLER_59_838 VGND VGND VPWR VPWR sky130_fd_sc_hd__fill_2
XFILLER_59_827 VGND VGND VPWR VPWR sky130_fd_sc_hd__fill_1
XFILLER_58_304 VGND VGND VPWR VPWR sky130_fd_sc_hd__decap_4
XFILLER_140_581 VGND VGND VPWR VPWR sky130_fd_sc_hd__decap_6
XTAP_TAPCELL_ROW_70_1459 VGND VPWR sky130_fd_sc_hd__tapvpwrvgnd_1
XFILLER_100_445 VGND VGND VPWR VPWR sky130_fd_sc_hd__fill_2
XFILLER_85_167 VGND VGND VPWR VPWR sky130_fd_sc_hd__fill_1
XFILLER_85_145 VGND VGND VPWR VPWR sky130_fd_sc_hd__fill_1
X_3258_ clknet_3_7__leaf_clk _0041_ net36 VGND VGND VPWR VPWR net38 sky130_fd_sc_hd__dfrtp_1
XFILLER_37_27 VPWR VGND VPWR VGND sky130_ef_sc_hd__decap_12
XFILLER_66_370 VPWR VGND VPWR VGND sky130_ef_sc_hd__decap_12
X_2209_ _1464_ _1465_ VGND VGND VPWR VPWR _1466_ sky130_fd_sc_hd__nand2_1
XFILLER_39_573 VPWR VGND VPWR VGND sky130_ef_sc_hd__decap_12
X_3189_ _0790_ _0837_ _0845_ _0870_ VGND VGND VPWR VPWR _0872_ sky130_fd_sc_hd__o211a_1
XTAP_TAPCELL_ROW_1_344 VGND VPWR sky130_fd_sc_hd__tapvpwrvgnd_1
XTAP_TAPCELL_ROW_1_355 VGND VPWR sky130_fd_sc_hd__tapvpwrvgnd_1
XFILLER_54_576 VPWR VGND VPWR VGND sky130_ef_sc_hd__decap_12
XFILLER_53_15 VGND VGND VPWR VPWR sky130_fd_sc_hd__fill_2
XFILLER_42_738 VPWR VGND VPWR VGND sky130_ef_sc_hd__decap_12
XTAP_TAPCELL_ROW_85_1691 VGND VPWR sky130_fd_sc_hd__tapvpwrvgnd_1
XFILLER_53_48 VGND VGND VPWR VPWR sky130_fd_sc_hd__decap_8
XFILLER_139_125 VPWR VGND VPWR VGND sky130_ef_sc_hd__decap_12
XFILLER_10_613 VPWR VGND VPWR VGND sky130_ef_sc_hd__decap_12
XFILLER_139_169 VPWR VGND VPWR VGND sky130_ef_sc_hd__decap_12
XFILLER_108_501 VPWR VGND VPWR VGND sky130_ef_sc_hd__decap_12
XFILLER_10_657 VPWR VGND VPWR VGND sky130_ef_sc_hd__decap_12
XFILLER_6_617 VGND VGND VPWR VPWR sky130_fd_sc_hd__decap_4
XFILLER_148_681 VPWR VGND VPWR VGND sky130_ef_sc_hd__decap_12
XANTENNA__3258__CLK clknet_3_7__leaf_clk VGND VGND VPWR VPWR sky130_fd_sc_hd__diode_2
XANTENNA__1729__B1 Encode_EN VGND VGND VPWR VPWR sky130_fd_sc_hd__diode_2
XFILLER_5_105 VGND VGND VPWR VPWR sky130_fd_sc_hd__decap_6
XTAP_TAPCELL_ROW_20_652 VGND VPWR sky130_fd_sc_hd__tapvpwrvgnd_1
XFILLER_118_41 VPWR VGND VPWR VGND sky130_ef_sc_hd__decap_12
XFILLER_108_556 VPWR VGND VPWR VGND sky130_ef_sc_hd__decap_12
XFILLER_5_149 VPWR VGND VPWR VGND sky130_ef_sc_hd__decap_12
XFILLER_150_301 VGND VGND VPWR VPWR sky130_fd_sc_hd__decap_6
XTAP_TAPCELL_ROW_116_2190 VGND VPWR sky130_fd_sc_hd__tapvpwrvgnd_1
XFILLER_108_589 VPWR VGND VPWR VGND sky130_ef_sc_hd__decap_12
XFILLER_150_345 VPWR VGND VPWR VGND sky130_ef_sc_hd__decap_12
XFILLER_123_559 VGND VGND VPWR VPWR sky130_fd_sc_hd__fill_1
XFILLER_118_85 VPWR VGND VPWR VGND sky130_ef_sc_hd__decap_12
XTAP_TAPCELL_ROW_9_477 VGND VPWR sky130_fd_sc_hd__tapvpwrvgnd_1
XFILLER_2_867 VGND VGND VPWR VPWR sky130_fd_sc_hd__fill_1
XFILLER_150_389 VPWR VGND VPWR VGND sky130_ef_sc_hd__decap_12
XFILLER_110_209 VPWR VGND VPWR VGND sky130_ef_sc_hd__decap_12
XFILLER_103_261 VPWR VGND VPWR VGND sky130_ef_sc_hd__decap_12
XFILLER_89_473 VPWR VGND VPWR VGND sky130_ef_sc_hd__decap_12
XFILLER_78_89 VGND VGND VPWR VPWR sky130_fd_sc_hd__fill_1
XFILLER_78_78 VGND VGND VPWR VPWR sky130_fd_sc_hd__decap_6
XANTENNA__2154__B1 A_reg\[13\] VGND VGND VPWR VPWR sky130_fd_sc_hd__diode_2
XFILLER_77_657 VPWR VGND VPWR VGND sky130_ef_sc_hd__decap_12
XFILLER_49_337 VGND VGND VPWR VPWR sky130_fd_sc_hd__decap_3
XFILLER_64_307 VGND VGND VPWR VPWR sky130_fd_sc_hd__fill_1
XFILLER_76_189 VGND VGND VPWR VPWR sky130_fd_sc_hd__decap_6
XFILLER_58_893 VPWR VGND VPWR VGND sky130_ef_sc_hd__decap_12
XFILLER_18_713 VPWR VGND VPWR VGND sky130_ef_sc_hd__decap_12
XFILLER_73_841 VPWR VGND VPWR VGND sky130_ef_sc_hd__decap_12
XFILLER_17_223 VGND VGND VPWR VPWR sky130_fd_sc_hd__fill_1
XFILLER_18_757 VPWR VGND VPWR VGND sky130_ef_sc_hd__decap_12
XFILLER_150_83 VGND VGND VPWR VPWR sky130_fd_sc_hd__fill_1
XFILLER_72_373 VGND VGND VPWR VPWR sky130_fd_sc_hd__fill_1
XFILLER_60_513 VPWR VGND VPWR VGND sky130_ef_sc_hd__decap_12
XFILLER_17_278 VGND VGND VPWR VPWR sky130_fd_sc_hd__fill_2
XFILLER_27_93 VPWR VGND VPWR VGND sky130_ef_sc_hd__decap_12
XTAP_TAPCELL_ROW_28_774 VGND VPWR sky130_fd_sc_hd__tapvpwrvgnd_1
XTAP_TAPCELL_ROW_28_785 VGND VPWR sky130_fd_sc_hd__tapvpwrvgnd_1
XFILLER_33_727 VGND VGND VPWR VPWR sky130_fd_sc_hd__fill_1
XFILLER_45_587 VPWR VGND VPWR VGND sky130_ef_sc_hd__decap_12
XFILLER_60_557 VGND VGND VPWR VPWR sky130_fd_sc_hd__decap_3
XFILLER_32_259 VGND VGND VPWR VPWR sky130_fd_sc_hd__fill_1
XTAP_TAPCELL_ROW_136_2511 VGND VPWR sky130_fd_sc_hd__tapvpwrvgnd_1
XTAP_TAPCELL_ROW_136_2500 VGND VPWR sky130_fd_sc_hd__tapvpwrvgnd_1
XFILLER_43_81 VPWR VGND VPWR VGND sky130_ef_sc_hd__decap_12
XFILLER_118_309 VPWR VGND VPWR VGND sky130_ef_sc_hd__decap_12
XFILLER_127_821 VPWR VGND VPWR VGND sky130_ef_sc_hd__decap_12
XFILLER_127_865 VPWR VGND VPWR VGND sky130_ef_sc_hd__decap_12
X_2560_ u_crt.r1\[2\] _0910_ _0184_ _0305_ VGND VGND VPWR VPWR _0031_ sky130_fd_sc_hd__a22o_1
XANTENNA__2251__A A_reg\[3\] VGND VGND VPWR VPWR sky130_fd_sc_hd__diode_2
XFILLER_142_813 VPWR VGND VPWR VGND sky130_ef_sc_hd__decap_12
X_2491_ a_r1\[2\] b_r1\[2\] VGND VGND VPWR VPWR _0239_ sky130_fd_sc_hd__or2_1
XANTENNA__2145__B1 _0911_ VGND VGND VPWR VPWR sky130_fd_sc_hd__diode_2
XFILLER_68_613 VGND VGND VPWR VPWR sky130_fd_sc_hd__decap_4
XFILLER_4_53 VPWR VGND VPWR VGND sky130_ef_sc_hd__decap_12
XFILLER_122_581 VGND VGND VPWR VPWR sky130_fd_sc_hd__decap_6
XFILLER_68_657 VPWR VGND VPWR VGND sky130_ef_sc_hd__decap_12
XFILLER_68_624 VPWR VGND VPWR VGND sky130_ef_sc_hd__decap_12
XTAP_TAPCELL_ROW_52_1167 VGND VPWR sky130_fd_sc_hd__tapvpwrvgnd_1
XTAP_TAPCELL_ROW_52_1156 VGND VPWR sky130_fd_sc_hd__tapvpwrvgnd_1
XFILLER_4_97 VPWR VGND VPWR VGND sky130_ef_sc_hd__decap_12
XTAP_TAPCELL_ROW_147_2684 VGND VPWR sky130_fd_sc_hd__tapvpwrvgnd_1
XFILLER_95_443 VGND VGND VPWR VPWR sky130_fd_sc_hd__decap_4
XFILLER_67_167 VGND VGND VPWR VPWR sky130_fd_sc_hd__fill_1
X_3112_ _0777_ _0778_ _0798_ VGND VGND VPWR VPWR _0800_ sky130_fd_sc_hd__and3_1
X_3043_ _0727_ _0729_ VGND VGND VPWR VPWR _0731_ sky130_fd_sc_hd__xnor2_1
XFILLER_91_671 VGND VGND VPWR VPWR sky130_fd_sc_hd__fill_1
XFILLER_63_373 VPWR VGND VPWR VGND sky130_ef_sc_hd__decap_12
XFILLER_36_565 VPWR VGND VPWR VGND sky130_ef_sc_hd__decap_12
XFILLER_23_237 VPWR VGND VPWR VGND sky130_ef_sc_hd__decap_12
XFILLER_24_749 VGND VGND VPWR VPWR sky130_fd_sc_hd__decap_6
XANTENNA__2860__S _0383_ VGND VGND VPWR VPWR sky130_fd_sc_hd__diode_2
XFILLER_137_629 VPWR VGND VPWR VGND sky130_ef_sc_hd__decap_12
XFILLER_31_281 VPWR VGND VPWR VGND sky130_ef_sc_hd__decap_12
XFILLER_136_139 VGND VGND VPWR VPWR sky130_fd_sc_hd__fill_1
X_2827_ net53 X_crt\[9\] _0553_ VGND VGND VPWR VPWR _0050_ sky130_fd_sc_hd__mux2_1
X_2758_ _0493_ _0497_ _0484_ VGND VGND VPWR VPWR _0498_ sky130_fd_sc_hd__a21o_1
XPHY_EDGE_ROW_52_Left_206 VGND VGND VPWR VPWR sky130_fd_sc_hd__decap_3
XFILLER_145_673 VPWR VGND VPWR VGND sky130_ef_sc_hd__decap_12
XFILLER_132_301 VGND VGND VPWR VPWR sky130_fd_sc_hd__decap_6
X_1709_ _0974_ _0981_ _0978_ VGND VGND VPWR VPWR _0985_ sky130_fd_sc_hd__o21ba_1
XFILLER_132_345 VPWR VGND VPWR VGND sky130_ef_sc_hd__decap_12
X_2689_ b_r3\[0\] a_r3\[2\] b_r3\[2\] a_r3\[0\] VGND VGND VPWR VPWR _0429_ sky130_fd_sc_hd__a22o_1
XFILLER_132_389 VPWR VGND VPWR VGND sky130_ef_sc_hd__decap_12
XANTENNA__2136__A0 B_reg\[3\] VGND VGND VPWR VPWR sky130_fd_sc_hd__diode_2
XFILLER_48_15 VPWR VGND VPWR VGND sky130_ef_sc_hd__decap_12
XTAP_TAPCELL_ROW_6_425 VGND VPWR sky130_fd_sc_hd__tapvpwrvgnd_1
XFILLER_101_721 VGND VGND VPWR VPWR sky130_fd_sc_hd__decap_6
XFILLER_86_421 VPWR VGND VPWR VGND sky130_ef_sc_hd__decap_12
XFILLER_59_624 VGND VGND VPWR VPWR sky130_fd_sc_hd__decap_3
XFILLER_101_765 VPWR VGND VPWR VGND sky130_ef_sc_hd__decap_12
XFILLER_100_253 VPWR VGND VPWR VGND sky130_ef_sc_hd__decap_12
XTAP_TAPCELL_ROW_87_1720 VGND VPWR sky130_fd_sc_hd__tapvpwrvgnd_1
XFILLER_73_104 VGND VGND VPWR VPWR sky130_fd_sc_hd__decap_8
XFILLER_58_189 VGND VGND VPWR VPWR sky130_fd_sc_hd__decap_6
XFILLER_104_65 VPWR VGND VPWR VGND sky130_ef_sc_hd__decap_12
XTAP_TAPCELL_ROW_87_1731 VGND VPWR sky130_fd_sc_hd__tapvpwrvgnd_1
XFILLER_73_137 VGND VGND VPWR VPWR sky130_fd_sc_hd__fill_2
XPHY_EDGE_ROW_61_Left_215 VGND VGND VPWR VPWR sky130_fd_sc_hd__decap_3
XFILLER_55_841 VGND VGND VPWR VPWR sky130_fd_sc_hd__decap_8
XFILLER_27_521 VGND VGND VPWR VPWR sky130_fd_sc_hd__fill_1
XFILLER_54_351 VGND VGND VPWR VPWR sky130_fd_sc_hd__decap_4
XFILLER_15_727 VGND VGND VPWR VPWR sky130_fd_sc_hd__fill_1
XFILLER_82_693 VGND VGND VPWR VPWR sky130_fd_sc_hd__decap_6
XTAP_TAPCELL_ROW_25_733 VGND VPWR sky130_fd_sc_hd__tapvpwrvgnd_1
XFILLER_147_3 VPWR VGND VPWR VGND sky130_ef_sc_hd__decap_12
XFILLER_120_53 VPWR VGND VPWR VGND sky130_ef_sc_hd__decap_12
XFILLER_42_557 VPWR VGND VPWR VGND sky130_ef_sc_hd__decap_12
XFILLER_120_97 VPWR VGND VPWR VGND sky130_ef_sc_hd__decap_12
XFILLER_10_421 VPWR VGND VPWR VGND sky130_ef_sc_hd__decap_12
XFILLER_13_51 VGND VGND VPWR VPWR sky130_fd_sc_hd__decap_4
XFILLER_22_281 VGND VGND VPWR VPWR sky130_fd_sc_hd__fill_1
XFILLER_129_51 VGND VGND VPWR VPWR sky130_fd_sc_hd__decap_4
XFILLER_109_821 VPWR VGND VPWR VGND sky130_ef_sc_hd__decap_12
XPHY_EDGE_ROW_70_Left_224 VGND VGND VPWR VPWR sky130_fd_sc_hd__decap_3
XFILLER_10_465 VGND VGND VPWR VPWR sky130_fd_sc_hd__decap_8
XFILLER_109_865 VPWR VGND VPWR VGND sky130_ef_sc_hd__decap_12
XTAP_TAPCELL_ROW_98_1893 VGND VPWR sky130_fd_sc_hd__tapvpwrvgnd_1
XANTENNA__2071__A B_reg\[2\] VGND VGND VPWR VPWR sky130_fd_sc_hd__diode_2
XFILLER_6_469 VGND VGND VPWR VPWR sky130_fd_sc_hd__decap_6
XFILLER_142_109 VPWR VGND VPWR VGND sky130_ef_sc_hd__decap_12
XFILLER_135_161 VGND VGND VPWR VPWR sky130_fd_sc_hd__decap_6
XTAP_TAPCELL_ROW_131_2430 VGND VPWR sky130_fd_sc_hd__tapvpwrvgnd_1
XFILLER_124_813 VPWR VGND VPWR VGND sky130_ef_sc_hd__decap_12
XTAP_TAPCELL_ROW_114_2149 VGND VPWR sky130_fd_sc_hd__tapvpwrvgnd_1
XFILLER_108_386 VGND VGND VPWR VPWR sky130_fd_sc_hd__decap_4
XFILLER_89_77 VPWR VGND VPWR VGND sky130_ef_sc_hd__decap_12
XANTENNA__3316__RESET_B net36 VGND VGND VPWR VPWR sky130_fd_sc_hd__diode_2
XFILLER_151_665 VGND VGND VPWR VPWR sky130_fd_sc_hd__decap_6
XFILLER_150_153 VPWR VGND VPWR VGND sky130_ef_sc_hd__decap_12
XFILLER_150_197 VPWR VGND VPWR VGND sky130_ef_sc_hd__decap_12
XFILLER_104_581 VGND VGND VPWR VPWR sky130_fd_sc_hd__decap_6
XTAP_TAPCELL_ROW_129_2392 VGND VPWR sky130_fd_sc_hd__tapvpwrvgnd_1
XFILLER_65_649 VPWR VGND VPWR VGND sky130_ef_sc_hd__decap_12
XFILLER_49_167 VGND VGND VPWR VPWR sky130_fd_sc_hd__fill_1
XFILLER_92_457 VPWR VGND VPWR VGND sky130_ef_sc_hd__decap_12
XFILLER_64_148 VPWR VGND VPWR VGND sky130_ef_sc_hd__decap_12
XFILLER_73_671 VGND VGND VPWR VPWR sky130_fd_sc_hd__fill_1
XFILLER_18_587 VGND VGND VPWR VPWR sky130_fd_sc_hd__fill_1
XFILLER_61_833 VGND VGND VPWR VPWR sky130_fd_sc_hd__decap_6
XFILLER_60_332 VPWR VGND VPWR VGND sky130_ef_sc_hd__decap_12
XFILLER_45_373 VPWR VGND VPWR VGND sky130_ef_sc_hd__decap_12
XFILLER_72_192 VGND VGND VPWR VPWR sky130_fd_sc_hd__fill_1
XFILLER_60_365 VPWR VGND VPWR VGND sky130_ef_sc_hd__decap_12
X_1991_ B_reg\[0\] _1246_ _1247_ _1253_ VGND VGND VPWR VPWR _1254_ sky130_fd_sc_hd__a31o_1
XFILLER_13_270 VGND VGND VPWR VPWR sky130_fd_sc_hd__decap_8
XFILLER_14_793 VPWR VGND VPWR VGND sky130_ef_sc_hd__decap_12
XFILLER_119_629 VPWR VGND VPWR VGND sky130_ef_sc_hd__decap_12
XPHY_EDGE_ROW_109_Left_263 VGND VGND VPWR VPWR sky130_fd_sc_hd__decap_3
XFILLER_13_281 VGND VGND VPWR VPWR sky130_fd_sc_hd__decap_6
XFILLER_118_139 VGND VGND VPWR VPWR sky130_fd_sc_hd__fill_1
X_2612_ _0353_ _0356_ VGND VGND VPWR VPWR _0357_ sky130_fd_sc_hd__nand2_1
XFILLER_62_3 VPWR VGND VPWR VGND sky130_ef_sc_hd__decap_12
XFILLER_127_673 VPWR VGND VPWR VGND sky130_ef_sc_hd__decap_12
XFILLER_114_301 VGND VGND VPWR VPWR sky130_fd_sc_hd__decap_6
X_2543_ _0285_ _0288_ _0290_ VGND VGND VPWR VPWR _0291_ sky130_fd_sc_hd__o21a_1
XFILLER_142_643 VGND VGND VPWR VPWR sky130_fd_sc_hd__fill_1
XFILLER_114_345 VPWR VGND VPWR VGND sky130_ef_sc_hd__decap_12
XTAP_TAPCELL_ROW_149_2713 VGND VPWR sky130_fd_sc_hd__tapvpwrvgnd_1
XFILLER_130_805 VGND VGND VPWR VPWR sky130_fd_sc_hd__decap_6
XFILLER_102_518 VPWR VGND VPWR VGND sky130_ef_sc_hd__decap_12
X_2474_ a_r1\[1\] b_r1\[1\] VGND VGND VPWR VPWR _0222_ sky130_fd_sc_hd__and2_1
XFILLER_130_849 VPWR VGND VPWR VGND sky130_ef_sc_hd__decap_12
XPHY_EDGE_ROW_118_Left_272 VGND VGND VPWR VPWR sky130_fd_sc_hd__decap_3
XFILLER_114_389 VPWR VGND VPWR VGND sky130_ef_sc_hd__decap_12
XFILLER_95_273 VGND VGND VPWR VPWR sky130_fd_sc_hd__decap_6
XANTENNA__2855__S _0383_ VGND VGND VPWR VPWR sky130_fd_sc_hd__diode_2
XFILLER_18_29 VPWR VGND VPWR VGND sky130_ef_sc_hd__decap_12
XFILLER_55_137 VPWR VGND VPWR VGND sky130_ef_sc_hd__decap_12
XFILLER_37_841 VPWR VGND VPWR VGND sky130_ef_sc_hd__decap_12
X_3026_ _0712_ _0713_ VGND VGND VPWR VPWR _0714_ sky130_fd_sc_hd__and2b_1
XFILLER_63_181 VGND VGND VPWR VPWR sky130_fd_sc_hd__decap_8
XFILLER_52_833 VPWR VGND VPWR VGND sky130_ef_sc_hd__decap_12
XANTENNA__2841__A1 A_reg\[7\] VGND VGND VPWR VPWR sky130_fd_sc_hd__diode_2
XFILLER_24_513 VPWR VGND VPWR VGND sky130_ef_sc_hd__decap_12
XTAP_TAPCELL_ROW_82_1650 VGND VPWR sky130_fd_sc_hd__tapvpwrvgnd_1
XTAP_TAPCELL_ROW_65_1369 VGND VPWR sky130_fd_sc_hd__tapvpwrvgnd_1
XFILLER_52_877 VGND VGND VPWR VPWR sky130_fd_sc_hd__decap_3
XFILLER_51_332 VGND VGND VPWR VPWR sky130_fd_sc_hd__decap_4
XFILLER_24_557 VPWR VGND VPWR VGND sky130_ef_sc_hd__decap_12
XPHY_EDGE_ROW_127_Left_281 VGND VGND VPWR VPWR sky130_fd_sc_hd__decap_3
XFILLER_138_905 VGND VGND VPWR VPWR sky130_fd_sc_hd__decap_4
Xclkload5 clknet_3_5__leaf_clk VGND VGND VPWR VPWR clkload5/Y sky130_fd_sc_hd__clkinvlp_4
XFILLER_50_27 VGND VGND VPWR VPWR sky130_fd_sc_hd__fill_1
XFILLER_124_109 VPWR VGND VPWR VGND sky130_ef_sc_hd__decap_12
XFILLER_117_161 VGND VGND VPWR VPWR sky130_fd_sc_hd__decap_6
XFILLER_106_813 VPWR VGND VPWR VGND sky130_ef_sc_hd__decap_12
XPHY_EDGE_ROW_136_Left_290 VGND VGND VPWR VPWR sky130_fd_sc_hd__decap_3
XFILLER_133_665 VGND VGND VPWR VPWR sky130_fd_sc_hd__decap_6
XFILLER_132_153 VPWR VGND VPWR VGND sky130_ef_sc_hd__decap_12
XFILLER_79_719 VGND VGND VPWR VPWR sky130_fd_sc_hd__decap_8
XFILLER_132_197 VPWR VGND VPWR VGND sky130_ef_sc_hd__decap_12
XFILLER_59_69 VPWR VGND VPWR VGND sky130_ef_sc_hd__decap_12
XFILLER_87_741 VPWR VGND VPWR VGND sky130_ef_sc_hd__decap_12
XFILLER_87_785 VPWR VGND VPWR VGND sky130_ef_sc_hd__decap_12
XFILLER_86_251 VGND VGND VPWR VPWR sky130_fd_sc_hd__fill_1
XFILLER_19_329 VGND VGND VPWR VPWR sky130_fd_sc_hd__decap_6
XFILLER_75_57 VPWR VGND VPWR VGND sky130_ef_sc_hd__decap_12
XFILLER_74_457 VPWR VGND VPWR VGND sky130_ef_sc_hd__decap_12
XFILLER_61_107 VGND VGND VPWR VPWR sky130_fd_sc_hd__decap_4
XFILLER_55_671 VGND VGND VPWR VPWR sky130_fd_sc_hd__fill_1
XFILLER_70_630 VGND VGND VPWR VPWR sky130_fd_sc_hd__decap_3
XFILLER_27_373 VGND VGND VPWR VPWR sky130_fd_sc_hd__decap_8
XFILLER_42_332 VPWR VGND VPWR VGND sky130_ef_sc_hd__decap_12
XFILLER_43_877 VPWR VGND VPWR VGND sky130_ef_sc_hd__decap_12
XFILLER_91_89 VGND VGND VPWR VPWR sky130_fd_sc_hd__decap_4
XFILLER_11_741 VPWR VGND VPWR VGND sky130_ef_sc_hd__decap_12
XFILLER_24_83 VGND VGND VPWR VPWR sky130_fd_sc_hd__fill_1
XFILLER_10_251 VGND VGND VPWR VPWR sky130_fd_sc_hd__fill_1
XFILLER_11_785 VPWR VGND VPWR VGND sky130_ef_sc_hd__decap_12
XFILLER_10_284 VGND VGND VPWR VPWR sky130_fd_sc_hd__decap_4
XFILLER_143_429 VPWR VGND VPWR VGND sky130_ef_sc_hd__decap_12
XFILLER_109_673 VPWR VGND VPWR VGND sky130_ef_sc_hd__decap_12
XFILLER_6_277 VGND VGND VPWR VPWR sky130_fd_sc_hd__decap_8
XFILLER_124_643 VGND VGND VPWR VPWR sky130_fd_sc_hd__fill_1
XFILLER_112_805 VGND VGND VPWR VPWR sky130_fd_sc_hd__decap_6
XFILLER_97_505 VGND VGND VPWR VPWR sky130_fd_sc_hd__decap_8
XFILLER_151_473 VPWR VGND VPWR VGND sky130_ef_sc_hd__decap_12
XFILLER_112_849 VPWR VGND VPWR VGND sky130_ef_sc_hd__decap_12
XFILLER_111_337 VPWR VGND VPWR VGND sky130_ef_sc_hd__decap_12
X_2190_ A_reg\[8\] _1441_ _1443_ _1444_ VGND VGND VPWR VPWR _1447_ sky130_fd_sc_hd__a22o_1
XTAP_TAPCELL_ROW_144_2632 VGND VPWR sky130_fd_sc_hd__tapvpwrvgnd_1
XFILLER_120_893 VPWR VGND VPWR VGND sky130_ef_sc_hd__decap_12
XFILLER_77_251 VPWR VGND VPWR VGND sky130_ef_sc_hd__decap_12
XTAP_TAPCELL_ROW_144_2643 VGND VPWR sky130_fd_sc_hd__tapvpwrvgnd_1
XFILLER_92_221 VPWR VGND VPWR VGND sky130_ef_sc_hd__decap_12
XFILLER_77_295 VGND VGND VPWR VPWR sky130_fd_sc_hd__decap_8
XFILLER_19_841 VPWR VGND VPWR VGND sky130_ef_sc_hd__decap_12
XFILLER_37_137 VPWR VGND VPWR VGND sky130_ef_sc_hd__decap_12
XFILLER_93_777 VGND VGND VPWR VPWR sky130_fd_sc_hd__decap_6
XFILLER_92_265 VPWR VGND VPWR VGND sky130_ef_sc_hd__decap_12
XFILLER_65_468 VGND VGND VPWR VPWR sky130_fd_sc_hd__decap_8
XFILLER_18_384 VPWR VGND VPWR VGND sky130_ef_sc_hd__decap_12
XFILLER_45_181 VPWR VGND VPWR VGND sky130_ef_sc_hd__decap_12
XFILLER_61_641 VGND VGND VPWR VPWR sky130_fd_sc_hd__decap_8
XFILLER_61_685 VPWR VGND VPWR VGND sky130_ef_sc_hd__decap_12
XTAP_TAPCELL_ROW_47_1088 VGND VPWR sky130_fd_sc_hd__tapvpwrvgnd_1
XFILLER_21_505 VPWR VGND VPWR VGND sky130_ef_sc_hd__decap_12
XTAP_TAPCELL_ROW_47_1077 VGND VPWR sky130_fd_sc_hd__tapvpwrvgnd_1
X_1974_ _1238_ VGND VGND VPWR VPWR _1239_ sky130_fd_sc_hd__inv_2
XTAP_TAPCELL_ROW_16_585 VGND VPWR sky130_fd_sc_hd__tapvpwrvgnd_1
XFILLER_146_245 VGND VGND VPWR VPWR sky130_fd_sc_hd__decap_6
XANTENNA__3238__RESET_B net36 VGND VGND VPWR VPWR sky130_fd_sc_hd__diode_2
XTAP_TAPCELL_ROW_60_1299 VGND VPWR sky130_fd_sc_hd__tapvpwrvgnd_1
XTAP_TAPCELL_ROW_60_1288 VGND VPWR sky130_fd_sc_hd__tapvpwrvgnd_1
XFILLER_146_289 VPWR VGND VPWR VGND sky130_ef_sc_hd__decap_12
XFILLER_106_109 VPWR VGND VPWR VGND sky130_ef_sc_hd__decap_12
XANTENNA__3319__CLK clknet_3_5__leaf_clk VGND VGND VPWR VPWR sky130_fd_sc_hd__diode_2
XFILLER_115_665 VGND VGND VPWR VPWR sky130_fd_sc_hd__decap_6
XFILLER_114_153 VPWR VGND VPWR VGND sky130_ef_sc_hd__decap_12
X_2526_ _0243_ _0238_ VGND VGND VPWR VPWR _0274_ sky130_fd_sc_hd__nand2b_1
XFILLER_130_613 VPWR VGND VPWR VGND sky130_ef_sc_hd__decap_12
X_2457_ _0195_ _0197_ VGND VGND VPWR VPWR _0207_ sky130_fd_sc_hd__or2_1
XFILLER_130_657 VPWR VGND VPWR VGND sky130_ef_sc_hd__decap_12
XFILLER_114_197 VPWR VGND VPWR VGND sky130_ef_sc_hd__decap_12
XFILLER_69_741 VPWR VGND VPWR VGND sky130_ef_sc_hd__decap_12
XFILLER_29_39 VPWR VGND VPWR VGND sky130_ef_sc_hd__decap_12
XFILLER_152_29 VPWR VGND VPWR VGND sky130_ef_sc_hd__decap_12
X_2388_ _0131_ _0133_ _0132_ VGND VGND VPWR VPWR _0142_ sky130_fd_sc_hd__a21bo_1
XFILLER_69_785 VPWR VGND VPWR VGND sky130_ef_sc_hd__decap_12
XFILLER_68_251 VGND VGND VPWR VPWR sky130_fd_sc_hd__fill_1
XFILLER_56_413 VGND VGND VPWR VPWR sky130_fd_sc_hd__decap_6
XFILLER_84_744 VPWR VGND VPWR VGND sky130_ef_sc_hd__decap_12
XFILLER_56_435 VPWR VGND VPWR VGND sky130_ef_sc_hd__decap_12
XFILLER_71_405 VGND VGND VPWR VPWR sky130_fd_sc_hd__decap_8
XTAP_TAPCELL_ROW_67_1409 VGND VPWR sky130_fd_sc_hd__tapvpwrvgnd_1
XFILLER_45_27 VPWR VGND VPWR VGND sky130_ef_sc_hd__decap_12
XFILLER_71_449 VGND VGND VPWR VPWR sky130_fd_sc_hd__decap_8
X_3009_ _0695_ _0696_ VGND VGND VPWR VPWR _0697_ sky130_fd_sc_hd__nand2b_1
XFILLER_25_833 VGND VGND VPWR VPWR sky130_fd_sc_hd__decap_6
XFILLER_37_671 VGND VGND VPWR VPWR sky130_fd_sc_hd__fill_1
XTAP_TAPCELL_ROW_80_1609 VGND VPWR sky130_fd_sc_hd__tapvpwrvgnd_1
XFILLER_24_321 VGND VGND VPWR VPWR sky130_fd_sc_hd__fill_1
XFILLER_24_343 VPWR VGND VPWR VGND sky130_ef_sc_hd__decap_12
XFILLER_25_877 VPWR VGND VPWR VGND sky130_ef_sc_hd__decap_12
XFILLER_101_55 VGND VGND VPWR VPWR sky130_fd_sc_hd__fill_1
XFILLER_61_15 VPWR VGND VPWR VGND sky130_ef_sc_hd__decap_12
XFILLER_24_365 VPWR VGND VPWR VGND sky130_ef_sc_hd__decap_12
XFILLER_40_825 VGND VGND VPWR VPWR sky130_fd_sc_hd__decap_6
XTAP_TAPCELL_ROW_35_894 VGND VPWR sky130_fd_sc_hd__tapvpwrvgnd_1
XFILLER_40_858 VGND VGND VPWR VPWR sky130_fd_sc_hd__decap_8
XFILLER_40_869 VGND VGND VPWR VPWR sky130_fd_sc_hd__decap_8
XFILLER_138_713 VPWR VGND VPWR VGND sky130_ef_sc_hd__decap_12
XFILLER_138_757 VPWR VGND VPWR VGND sky130_ef_sc_hd__decap_12
XFILLER_137_223 VGND VGND VPWR VPWR sky130_fd_sc_hd__fill_1
XFILLER_125_429 VPWR VGND VPWR VGND sky130_ef_sc_hd__decap_12
XTAP_TAPCELL_ROW_111_2108 VGND VPWR sky130_fd_sc_hd__tapvpwrvgnd_1
XFILLER_106_643 VGND VGND VPWR VPWR sky130_fd_sc_hd__fill_1
XTAP_TAPCELL_ROW_95_1852 VGND VPWR sky130_fd_sc_hd__tapvpwrvgnd_1
XFILLER_4_737 VPWR VGND VPWR VGND sky130_ef_sc_hd__decap_12
XFILLER_3_225 VGND VGND VPWR VPWR sky130_fd_sc_hd__decap_8
XFILLER_79_505 VPWR VGND VPWR VGND sky130_ef_sc_hd__decap_12
XFILLER_10_41 VPWR VGND VPWR VGND sky130_ef_sc_hd__decap_12
XFILLER_133_473 VPWR VGND VPWR VGND sky130_ef_sc_hd__decap_12
XFILLER_126_41 VPWR VGND VPWR VGND sky130_ef_sc_hd__decap_12
XFILLER_10_85 VPWR VGND VPWR VGND sky130_ef_sc_hd__decap_12
XFILLER_126_85 VPWR VGND VPWR VGND sky130_ef_sc_hd__decap_12
XFILLER_120_189 VGND VGND VPWR VPWR sky130_fd_sc_hd__decap_6
XTAP_TAPCELL_ROW_126_2351 VGND VPWR sky130_fd_sc_hd__tapvpwrvgnd_1
XTAP_TAPCELL_ROW_126_2340 VGND VPWR sky130_fd_sc_hd__tapvpwrvgnd_1
XFILLER_102_893 VPWR VGND VPWR VGND sky130_ef_sc_hd__decap_12
XFILLER_74_221 VPWR VGND VPWR VGND sky130_ef_sc_hd__decap_12
XFILLER_19_137 VPWR VGND VPWR VGND sky130_ef_sc_hd__decap_12
XFILLER_75_766 VPWR VGND VPWR VGND sky130_ef_sc_hd__decap_12
XFILLER_74_265 VPWR VGND VPWR VGND sky130_ef_sc_hd__decap_12
XFILLER_90_725 VPWR VGND VPWR VGND sky130_ef_sc_hd__decap_12
XFILLER_16_811 VGND VGND VPWR VPWR sky130_fd_sc_hd__fill_1
XFILLER_28_693 VGND VGND VPWR VPWR sky130_fd_sc_hd__decap_6
XANTENNA__2805__A1 _0184_ VGND VGND VPWR VPWR sky130_fd_sc_hd__diode_2
XFILLER_90_769 VPWR VGND VPWR VGND sky130_ef_sc_hd__decap_12
XFILLER_27_181 VPWR VGND VPWR VGND sky130_ef_sc_hd__decap_12
XFILLER_35_93 VPWR VGND VPWR VGND sky130_ef_sc_hd__decap_12
XFILLER_43_685 VPWR VGND VPWR VGND sky130_ef_sc_hd__decap_12
XTAP_TAPCELL_ROW_104_1992 VGND VPWR sky130_fd_sc_hd__tapvpwrvgnd_1
XTAP_TAPCELL_ROW_13_533 VGND VPWR sky130_fd_sc_hd__tapvpwrvgnd_1
XFILLER_30_335 VPWR VGND VPWR VGND sky130_ef_sc_hd__decap_12
XFILLER_42_184 VPWR VGND VPWR VGND sky130_ef_sc_hd__decap_12
XTAP_TAPCELL_ROW_13_544 VGND VPWR sky130_fd_sc_hd__tapvpwrvgnd_1
XFILLER_128_245 VGND VGND VPWR VPWR sky130_fd_sc_hd__decap_6
XFILLER_128_289 VPWR VGND VPWR VGND sky130_ef_sc_hd__decap_12
XFILLER_7_553 VGND VGND VPWR VPWR sky130_fd_sc_hd__decap_6
X_1690_ _0964_ _0965_ _0958_ VGND VGND VPWR VPWR _0966_ sky130_fd_sc_hd__a21o_1
XFILLER_144_749 VGND VGND VPWR VPWR sky130_fd_sc_hd__decap_6
XFILLER_143_237 VPWR VGND VPWR VGND sky130_ef_sc_hd__decap_12
XFILLER_109_492 VPWR VGND VPWR VGND sky130_ef_sc_hd__decap_12
XFILLER_98_825 VPWR VGND VPWR VGND sky130_ef_sc_hd__decap_12
XFILLER_152_793 VPWR VGND VPWR VGND sky130_ef_sc_hd__decap_12
XFILLER_112_613 VPWR VGND VPWR VGND sky130_ef_sc_hd__decap_12
X_2311_ _1552_ _1560_ VGND VGND VPWR VPWR _1564_ sky130_fd_sc_hd__xor2_1
XFILLER_151_281 VPWR VGND VPWR VGND sky130_ef_sc_hd__decap_12
XFILLER_112_657 VPWR VGND VPWR VGND sky130_ef_sc_hd__decap_12
XFILLER_98_869 VPWR VGND VPWR VGND sky130_ef_sc_hd__decap_12
X_3291_ clknet_3_2__leaf_clk _0074_ net36 VGND VGND VPWR VPWR B_reg\[1\] sky130_fd_sc_hd__dfrtp_4
XFILLER_111_167 VGND VGND VPWR VPWR sky130_fd_sc_hd__fill_1
XFILLER_25_3 VPWR VGND VPWR VGND sky130_ef_sc_hd__decap_12
X_2242_ _1489_ _1490_ _1496_ _1497_ _1498_ VGND VGND VPWR VPWR _1499_ sky130_fd_sc_hd__o32a_1
XFILLER_65_210 VPWR VGND VPWR VGND sky130_ef_sc_hd__decap_12
X_2173_ _1419_ _1421_ _1427_ _1429_ VGND VGND VPWR VPWR _1430_ sky130_fd_sc_hd__a31o_1
XFILLER_66_777 VPWR VGND VPWR VGND sky130_ef_sc_hd__decap_12
XFILLER_53_405 VPWR VGND VPWR VGND sky130_ef_sc_hd__decap_12
XTAP_TAPCELL_ROW_49_1117 VGND VPWR sky130_fd_sc_hd__tapvpwrvgnd_1
XFILLER_65_276 VGND VGND VPWR VPWR sky130_fd_sc_hd__decap_4
XFILLER_19_671 VGND VGND VPWR VPWR sky130_fd_sc_hd__fill_1
XFILLER_53_449 VGND VGND VPWR VPWR sky130_fd_sc_hd__fill_1
XTAP_TAPCELL_ROW_62_1328 VGND VPWR sky130_fd_sc_hd__tapvpwrvgnd_1
XTAP_TAPCELL_ROW_62_1317 VGND VPWR sky130_fd_sc_hd__tapvpwrvgnd_1
XFILLER_22_825 VPWR VGND VPWR VGND sky130_ef_sc_hd__decap_12
XFILLER_21_335 VGND VGND VPWR VPWR sky130_fd_sc_hd__fill_1
XFILLER_22_869 VPWR VGND VPWR VGND sky130_ef_sc_hd__decap_12
XTAP_TAPCELL_ROW_32_842 VGND VPWR sky130_fd_sc_hd__tapvpwrvgnd_1
XFILLER_119_223 VGND VGND VPWR VPWR sky130_fd_sc_hd__fill_1
X_1957_ _1207_ _1221_ VGND VGND VPWR VPWR _1222_ sky130_fd_sc_hd__xnor2_1
XFILLER_135_727 VGND VGND VPWR VPWR sky130_fd_sc_hd__fill_1
X_1888_ _1155_ _1157_ _0886_ VGND VGND VPWR VPWR _1158_ sky130_fd_sc_hd__a21oi_1
XANTENNA__3291__CLK clknet_3_2__leaf_clk VGND VGND VPWR VPWR sky130_fd_sc_hd__diode_2
XTAP_TAPCELL_ROW_77_1571 VGND VPWR sky130_fd_sc_hd__tapvpwrvgnd_1
XTAP_TAPCELL_ROW_77_1560 VGND VPWR sky130_fd_sc_hd__tapvpwrvgnd_1
XFILLER_115_473 VPWR VGND VPWR VGND sky130_ef_sc_hd__decap_12
XFILLER_1_729 VPWR VGND VPWR VGND sky130_ef_sc_hd__decap_12
X_2509_ _0185_ _0256_ VGND VGND VPWR VPWR _0257_ sky130_fd_sc_hd__nor2_1
XFILLER_130_421 VPWR VGND VPWR VGND sky130_ef_sc_hd__decap_12
XTAP_TAPCELL_ROW_90_1771 VGND VPWR sky130_fd_sc_hd__tapvpwrvgnd_1
XFILLER_88_357 VGND VGND VPWR VPWR sky130_fd_sc_hd__decap_6
XFILLER_102_189 VGND VGND VPWR VPWR sky130_fd_sc_hd__decap_6
XFILLER_56_221 VPWR VGND VPWR VGND sky130_ef_sc_hd__decap_12
XFILLER_84_574 VPWR VGND VPWR VGND sky130_ef_sc_hd__decap_12
XFILLER_56_265 VGND VGND VPWR VPWR sky130_fd_sc_hd__decap_4
XFILLER_56_48 VPWR VGND VPWR VGND sky130_ef_sc_hd__decap_12
XFILLER_72_725 VPWR VGND VPWR VGND sky130_ef_sc_hd__decap_12
XFILLER_71_213 VGND VGND VPWR VPWR sky130_fd_sc_hd__decap_8
XFILLER_56_287 VPWR VGND VPWR VGND sky130_ef_sc_hd__decap_12
XFILLER_112_65 VPWR VGND VPWR VGND sky130_ef_sc_hd__decap_12
XFILLER_25_641 VPWR VGND VPWR VGND sky130_ef_sc_hd__decap_12
XTAP_TAPCELL_ROW_121_2270 VGND VPWR sky130_fd_sc_hd__tapvpwrvgnd_1
XFILLER_71_279 VGND VGND VPWR VPWR sky130_fd_sc_hd__fill_1
XFILLER_25_685 VPWR VGND VPWR VGND sky130_ef_sc_hd__decap_12
XFILLER_52_482 VPWR VGND VPWR VGND sky130_ef_sc_hd__decap_12
XFILLER_24_195 VGND VGND VPWR VPWR sky130_fd_sc_hd__fill_1
XFILLER_8_328 VPWR VGND VPWR VGND sky130_ef_sc_hd__decap_12
XFILLER_40_699 VGND VGND VPWR VPWR sky130_fd_sc_hd__fill_1
XFILLER_138_587 VGND VGND VPWR VPWR sky130_fd_sc_hd__fill_1
XFILLER_126_749 VGND VGND VPWR VPWR sky130_fd_sc_hd__decap_6
XFILLER_125_237 VPWR VGND VPWR VGND sky130_ef_sc_hd__decap_12
XFILLER_21_51 VGND VGND VPWR VPWR sky130_fd_sc_hd__decap_4
XFILLER_153_557 VGND VGND VPWR VPWR sky130_fd_sc_hd__fill_1
XFILLER_137_51 VGND VGND VPWR VPWR sky130_fd_sc_hd__decap_4
XFILLER_134_793 VPWR VGND VPWR VGND sky130_ef_sc_hd__decap_12
XFILLER_106_473 VGND VGND VPWR VPWR sky130_fd_sc_hd__decap_3
XFILLER_97_44 VPWR VGND VPWR VGND sky130_ef_sc_hd__decap_12
XFILLER_4_589 VGND VGND VPWR VPWR sky130_fd_sc_hd__fill_2
XFILLER_133_281 VPWR VGND VPWR VGND sky130_ef_sc_hd__decap_12
XFILLER_95_839 VGND VGND VPWR VPWR sky130_fd_sc_hd__fill_1
XFILLER_75_541 VPWR VGND VPWR VGND sky130_ef_sc_hd__decap_12
XFILLER_48_777 VGND VGND VPWR VPWR sky130_fd_sc_hd__decap_3
XFILLER_35_405 VGND VGND VPWR VPWR sky130_fd_sc_hd__decap_8
XFILLER_75_585 VGND VGND VPWR VPWR sky130_fd_sc_hd__fill_1
XFILLER_62_224 VGND VGND VPWR VPWR sky130_fd_sc_hd__fill_2
XTAP_TAPCELL_ROW_18_614 VGND VPWR sky130_fd_sc_hd__tapvpwrvgnd_1
XTAP_TAPCELL_ROW_18_625 VGND VPWR sky130_fd_sc_hd__tapvpwrvgnd_1
XFILLER_62_257 VPWR VGND VPWR VGND sky130_ef_sc_hd__decap_12
XFILLER_51_909 VGND VGND VPWR VPWR sky130_fd_sc_hd__fill_1
XFILLER_35_449 VPWR VGND VPWR VGND sky130_ef_sc_hd__decap_12
XFILLER_50_419 VGND VGND VPWR VPWR sky130_fd_sc_hd__fill_1
X_2860_ net18 B_reg\[10\] _0383_ VGND VGND VPWR VPWR _0083_ sky130_fd_sc_hd__mux2_1
XFILLER_30_121 VPWR VGND VPWR VGND sky130_ef_sc_hd__decap_12
XTAP_TAPCELL_ROW_44_1036 VGND VPWR sky130_fd_sc_hd__tapvpwrvgnd_1
XFILLER_148_307 VGND VGND VPWR VPWR sky130_fd_sc_hd__fill_1
XTAP_TAPCELL_ROW_139_2553 VGND VPWR sky130_fd_sc_hd__tapvpwrvgnd_1
XFILLER_31_655 VPWR VGND VPWR VGND sky130_ef_sc_hd__decap_12
X_1811_ A_reg\[3\] _1083_ VGND VGND VPWR VPWR _1084_ sky130_fd_sc_hd__nor2_1
X_2791_ _0528_ _0530_ _0522_ VGND VGND VPWR VPWR _0531_ sky130_fd_sc_hd__a21o_1
XFILLER_30_165 VPWR VGND VPWR VGND sky130_ef_sc_hd__decap_12
XFILLER_144_513 VPWR VGND VPWR VGND sky130_ef_sc_hd__decap_12
XFILLER_117_727 VGND VGND VPWR VPWR sky130_fd_sc_hd__fill_1
X_1742_ A_reg\[12\] _1007_ _1012_ _1013_ A_reg\[11\] VGND VGND VPWR VPWR _1015_ sky130_fd_sc_hd__a311o_1
XTAP_TAPCELL_ROW_152_2764 VGND VPWR sky130_fd_sc_hd__tapvpwrvgnd_1
XANTENNA__2701__B a_r3\[3\] VGND VGND VPWR VPWR sky130_fd_sc_hd__diode_2
X_1673_ _0890_ _0943_ _0945_ VGND VGND VPWR VPWR _0949_ sky130_fd_sc_hd__a21bo_1
XFILLER_144_557 VPWR VGND VPWR VGND sky130_ef_sc_hd__decap_12
XFILLER_112_421 VPWR VGND VPWR VGND sky130_ef_sc_hd__decap_12
XANTENNA__2190__A1 A_reg\[8\] VGND VGND VPWR VPWR sky130_fd_sc_hd__diode_2
XFILLER_98_699 VGND VGND VPWR VPWR sky130_fd_sc_hd__fill_1
X_3274_ clknet_3_4__leaf_clk _0057_ net36 VGND VGND VPWR VPWR A_reg\[0\] sky130_fd_sc_hd__dfrtp_4
XFILLER_85_349 VPWR VGND VPWR VGND sky130_ef_sc_hd__decap_12
XTAP_TAPCELL_ROW_72_1490 VGND VPWR sky130_fd_sc_hd__tapvpwrvgnd_1
X_2225_ _1467_ _1474_ _1470_ VGND VGND VPWR VPWR _1482_ sky130_fd_sc_hd__a21o_1
XFILLER_38_221 VPWR VGND VPWR VGND sky130_ef_sc_hd__decap_12
XFILLER_39_722 VGND VGND VPWR VPWR sky130_fd_sc_hd__decap_6
XFILLER_94_861 VGND VGND VPWR VPWR sky130_fd_sc_hd__decap_6
X_2156_ A_reg\[11\] _1408_ _1409_ _1411_ _0927_ VGND VGND VPWR VPWR _1413_ sky130_fd_sc_hd__a32o_1
XFILLER_26_29 VPWR VGND VPWR VGND sky130_ef_sc_hd__decap_12
XFILLER_26_416 VGND VGND VPWR VPWR sky130_fd_sc_hd__decap_4
XTAP_TAPCELL_ROW_37_923 VGND VPWR sky130_fd_sc_hd__tapvpwrvgnd_1
XFILLER_93_393 VPWR VGND VPWR VGND sky130_ef_sc_hd__decap_12
X_2087_ _1346_ _1347_ _1348_ VGND VGND VPWR VPWR _1349_ sky130_fd_sc_hd__o21a_1
XFILLER_54_769 VGND VGND VPWR VPWR sky130_fd_sc_hd__decap_8
XANTENNA__2863__S _0383_ VGND VGND VPWR VPWR sky130_fd_sc_hd__diode_2
XPHY_EDGE_ROW_5_Right_5 VGND VGND VPWR VPWR sky130_fd_sc_hd__decap_3
XANTENNA__2435__Y _0185_ VGND VGND VPWR VPWR sky130_fd_sc_hd__diode_2
XANTENNA__3253__RESET_B net36 VGND VGND VPWR VPWR sky130_fd_sc_hd__diode_2
XANTENNA__2164__A A_reg\[10\] VGND VGND VPWR VPWR sky130_fd_sc_hd__diode_2
XFILLER_139_329 VGND VGND VPWR VPWR sky130_fd_sc_hd__decap_6
XTAP_TAPCELL_ROW_79_1600 VGND VPWR sky130_fd_sc_hd__tapvpwrvgnd_1
X_2989_ _0676_ _0675_ VGND VGND VPWR VPWR _0677_ sky130_fd_sc_hd__and2b_1
XFILLER_22_699 VGND VGND VPWR VPWR sky130_fd_sc_hd__fill_1
XFILLER_147_373 VPWR VGND VPWR VGND sky130_ef_sc_hd__decap_12
XFILLER_108_749 VGND VGND VPWR VPWR sky130_fd_sc_hd__decap_6
XFILLER_107_237 VPWR VGND VPWR VGND sky130_ef_sc_hd__decap_12
XTAP_TAPCELL_ROW_92_1811 VGND VPWR sky130_fd_sc_hd__tapvpwrvgnd_1
XTAP_TAPCELL_ROW_92_1800 VGND VPWR sky130_fd_sc_hd__tapvpwrvgnd_1
XFILLER_116_793 VPWR VGND VPWR VGND sky130_ef_sc_hd__decap_12
XFILLER_131_741 VPWR VGND VPWR VGND sky130_ef_sc_hd__decap_12
XFILLER_115_281 VPWR VGND VPWR VGND sky130_ef_sc_hd__decap_12
XFILLER_103_421 VPWR VGND VPWR VGND sky130_ef_sc_hd__decap_12
XFILLER_88_121 VPWR VGND VPWR VGND sky130_ef_sc_hd__decap_12
XFILLER_1_559 VGND VGND VPWR VPWR sky130_fd_sc_hd__fill_1
XFILLER_131_785 VPWR VGND VPWR VGND sky130_ef_sc_hd__decap_12
XFILLER_130_251 VGND VGND VPWR VPWR sky130_fd_sc_hd__fill_1
XFILLER_88_165 VGND VGND VPWR VPWR sky130_fd_sc_hd__decap_6
XFILLER_77_839 VGND VGND VPWR VPWR sky130_fd_sc_hd__fill_1
XFILLER_76_316 VPWR VGND VPWR VGND sky130_ef_sc_hd__decap_12
XFILLER_67_69 VPWR VGND VPWR VGND sky130_ef_sc_hd__decap_12
XPHY_EDGE_ROW_150_Right_150 VGND VGND VPWR VPWR sky130_fd_sc_hd__decap_3
XTAP_TAPCELL_ROW_106_2029 VGND VPWR sky130_fd_sc_hd__tapvpwrvgnd_1
XFILLER_57_541 VPWR VGND VPWR VGND sky130_ef_sc_hd__decap_12
XFILLER_29_243 VPWR VGND VPWR VGND sky130_ef_sc_hd__decap_12
XFILLER_57_585 VGND VGND VPWR VPWR sky130_fd_sc_hd__decap_6
XTAP_TAPCELL_ROW_4_397 VGND VPWR sky130_fd_sc_hd__tapvpwrvgnd_1
XFILLER_17_405 VPWR VGND VPWR VGND sky130_ef_sc_hd__decap_12
XFILLER_17_449 VPWR VGND VPWR VGND sky130_ef_sc_hd__decap_12
XFILLER_45_769 VGND VGND VPWR VPWR sky130_fd_sc_hd__fill_1
XFILLER_32_419 VGND VGND VPWR VPWR sky130_fd_sc_hd__fill_1
XTAP_TAPCELL_ROW_101_1951 VGND VPWR sky130_fd_sc_hd__tapvpwrvgnd_1
XTAP_TAPCELL_ROW_101_1940 VGND VPWR sky130_fd_sc_hd__tapvpwrvgnd_1
XFILLER_9_615 VGND VGND VPWR VPWR sky130_fd_sc_hd__fill_1
XFILLER_12_121 VPWR VGND VPWR VGND sky130_ef_sc_hd__decap_12
XFILLER_139_841 VPWR VGND VPWR VGND sky130_ef_sc_hd__decap_12
XFILLER_12_165 VPWR VGND VPWR VGND sky130_ef_sc_hd__decap_12
XTAP_TAPCELL_ROW_23_694 VGND VPWR sky130_fd_sc_hd__tapvpwrvgnd_1
XFILLER_32_83 VGND VGND VPWR VPWR sky130_fd_sc_hd__fill_1
XFILLER_153_321 VPWR VGND VPWR VGND sky130_ef_sc_hd__decap_12
XFILLER_148_83 VGND VGND VPWR VPWR sky130_fd_sc_hd__fill_1
XFILLER_126_513 VPWR VGND VPWR VGND sky130_ef_sc_hd__decap_12
XFILLER_5_821 VPWR VGND VPWR VGND sky130_ef_sc_hd__decap_12
XFILLER_141_505 VPWR VGND VPWR VGND sky130_ef_sc_hd__decap_12
XTAP_TAPCELL_ROW_134_2483 VGND VPWR sky130_fd_sc_hd__tapvpwrvgnd_1
XTAP_TAPCELL_ROW_134_2472 VGND VPWR sky130_fd_sc_hd__tapvpwrvgnd_1
XFILLER_126_557 VPWR VGND VPWR VGND sky130_ef_sc_hd__decap_12
XFILLER_5_865 VPWR VGND VPWR VGND sky130_ef_sc_hd__decap_12
XFILLER_153_365 VPWR VGND VPWR VGND sky130_ef_sc_hd__decap_12
XFILLER_4_375 VGND VGND VPWR VPWR sky130_fd_sc_hd__fill_1
XFILLER_67_305 VPWR VGND VPWR VGND sky130_ef_sc_hd__decap_12
XFILLER_121_273 VGND VGND VPWR VPWR sky130_fd_sc_hd__decap_6
XFILLER_67_349 VGND VGND VPWR VPWR sky130_fd_sc_hd__decap_4
XFILLER_0_581 VGND VGND VPWR VPWR sky130_fd_sc_hd__decap_3
XFILLER_94_146 VPWR VGND VPWR VGND sky130_ef_sc_hd__decap_12
XFILLER_83_809 VPWR VGND VPWR VGND sky130_ef_sc_hd__decap_12
XFILLER_76_861 VGND VGND VPWR VPWR sky130_fd_sc_hd__decap_6
X_2010_ _1263_ _1271_ _1264_ VGND VGND VPWR VPWR _1272_ sky130_fd_sc_hd__o21a_1
XFILLER_36_725 VPWR VGND VPWR VGND sky130_ef_sc_hd__decap_12
XFILLER_91_853 VPWR VGND VPWR VGND sky130_ef_sc_hd__decap_12
XFILLER_75_393 VPWR VGND VPWR VGND sky130_ef_sc_hd__decap_12
XFILLER_24_909 VGND VGND VPWR VPWR sky130_fd_sc_hd__fill_1
XFILLER_36_769 VPWR VGND VPWR VGND sky130_ef_sc_hd__decap_12
XFILLER_91_897 VPWR VGND VPWR VGND sky130_ef_sc_hd__decap_12
X_2912_ _0594_ _0595_ VGND VGND VPWR VPWR _0600_ sky130_fd_sc_hd__xnor2_1
XFILLER_31_441 VGND VGND VPWR VPWR sky130_fd_sc_hd__decap_6
X_2843_ net16 A_reg\[9\] _0383_ VGND VGND VPWR VPWR _0066_ sky130_fd_sc_hd__mux2_1
XFILLER_31_485 VPWR VGND VPWR VGND sky130_ef_sc_hd__decap_12
X_2774_ _0504_ _0510_ VGND VGND VPWR VPWR _0514_ sky130_fd_sc_hd__xnor2_1
XFILLER_145_833 VGND VGND VPWR VPWR sky130_fd_sc_hd__decap_6
XFILLER_144_321 VPWR VGND VPWR VGND sky130_ef_sc_hd__decap_12
XFILLER_129_373 VPWR VGND VPWR VGND sky130_ef_sc_hd__decap_12
X_1725_ A_reg\[0\] _0998_ VGND VGND VPWR VPWR _1001_ sky130_fd_sc_hd__and2_1
XFILLER_8_681 VPWR VGND VPWR VGND sky130_ef_sc_hd__decap_12
XFILLER_145_877 VPWR VGND VPWR VGND sky130_ef_sc_hd__decap_12
XANTENNA__2431__B _0911_ VGND VGND VPWR VPWR sky130_fd_sc_hd__diode_2
XFILLER_144_365 VPWR VGND VPWR VGND sky130_ef_sc_hd__decap_12
XTAP_TAPCELL_ROW_57_1249 VGND VPWR sky130_fd_sc_hd__tapvpwrvgnd_1
XTAP_TAPCELL_ROW_57_1238 VGND VPWR sky130_fd_sc_hd__tapvpwrvgnd_1
X_1656_ _0919_ _0931_ _0914_ VGND VGND VPWR VPWR _0932_ sky130_fd_sc_hd__a21o_1
XFILLER_113_741 VPWR VGND VPWR VGND sky130_ef_sc_hd__decap_12
XANTENNA__2858__S _0383_ VGND VGND VPWR VPWR sky130_fd_sc_hd__diode_2
XFILLER_113_785 VPWR VGND VPWR VGND sky130_ef_sc_hd__decap_12
XFILLER_112_251 VGND VGND VPWR VPWR sky130_fd_sc_hd__fill_1
XFILLER_98_452 VGND VGND VPWR VPWR sky130_fd_sc_hd__decap_3
XFILLER_86_658 VGND VGND VPWR VPWR sky130_fd_sc_hd__fill_1
XFILLER_85_113 VPWR VGND VPWR VGND sky130_ef_sc_hd__decap_12
XTAP_TAPCELL_ROW_70_1449 VGND VPWR sky130_fd_sc_hd__tapvpwrvgnd_1
X_3257_ clknet_3_6__leaf_clk _0040_ net36 VGND VGND VPWR VPWR u_crt.r3\[3\] sky130_fd_sc_hd__dfrtp_2
XFILLER_37_39 VPWR VGND VPWR VGND sky130_ef_sc_hd__decap_12
XFILLER_39_541 VPWR VGND VPWR VGND sky130_ef_sc_hd__decap_12
X_3188_ _0870_ _0871_ X_crt\[4\] CRT_Start VGND VGND VPWR VPWR _0093_ sky130_fd_sc_hd__o2bb2a_1
X_2208_ _0892_ _1442_ _1455_ VGND VGND VPWR VPWR _1465_ sky130_fd_sc_hd__or3b_1
XFILLER_39_585 VPWR VGND VPWR VGND sky130_ef_sc_hd__decap_12
X_2139_ _0908_ _1394_ _1396_ VGND VGND VPWR VPWR _1398_ sky130_fd_sc_hd__a21o_1
XFILLER_66_382 VPWR VGND VPWR VGND sky130_ef_sc_hd__decap_12
XFILLER_54_533 VGND VGND VPWR VPWR sky130_fd_sc_hd__decap_8
XTAP_TAPCELL_ROW_1_345 VGND VPWR sky130_fd_sc_hd__tapvpwrvgnd_1
XFILLER_15_909 VGND VGND VPWR VPWR sky130_fd_sc_hd__fill_1
XFILLER_26_235 VPWR VGND VPWR VGND sky130_ef_sc_hd__decap_12
XFILLER_41_205 VGND VGND VPWR VPWR sky130_fd_sc_hd__decap_8
XTAP_TAPCELL_ROW_85_1692 VGND VPWR sky130_fd_sc_hd__tapvpwrvgnd_1
XFILLER_50_750 VGND VGND VPWR VPWR sky130_fd_sc_hd__decap_6
XFILLER_139_137 VPWR VGND VPWR VGND sky130_ef_sc_hd__decap_12
XFILLER_10_625 VPWR VGND VPWR VGND sky130_ef_sc_hd__decap_12
XFILLER_136_811 VGND VGND VPWR VPWR sky130_fd_sc_hd__fill_1
XFILLER_10_669 VPWR VGND VPWR VGND sky130_ef_sc_hd__decap_12
XANTENNA__3179__B1 _0912_ VGND VGND VPWR VPWR sky130_fd_sc_hd__diode_2
XFILLER_148_693 VGND VGND VPWR VPWR sky130_fd_sc_hd__decap_6
XFILLER_108_513 VPWR VGND VPWR VGND sky130_ef_sc_hd__decap_12
XTAP_TAPCELL_ROW_20_653 VGND VPWR sky130_fd_sc_hd__tapvpwrvgnd_1
XFILLER_147_181 VPWR VGND VPWR VGND sky130_ef_sc_hd__decap_12
XTAP_TAPCELL_ROW_116_2180 VGND VPWR sky130_fd_sc_hd__tapvpwrvgnd_1
XFILLER_108_568 VPWR VGND VPWR VGND sky130_ef_sc_hd__decap_12
XFILLER_123_505 VPWR VGND VPWR VGND sky130_ef_sc_hd__decap_12
XFILLER_118_53 VPWR VGND VPWR VGND sky130_ef_sc_hd__decap_12
XTAP_TAPCELL_ROW_116_2191 VGND VPWR sky130_fd_sc_hd__tapvpwrvgnd_1
XFILLER_2_813 VPWR VGND VPWR VGND sky130_ef_sc_hd__decap_12
XFILLER_118_97 VPWR VGND VPWR VGND sky130_ef_sc_hd__decap_12
XFILLER_150_357 VGND VGND VPWR VPWR sky130_fd_sc_hd__decap_6
XFILLER_49_305 VPWR VGND VPWR VGND sky130_ef_sc_hd__decap_12
XTAP_TAPCELL_ROW_9_478 VGND VPWR sky130_fd_sc_hd__tapvpwrvgnd_1
XANTENNA__2154__A1 A_reg\[15\] VGND VGND VPWR VPWR sky130_fd_sc_hd__diode_2
XFILLER_134_41 VPWR VGND VPWR VGND sky130_ef_sc_hd__decap_12
XFILLER_103_273 VGND VGND VPWR VPWR sky130_fd_sc_hd__decap_6
XFILLER_89_485 VPWR VGND VPWR VGND sky130_ef_sc_hd__decap_12
XFILLER_134_85 VPWR VGND VPWR VGND sky130_ef_sc_hd__decap_12
XFILLER_94_23 VGND VGND VPWR VPWR sky130_fd_sc_hd__fill_1
XANTENNA__2069__A B_reg\[3\] VGND VGND VPWR VPWR sky130_fd_sc_hd__diode_2
XFILLER_77_669 VGND VGND VPWR VPWR sky130_fd_sc_hd__decap_3
XFILLER_65_809 VPWR VGND VPWR VGND sky130_ef_sc_hd__decap_12
XFILLER_18_725 VPWR VGND VPWR VGND sky130_ef_sc_hd__decap_12
XFILLER_73_853 VPWR VGND VPWR VGND sky130_ef_sc_hd__decap_12
XFILLER_57_393 VGND VGND VPWR VPWR sky130_fd_sc_hd__decap_4
XANTENNA_input12_A A_in[5] VGND VGND VPWR VPWR sky130_fd_sc_hd__diode_2
XFILLER_18_769 VPWR VGND VPWR VGND sky130_ef_sc_hd__decap_12
XFILLER_73_897 VPWR VGND VPWR VGND sky130_ef_sc_hd__decap_12
XFILLER_72_363 VGND VGND VPWR VPWR sky130_fd_sc_hd__fill_1
XTAP_TAPCELL_ROW_28_775 VGND VPWR sky130_fd_sc_hd__tapvpwrvgnd_1
XFILLER_60_525 VGND VGND VPWR VPWR sky130_fd_sc_hd__decap_6
XTAP_TAPCELL_ROW_28_786 VGND VPWR sky130_fd_sc_hd__tapvpwrvgnd_1
XFILLER_45_599 VPWR VGND VPWR VGND sky130_ef_sc_hd__decap_12
XANTENNA_clkbuf_3_7__f_clk_A clknet_0_clk VGND VGND VPWR VPWR sky130_fd_sc_hd__diode_2
XFILLER_13_452 VPWR VGND VPWR VGND sky130_ef_sc_hd__decap_12
XTAP_TAPCELL_ROW_136_2512 VGND VPWR sky130_fd_sc_hd__tapvpwrvgnd_1
XTAP_TAPCELL_ROW_136_2501 VGND VPWR sky130_fd_sc_hd__tapvpwrvgnd_1
XANTENNA__2090__B1 b_r1\[0\] VGND VGND VPWR VPWR sky130_fd_sc_hd__diode_2
XFILLER_40_271 VPWR VGND VPWR VGND sky130_ef_sc_hd__decap_12
XFILLER_41_783 VGND VGND VPWR VPWR sky130_fd_sc_hd__fill_1
XFILLER_43_93 VPWR VGND VPWR VGND sky130_ef_sc_hd__decap_12
XFILLER_139_671 VGND VGND VPWR VPWR sky130_fd_sc_hd__fill_1
XFILLER_127_833 VGND VGND VPWR VPWR sky130_fd_sc_hd__decap_6
XFILLER_127_877 VPWR VGND VPWR VGND sky130_ef_sc_hd__decap_12
XFILLER_126_321 VPWR VGND VPWR VGND sky130_ef_sc_hd__decap_12
XFILLER_142_825 VPWR VGND VPWR VGND sky130_ef_sc_hd__decap_12
XFILLER_126_365 VPWR VGND VPWR VGND sky130_ef_sc_hd__decap_12
XFILLER_5_673 VPWR VGND VPWR VGND sky130_ef_sc_hd__decap_12
X_2490_ a_r1\[2\] b_r1\[2\] VGND VGND VPWR VPWR _0238_ sky130_fd_sc_hd__nand2_1
XFILLER_142_869 VPWR VGND VPWR VGND sky130_ef_sc_hd__decap_12
XFILLER_141_335 VGND VGND VPWR VPWR sky130_fd_sc_hd__fill_1
XFILLER_4_65 VPWR VGND VPWR VGND sky130_ef_sc_hd__decap_12
XFILLER_95_422 VPWR VGND VPWR VGND sky130_ef_sc_hd__decap_12
XFILLER_68_636 VGND VGND VPWR VPWR sky130_fd_sc_hd__decap_8
XFILLER_67_113 VPWR VGND VPWR VGND sky130_ef_sc_hd__decap_12
XTAP_TAPCELL_ROW_52_1157 VGND VPWR sky130_fd_sc_hd__tapvpwrvgnd_1
X_3111_ _0778_ _0798_ VGND VGND VPWR VPWR _0799_ sky130_fd_sc_hd__nand2_2
XFILLER_110_755 VGND VGND VPWR VPWR sky130_fd_sc_hd__fill_1
XFILLER_68_669 VGND VGND VPWR VPWR sky130_fd_sc_hd__decap_8
XTAP_TAPCELL_ROW_52_1168 VGND VPWR sky130_fd_sc_hd__tapvpwrvgnd_1
XTAP_TAPCELL_ROW_147_2685 VGND VPWR sky130_fd_sc_hd__tapvpwrvgnd_1
XFILLER_83_617 VPWR VGND VPWR VGND sky130_ef_sc_hd__decap_12
XFILLER_76_680 VGND VGND VPWR VPWR sky130_fd_sc_hd__fill_2
XFILLER_49_872 VPWR VGND VPWR VGND sky130_ef_sc_hd__decap_12
X_3042_ _0727_ _0729_ VGND VGND VPWR VPWR _0730_ sky130_fd_sc_hd__nor2_1
XFILLER_36_500 VPWR VGND VPWR VGND sky130_ef_sc_hd__decap_12
XFILLER_76_691 VGND VGND VPWR VPWR sky130_fd_sc_hd__fill_1
XFILLER_36_533 VPWR VGND VPWR VGND sky130_ef_sc_hd__decap_12
XFILLER_23_205 VPWR VGND VPWR VGND sky130_ef_sc_hd__decap_12
XANTENNA__1611__A A_reg\[8\] VGND VGND VPWR VPWR sky130_fd_sc_hd__diode_2
XFILLER_36_577 VGND VGND VPWR VPWR sky130_fd_sc_hd__decap_8
XFILLER_63_385 VGND VGND VPWR VPWR sky130_fd_sc_hd__decap_4
XFILLER_32_783 VPWR VGND VPWR VGND sky130_ef_sc_hd__decap_12
X_2826_ net52 X_crt\[8\] _0553_ VGND VGND VPWR VPWR _0049_ sky130_fd_sc_hd__mux2_1
XFILLER_31_293 VGND VGND VPWR VPWR sky130_fd_sc_hd__decap_3
XFILLER_118_811 VGND VGND VPWR VPWR sky130_fd_sc_hd__fill_1
XFILLER_145_641 VPWR VGND VPWR VGND sky130_ef_sc_hd__decap_12
XFILLER_129_181 VPWR VGND VPWR VGND sky130_ef_sc_hd__decap_12
X_2757_ _0495_ _0496_ VGND VGND VPWR VPWR _0497_ sky130_fd_sc_hd__nor2_1
XFILLER_145_685 VPWR VGND VPWR VGND sky130_ef_sc_hd__decap_12
XFILLER_105_505 VPWR VGND VPWR VGND sky130_ef_sc_hd__decap_12
X_2688_ _0385_ _0423_ VGND VGND VPWR VPWR _0428_ sky130_fd_sc_hd__nor2_1
X_1708_ _0983_ VGND VGND VPWR VPWR _0984_ sky130_fd_sc_hd__inv_2
XFILLER_2_109 VPWR VGND VPWR VGND sky130_ef_sc_hd__decap_12
XFILLER_144_195 VGND VGND VPWR VPWR sky130_fd_sc_hd__fill_1
XFILLER_105_549 VGND VGND VPWR VPWR sky130_fd_sc_hd__decap_8
X_1639_ A_reg\[14\] A_reg\[13\] VGND VGND VPWR VPWR _0915_ sky130_fd_sc_hd__nand2_1
XFILLER_132_357 VGND VGND VPWR VPWR sky130_fd_sc_hd__decap_6
XFILLER_59_603 VPWR VGND VPWR VGND sky130_ef_sc_hd__decap_12
XTAP_TAPCELL_ROW_6_426 VGND VPWR sky130_fd_sc_hd__tapvpwrvgnd_1
XFILLER_99_783 VGND VGND VPWR VPWR sky130_fd_sc_hd__fill_1
XFILLER_98_260 VGND VGND VPWR VPWR sky130_fd_sc_hd__decap_6
XFILLER_86_433 VPWR VGND VPWR VGND sky130_ef_sc_hd__decap_12
XFILLER_48_27 VGND VGND VPWR VPWR sky130_fd_sc_hd__fill_1
XANTENNA_input4_A A_in[12] VGND VGND VPWR VPWR sky130_fd_sc_hd__diode_2
XFILLER_100_243 VGND VGND VPWR VPWR sky130_fd_sc_hd__decap_8
XFILLER_100_221 VGND VGND VPWR VPWR sky130_fd_sc_hd__decap_8
XFILLER_47_809 VPWR VGND VPWR VGND sky130_ef_sc_hd__decap_12
X_3309_ clknet_3_7__leaf_clk _0092_ net36 VGND VGND VPWR VPWR X_crt\[3\] sky130_fd_sc_hd__dfrtp_1
XFILLER_101_777 VGND VGND VPWR VPWR sky130_fd_sc_hd__decap_6
XFILLER_100_265 VPWR VGND VPWR VGND sky130_ef_sc_hd__decap_12
XTAP_TAPCELL_ROW_87_1721 VGND VPWR sky130_fd_sc_hd__tapvpwrvgnd_1
XFILLER_86_477 VPWR VGND VPWR VGND sky130_ef_sc_hd__decap_12
XFILLER_104_77 VGND VGND VPWR VPWR sky130_fd_sc_hd__decap_6
XANTENNA__2617__A _0187_ VGND VGND VPWR VPWR sky130_fd_sc_hd__diode_2
XFILLER_64_15 VPWR VGND VPWR VGND sky130_ef_sc_hd__decap_12
XFILLER_39_393 VPWR VGND VPWR VGND sky130_ef_sc_hd__decap_12
XFILLER_55_875 VPWR VGND VPWR VGND sky130_ef_sc_hd__decap_12
XFILLER_54_363 VGND VGND VPWR VPWR sky130_fd_sc_hd__fill_1
XFILLER_55_897 VPWR VGND VPWR VGND sky130_ef_sc_hd__decap_12
XFILLER_54_374 VPWR VGND VPWR VGND sky130_ef_sc_hd__decap_12
XTAP_TAPCELL_ROW_25_734 VGND VPWR sky130_fd_sc_hd__tapvpwrvgnd_1
XFILLER_42_514 VPWR VGND VPWR VGND sky130_ef_sc_hd__decap_12
XFILLER_120_65 VPWR VGND VPWR VGND sky130_ef_sc_hd__decap_12
XFILLER_81_193 VPWR VGND VPWR VGND sky130_ef_sc_hd__decap_12
XANTENNA__3225__CLK clknet_3_3__leaf_clk VGND VGND VPWR VPWR sky130_fd_sc_hd__diode_2
XFILLER_70_867 VGND VGND VPWR VPWR sky130_fd_sc_hd__fill_1
XFILLER_42_569 VPWR VGND VPWR VGND sky130_ef_sc_hd__decap_12
XFILLER_23_783 VGND VGND VPWR VPWR sky130_fd_sc_hd__fill_1
XTAP_TAPCELL_ROW_118_2220 VGND VPWR sky130_fd_sc_hd__tapvpwrvgnd_1
XFILLER_10_433 VPWR VGND VPWR VGND sky130_ef_sc_hd__decap_12
XFILLER_109_833 VGND VGND VPWR VPWR sky130_fd_sc_hd__decap_6
XFILLER_10_477 VPWR VGND VPWR VGND sky130_ef_sc_hd__decap_12
XFILLER_108_321 VPWR VGND VPWR VGND sky130_ef_sc_hd__decap_12
XTAP_TAPCELL_ROW_131_2431 VGND VPWR sky130_fd_sc_hd__tapvpwrvgnd_1
XTAP_TAPCELL_ROW_131_2420 VGND VPWR sky130_fd_sc_hd__tapvpwrvgnd_1
XFILLER_124_825 VPWR VGND VPWR VGND sky130_ef_sc_hd__decap_12
XFILLER_109_877 VPWR VGND VPWR VGND sky130_ef_sc_hd__decap_12
XFILLER_108_365 VPWR VGND VPWR VGND sky130_ef_sc_hd__decap_12
XTAP_TAPCELL_ROW_98_1894 VGND VPWR sky130_fd_sc_hd__tapvpwrvgnd_1
XFILLER_150_121 VPWR VGND VPWR VGND sky130_ef_sc_hd__decap_12
XFILLER_124_869 VPWR VGND VPWR VGND sky130_ef_sc_hd__decap_12
XFILLER_123_335 VGND VGND VPWR VPWR sky130_fd_sc_hd__fill_1
XFILLER_97_709 VPWR VGND VPWR VGND sky130_ef_sc_hd__decap_12
XFILLER_89_89 VPWR VGND VPWR VGND sky130_ef_sc_hd__decap_12
XFILLER_150_165 VPWR VGND VPWR VGND sky130_ef_sc_hd__decap_12
XFILLER_145_51 VGND VGND VPWR VPWR sky130_fd_sc_hd__decap_4
XFILLER_2_643 VGND VGND VPWR VPWR sky130_fd_sc_hd__fill_1
XFILLER_49_113 VPWR VGND VPWR VGND sky130_ef_sc_hd__decap_12
XTAP_TAPCELL_ROW_129_2393 VGND VPWR sky130_fd_sc_hd__tapvpwrvgnd_1
XFILLER_92_403 VPWR VGND VPWR VGND sky130_ef_sc_hd__decap_12
XFILLER_65_617 VGND VGND VPWR VPWR sky130_fd_sc_hd__decap_3
XFILLER_64_138 VGND VGND VPWR VPWR sky130_fd_sc_hd__fill_2
XFILLER_18_533 VPWR VGND VPWR VGND sky130_ef_sc_hd__decap_12
XFILLER_92_469 VGND VGND VPWR VPWR sky130_fd_sc_hd__decap_6
XFILLER_46_864 VGND VGND VPWR VPWR sky130_fd_sc_hd__fill_2
XFILLER_45_385 VGND VGND VPWR VPWR sky130_fd_sc_hd__decap_6
X_1990_ _1240_ _1244_ VGND VGND VPWR VPWR _1253_ sky130_fd_sc_hd__xnor2_1
XFILLER_60_344 VPWR VGND VPWR VGND sky130_ef_sc_hd__decap_12
XFILLER_21_709 VPWR VGND VPWR VGND sky130_ef_sc_hd__decap_12
XFILLER_33_547 VGND VGND VPWR VPWR sky130_fd_sc_hd__fill_2
XFILLER_60_377 VPWR VGND VPWR VGND sky130_ef_sc_hd__decap_12
XFILLER_127_641 VPWR VGND VPWR VGND sky130_ef_sc_hd__decap_12
X_2611_ _0352_ _0354_ VGND VGND VPWR VPWR _0356_ sky130_fd_sc_hd__xnor2_1
XFILLER_127_685 VPWR VGND VPWR VGND sky130_ef_sc_hd__decap_12
X_2542_ _0281_ _0289_ VGND VGND VPWR VPWR _0290_ sky130_fd_sc_hd__nand2_1
XFILLER_126_195 VGND VGND VPWR VPWR sky130_fd_sc_hd__fill_1
XTAP_TAPCELL_ROW_149_2714 VGND VPWR sky130_fd_sc_hd__tapvpwrvgnd_1
XFILLER_114_357 VGND VGND VPWR VPWR sky130_fd_sc_hd__decap_6
XANTENNA__2118__A1 B_reg\[8\] VGND VGND VPWR VPWR sky130_fd_sc_hd__diode_2
XANTENNA__1606__A A_reg\[0\] VGND VGND VPWR VPWR sky130_fd_sc_hd__diode_2
X_2473_ a_r1\[0\] _0185_ VGND VGND VPWR VPWR _0221_ sky130_fd_sc_hd__nand2_1
XFILLER_142_699 VGND VGND VPWR VPWR sky130_fd_sc_hd__fill_1
XANTENNA__1877__B1 A_reg\[3\] VGND VGND VPWR VPWR sky130_fd_sc_hd__diode_2
XFILLER_29_809 VPWR VGND VPWR VGND sky130_ef_sc_hd__decap_12
XFILLER_68_477 VPWR VGND VPWR VGND sky130_ef_sc_hd__decap_12
XFILLER_56_617 VPWR VGND VPWR VGND sky130_ef_sc_hd__decap_12
XFILLER_83_447 VGND VGND VPWR VPWR sky130_fd_sc_hd__fill_1
XANTENNA__3248__CLK clknet_3_6__leaf_clk VGND VGND VPWR VPWR sky130_fd_sc_hd__diode_2
XTAP_TAPCELL_ROW_69_1440 VGND VPWR sky130_fd_sc_hd__tapvpwrvgnd_1
X_3025_ _0685_ _0686_ VGND VGND VPWR VPWR _0713_ sky130_fd_sc_hd__xor2_1
XFILLER_55_149 VPWR VGND VPWR VGND sky130_ef_sc_hd__decap_12
XFILLER_37_853 VPWR VGND VPWR VGND sky130_ef_sc_hd__decap_12
XFILLER_52_845 VPWR VGND VPWR VGND sky130_ef_sc_hd__decap_12
XFILLER_24_525 VGND VGND VPWR VPWR sky130_fd_sc_hd__decap_6
XFILLER_37_897 VPWR VGND VPWR VGND sky130_ef_sc_hd__decap_12
XTAP_TAPCELL_ROW_82_1651 VGND VPWR sky130_fd_sc_hd__tapvpwrvgnd_1
XTAP_TAPCELL_ROW_82_1640 VGND VPWR sky130_fd_sc_hd__tapvpwrvgnd_1
XFILLER_24_569 VPWR VGND VPWR VGND sky130_ef_sc_hd__decap_12
XFILLER_34_29 VPWR VGND VPWR VGND sky130_ef_sc_hd__decap_12
XFILLER_137_405 VPWR VGND VPWR VGND sky130_ef_sc_hd__decap_12
Xclkload6 clknet_3_6__leaf_clk VGND VGND VPWR VPWR clkload6/Y sky130_fd_sc_hd__clkinv_4
XFILLER_153_909 VGND VGND VPWR VPWR sky130_fd_sc_hd__fill_1
XFILLER_137_449 VPWR VGND VPWR VGND sky130_ef_sc_hd__decap_12
X_2809_ _0535_ _0536_ _0542_ VGND VGND VPWR VPWR _0547_ sky130_fd_sc_hd__o21ba_1
XFILLER_152_419 VGND VGND VPWR VPWR sky130_fd_sc_hd__fill_1
XFILLER_106_825 VPWR VGND VPWR VGND sky130_ef_sc_hd__decap_12
XFILLER_132_121 VPWR VGND VPWR VGND sky130_ef_sc_hd__decap_12
XFILLER_105_335 VGND VGND VPWR VPWR sky130_fd_sc_hd__fill_1
XFILLER_106_869 VPWR VGND VPWR VGND sky130_ef_sc_hd__decap_12
XFILLER_79_709 VGND VGND VPWR VPWR sky130_fd_sc_hd__fill_2
XFILLER_132_165 VPWR VGND VPWR VGND sky130_ef_sc_hd__decap_12
XFILLER_121_839 VGND VGND VPWR VPWR sky130_fd_sc_hd__fill_1
XFILLER_101_541 VPWR VGND VPWR VGND sky130_ef_sc_hd__decap_12
XFILLER_87_753 VPWR VGND VPWR VGND sky130_ef_sc_hd__decap_12
XFILLER_86_241 VGND VGND VPWR VPWR sky130_fd_sc_hd__fill_1
XFILLER_101_574 VPWR VGND VPWR VGND sky130_ef_sc_hd__decap_12
XFILLER_87_797 VPWR VGND VPWR VGND sky130_ef_sc_hd__decap_12
XFILLER_47_617 VPWR VGND VPWR VGND sky130_ef_sc_hd__decap_12
XFILLER_75_69 VPWR VGND VPWR VGND sky130_ef_sc_hd__decap_12
XFILLER_74_469 VGND VGND VPWR VPWR sky130_fd_sc_hd__decap_6
XFILLER_15_503 VGND VGND VPWR VPWR sky130_fd_sc_hd__fill_1
XFILLER_91_57 VPWR VGND VPWR VGND sky130_ef_sc_hd__decap_12
XFILLER_42_344 VPWR VGND VPWR VGND sky130_ef_sc_hd__decap_12
XFILLER_43_889 VGND VGND VPWR VPWR sky130_fd_sc_hd__decap_6
XFILLER_42_399 VPWR VGND VPWR VGND sky130_ef_sc_hd__decap_12
XFILLER_11_753 VPWR VGND VPWR VGND sky130_ef_sc_hd__decap_12
XFILLER_144_909 VGND VGND VPWR VPWR sky130_fd_sc_hd__fill_1
XFILLER_109_641 VPWR VGND VPWR VGND sky130_ef_sc_hd__decap_12
XFILLER_11_797 VPWR VGND VPWR VGND sky130_ef_sc_hd__decap_12
XFILLER_109_685 VPWR VGND VPWR VGND sky130_ef_sc_hd__decap_12
XFILLER_108_195 VGND VGND VPWR VPWR sky130_fd_sc_hd__fill_1
XFILLER_40_83 VGND VGND VPWR VPWR sky130_fd_sc_hd__fill_1
XFILLER_151_441 VGND VGND VPWR VPWR sky130_fd_sc_hd__decap_6
XFILLER_151_485 VPWR VGND VPWR VGND sky130_ef_sc_hd__decap_12
XFILLER_124_699 VGND VGND VPWR VPWR sky130_fd_sc_hd__fill_1
XFILLER_111_305 VPWR VGND VPWR VGND sky130_ef_sc_hd__decap_12
XFILLER_111_349 VPWR VGND VPWR VGND sky130_ef_sc_hd__decap_12
XFILLER_49_81 VPWR VGND VPWR VGND sky130_ef_sc_hd__decap_12
XANTENNA__1859__B1 A_reg\[8\] VGND VGND VPWR VPWR sky130_fd_sc_hd__diode_2
XFILLER_120_861 VGND VGND VPWR VPWR sky130_fd_sc_hd__decap_6
XFILLER_77_263 VGND VGND VPWR VPWR sky130_fd_sc_hd__fill_2
XFILLER_37_105 VGND VGND VPWR VPWR sky130_fd_sc_hd__decap_6
XTAP_TAPCELL_ROW_144_2633 VGND VPWR sky130_fd_sc_hd__tapvpwrvgnd_1
XFILLER_92_233 VPWR VGND VPWR VGND sky130_ef_sc_hd__decap_12
XFILLER_65_447 VGND VGND VPWR VPWR sky130_fd_sc_hd__fill_1
XFILLER_1_55 VGND VGND VPWR VPWR sky130_fd_sc_hd__fill_1
XFILLER_19_853 VPWR VGND VPWR VGND sky130_ef_sc_hd__decap_12
XFILLER_37_149 VPWR VGND VPWR VGND sky130_ef_sc_hd__decap_12
XFILLER_92_277 VPWR VGND VPWR VGND sky130_ef_sc_hd__decap_12
XFILLER_18_363 VGND VGND VPWR VPWR sky130_fd_sc_hd__fill_1
XFILLER_19_897 VPWR VGND VPWR VGND sky130_ef_sc_hd__decap_12
XFILLER_33_300 VPWR VGND VPWR VGND sky130_ef_sc_hd__decap_12
XFILLER_18_396 VPWR VGND VPWR VGND sky130_ef_sc_hd__decap_12
XFILLER_34_867 VGND VGND VPWR VPWR sky130_fd_sc_hd__fill_1
XFILLER_45_193 VPWR VGND VPWR VGND sky130_ef_sc_hd__decap_12
XFILLER_61_697 VPWR VGND VPWR VGND sky130_ef_sc_hd__decap_12
XFILLER_60_141 VPWR VGND VPWR VGND sky130_ef_sc_hd__decap_12
XTAP_TAPCELL_ROW_47_1089 VGND VPWR sky130_fd_sc_hd__tapvpwrvgnd_1
XFILLER_21_517 VPWR VGND VPWR VGND sky130_ef_sc_hd__decap_12
XFILLER_33_366 VPWR VGND VPWR VGND sky130_ef_sc_hd__decap_12
XFILLER_34_889 VGND VGND VPWR VPWR sky130_fd_sc_hd__fill_1
XTAP_TAPCELL_ROW_47_1078 VGND VPWR sky130_fd_sc_hd__tapvpwrvgnd_1
X_1973_ _1236_ _1237_ B_reg\[2\] VGND VGND VPWR VPWR _1238_ sky130_fd_sc_hd__o21ai_2
XTAP_TAPCELL_ROW_16_586 VGND VPWR sky130_fd_sc_hd__tapvpwrvgnd_1
XFILLER_119_405 VPWR VGND VPWR VGND sky130_ef_sc_hd__decap_12
XFILLER_135_909 VGND VGND VPWR VPWR sky130_fd_sc_hd__fill_1
XFILLER_119_449 VPWR VGND VPWR VGND sky130_ef_sc_hd__decap_12
XTAP_TAPCELL_ROW_60_1289 VGND VPWR sky130_fd_sc_hd__tapvpwrvgnd_1
XFILLER_134_419 VGND VGND VPWR VPWR sky130_fd_sc_hd__fill_1
XFILLER_114_121 VPWR VGND VPWR VGND sky130_ef_sc_hd__decap_12
XANTENNA__3278__RESET_B net36 VGND VGND VPWR VPWR sky130_fd_sc_hd__diode_2
X_2525_ _0270_ _0272_ _0187_ VGND VGND VPWR VPWR _0273_ sky130_fd_sc_hd__mux2_1
XFILLER_130_625 VPWR VGND VPWR VGND sky130_ef_sc_hd__decap_12
XFILLER_114_165 VPWR VGND VPWR VGND sky130_ef_sc_hd__decap_12
XFILLER_103_839 VGND VGND VPWR VPWR sky130_fd_sc_hd__fill_1
X_2456_ a_r0\[0\] _0186_ _0203_ _0204_ VGND VGND VPWR VPWR _0206_ sky130_fd_sc_hd__a2bb2o_1
XFILLER_130_669 VPWR VGND VPWR VGND sky130_ef_sc_hd__decap_12
XFILLER_69_753 VPWR VGND VPWR VGND sky130_ef_sc_hd__decap_12
X_2387_ _0139_ _0140_ _0135_ VGND VGND VPWR VPWR _0141_ sky130_fd_sc_hd__a21o_1
XFILLER_84_701 VPWR VGND VPWR VGND sky130_ef_sc_hd__decap_12
XFILLER_69_797 VPWR VGND VPWR VGND sky130_ef_sc_hd__decap_12
XANTENNA__2511__A1 b_r1\[0\] VGND VGND VPWR VPWR sky130_fd_sc_hd__diode_2
XFILLER_29_617 VPWR VGND VPWR VGND sky130_ef_sc_hd__decap_12
XANTENNA__2438__Y _0188_ VGND VGND VPWR VPWR sky130_fd_sc_hd__diode_2
XFILLER_56_447 VPWR VGND VPWR VGND sky130_ef_sc_hd__decap_12
X_3008_ _0675_ _0676_ VGND VGND VPWR VPWR _0696_ sky130_fd_sc_hd__xnor2_1
XFILLER_45_39 VPWR VGND VPWR VGND sky130_ef_sc_hd__decap_12
XFILLER_52_653 VPWR VGND VPWR VGND sky130_ef_sc_hd__decap_12
XFILLER_52_697 VGND VGND VPWR VPWR sky130_fd_sc_hd__decap_3
XFILLER_51_152 VPWR VGND VPWR VGND sky130_ef_sc_hd__decap_12
XFILLER_51_141 VGND VGND VPWR VPWR sky130_fd_sc_hd__decap_6
XFILLER_24_355 VGND VGND VPWR VPWR sky130_fd_sc_hd__decap_8
XFILLER_24_377 VPWR VGND VPWR VGND sky130_ef_sc_hd__decap_12
XFILLER_25_889 VGND VGND VPWR VPWR sky130_fd_sc_hd__decap_6
XTAP_TAPCELL_ROW_35_884 VGND VPWR sky130_fd_sc_hd__tapvpwrvgnd_1
XANTENNA__2614__B _0186_ VGND VGND VPWR VPWR sky130_fd_sc_hd__diode_2
XFILLER_61_27 VGND VGND VPWR VPWR sky130_fd_sc_hd__fill_1
XTAP_TAPCELL_ROW_35_895 VGND VPWR sky130_fd_sc_hd__tapvpwrvgnd_1
XFILLER_138_725 VPWR VGND VPWR VGND sky130_ef_sc_hd__decap_12
XFILLER_138_769 VPWR VGND VPWR VGND sky130_ef_sc_hd__decap_12
XFILLER_126_909 VGND VGND VPWR VPWR sky130_fd_sc_hd__fill_1
XFILLER_137_279 VGND VGND VPWR VPWR sky130_fd_sc_hd__fill_1
XTAP_TAPCELL_ROW_111_2109 VGND VPWR sky130_fd_sc_hd__tapvpwrvgnd_1
XTAP_TAPCELL_ROW_95_1853 VGND VPWR sky130_fd_sc_hd__tapvpwrvgnd_1
XFILLER_4_749 VGND VGND VPWR VPWR sky130_fd_sc_hd__decap_6
XFILLER_133_441 VGND VGND VPWR VPWR sky130_fd_sc_hd__decap_6
XFILLER_10_53 VPWR VGND VPWR VGND sky130_ef_sc_hd__decap_12
XFILLER_133_485 VPWR VGND VPWR VGND sky130_ef_sc_hd__decap_12
XFILLER_126_53 VPWR VGND VPWR VGND sky130_ef_sc_hd__decap_12
XFILLER_106_699 VGND VGND VPWR VPWR sky130_fd_sc_hd__fill_1
XFILLER_79_517 VPWR VGND VPWR VGND sky130_ef_sc_hd__decap_12
XFILLER_10_97 VPWR VGND VPWR VGND sky130_ef_sc_hd__decap_12
XFILLER_126_97 VPWR VGND VPWR VGND sky130_ef_sc_hd__decap_12
XFILLER_48_904 VGND VGND VPWR VPWR sky130_fd_sc_hd__decap_6
XFILLER_102_861 VGND VGND VPWR VPWR sky130_fd_sc_hd__decap_6
XFILLER_19_105 VGND VGND VPWR VPWR sky130_fd_sc_hd__decap_6
XANTENNA__2502__A1 b_r1\[0\] VGND VGND VPWR VPWR sky130_fd_sc_hd__diode_2
XFILLER_142_41 VPWR VGND VPWR VGND sky130_ef_sc_hd__decap_12
XTAP_TAPCELL_ROW_126_2341 VGND VPWR sky130_fd_sc_hd__tapvpwrvgnd_1
XFILLER_19_51 VGND VGND VPWR VPWR sky130_fd_sc_hd__decap_4
XFILLER_47_425 VGND VGND VPWR VPWR sky130_fd_sc_hd__fill_2
XFILLER_142_85 VPWR VGND VPWR VGND sky130_ef_sc_hd__decap_12
XTAP_TAPCELL_ROW_126_2352 VGND VPWR sky130_fd_sc_hd__tapvpwrvgnd_1
XFILLER_75_778 VGND VGND VPWR VPWR sky130_fd_sc_hd__decap_6
XFILLER_74_233 VPWR VGND VPWR VGND sky130_ef_sc_hd__decap_12
XANTENNA__2077__A B_reg\[2\] VGND VGND VPWR VPWR sky130_fd_sc_hd__diode_2
XFILLER_19_149 VPWR VGND VPWR VGND sky130_ef_sc_hd__decap_12
XFILLER_90_737 VPWR VGND VPWR VGND sky130_ef_sc_hd__decap_12
XFILLER_74_277 VPWR VGND VPWR VGND sky130_ef_sc_hd__decap_12
XFILLER_16_867 VGND VGND VPWR VPWR sky130_fd_sc_hd__fill_1
XFILLER_27_193 VPWR VGND VPWR VGND sky130_ef_sc_hd__decap_12
XFILLER_42_141 VPWR VGND VPWR VGND sky130_ef_sc_hd__decap_12
XTAP_TAPCELL_ROW_104_1993 VGND VPWR sky130_fd_sc_hd__tapvpwrvgnd_1
XTAP_TAPCELL_ROW_13_534 VGND VPWR sky130_fd_sc_hd__tapvpwrvgnd_1
XFILLER_31_837 VGND VGND VPWR VPWR sky130_fd_sc_hd__fill_1
XFILLER_43_697 VPWR VGND VPWR VGND sky130_ef_sc_hd__decap_12
XTAP_TAPCELL_ROW_13_545 VGND VPWR sky130_fd_sc_hd__tapvpwrvgnd_1
XFILLER_30_347 VPWR VGND VPWR VGND sky130_ef_sc_hd__decap_12
XFILLER_117_909 VGND VGND VPWR VPWR sky130_fd_sc_hd__fill_1
XFILLER_51_60 VPWR VGND VPWR VGND sky130_ef_sc_hd__decap_12
XFILLER_11_561 VGND VGND VPWR VPWR sky130_fd_sc_hd__decap_8
XFILLER_143_205 VPWR VGND VPWR VGND sky130_ef_sc_hd__decap_12
XFILLER_116_419 VGND VGND VPWR VPWR sky130_fd_sc_hd__fill_1
XFILLER_143_249 VPWR VGND VPWR VGND sky130_ef_sc_hd__decap_12
XFILLER_112_625 VPWR VGND VPWR VGND sky130_ef_sc_hd__decap_12
XFILLER_98_837 VPWR VGND VPWR VGND sky130_ef_sc_hd__decap_12
X_3290_ clknet_3_2__leaf_clk _0073_ net36 VGND VGND VPWR VPWR B_reg\[0\] sky130_fd_sc_hd__dfrtp_4
XANTENNA__3300__RESET_B net36 VGND VGND VPWR VPWR sky130_fd_sc_hd__diode_2
X_2310_ _0900_ _1560_ _1561_ VGND VGND VPWR VPWR _1563_ sky130_fd_sc_hd__or3_1
XFILLER_151_293 VPWR VGND VPWR VGND sky130_ef_sc_hd__decap_12
XFILLER_112_669 VPWR VGND VPWR VGND sky130_ef_sc_hd__decap_12
XFILLER_111_113 VPWR VGND VPWR VGND sky130_ef_sc_hd__decap_12
X_2241_ A_reg\[4\] _1478_ _1487_ VGND VGND VPWR VPWR _1498_ sky130_fd_sc_hd__and3_1
XFILLER_66_701 VPWR VGND VPWR VGND sky130_ef_sc_hd__decap_12
XFILLER_65_222 VGND VGND VPWR VPWR sky130_fd_sc_hd__fill_2
X_2172_ _1421_ _1428_ _1419_ VGND VGND VPWR VPWR _1429_ sky130_fd_sc_hd__a21oi_1
XFILLER_18_3 VPWR VGND VPWR VGND sky130_ef_sc_hd__decap_12
XFILLER_66_789 VPWR VGND VPWR VGND sky130_ef_sc_hd__decap_12
XFILLER_65_233 VGND VGND VPWR VPWR sky130_fd_sc_hd__fill_1
XFILLER_80_214 VPWR VGND VPWR VGND sky130_ef_sc_hd__decap_12
XFILLER_53_417 VPWR VGND VPWR VGND sky130_ef_sc_hd__decap_12
XTAP_TAPCELL_ROW_49_1118 VGND VPWR sky130_fd_sc_hd__tapvpwrvgnd_1
XTAP_TAPCELL_ROW_62_1329 VGND VPWR sky130_fd_sc_hd__tapvpwrvgnd_1
XTAP_TAPCELL_ROW_62_1318 VGND VPWR sky130_fd_sc_hd__tapvpwrvgnd_1
XFILLER_61_461 VPWR VGND VPWR VGND sky130_ef_sc_hd__decap_12
XFILLER_22_837 VPWR VGND VPWR VGND sky130_ef_sc_hd__decap_12
X_1956_ _1212_ _1220_ _1214_ VGND VGND VPWR VPWR _1221_ sky130_fd_sc_hd__a21o_1
XTAP_TAPCELL_ROW_32_843 VGND VPWR sky130_fd_sc_hd__tapvpwrvgnd_1
XFILLER_108_909 VGND VGND VPWR VPWR sky130_fd_sc_hd__fill_1
XFILLER_119_279 VGND VGND VPWR VPWR sky130_fd_sc_hd__fill_1
X_1887_ A_reg\[0\] _1156_ VGND VGND VPWR VPWR _1157_ sky130_fd_sc_hd__nand2_1
XPHY_EDGE_ROW_131_Right_131 VGND VGND VPWR VPWR sky130_fd_sc_hd__decap_3
XFILLER_115_441 VGND VGND VPWR VPWR sky130_fd_sc_hd__decap_6
XTAP_TAPCELL_ROW_77_1561 VGND VPWR sky130_fd_sc_hd__tapvpwrvgnd_1
XFILLER_143_783 VGND VGND VPWR VPWR sky130_fd_sc_hd__fill_1
XFILLER_115_485 VPWR VGND VPWR VGND sky130_ef_sc_hd__decap_12
X_2508_ _0249_ _0255_ _0187_ VGND VGND VPWR VPWR _0256_ sky130_fd_sc_hd__mux2_1
XFILLER_130_433 VPWR VGND VPWR VGND sky130_ef_sc_hd__decap_12
XFILLER_130_477 VPWR VGND VPWR VGND sky130_ef_sc_hd__decap_12
XTAP_TAPCELL_ROW_90_1772 VGND VPWR sky130_fd_sc_hd__tapvpwrvgnd_1
X_2439_ b_r0\[0\] _0187_ VGND VGND VPWR VPWR _0189_ sky130_fd_sc_hd__nor2_1
XFILLER_69_561 VPWR VGND VPWR VGND sky130_ef_sc_hd__decap_12
XFILLER_57_723 VGND VGND VPWR VPWR sky130_fd_sc_hd__decap_4
XTAP_TAPCELL_ROW_108_2060 VGND VPWR sky130_fd_sc_hd__tapvpwrvgnd_1
XFILLER_57_778 VGND VGND VPWR VPWR sky130_fd_sc_hd__decap_3
XFILLER_56_233 VPWR VGND VPWR VGND sky130_ef_sc_hd__decap_12
XANTENNA__1735__A_N A_reg\[15\] VGND VGND VPWR VPWR sky130_fd_sc_hd__diode_2
XFILLER_17_609 VGND VGND VPWR VPWR sky130_fd_sc_hd__decap_6
XFILLER_29_447 VGND VGND VPWR VPWR sky130_fd_sc_hd__fill_1
XFILLER_84_597 VGND VGND VPWR VPWR sky130_fd_sc_hd__fill_2
XFILLER_84_586 VGND VGND VPWR VPWR sky130_fd_sc_hd__fill_2
XFILLER_72_737 VGND VGND VPWR VPWR sky130_fd_sc_hd__decap_8
XFILLER_56_299 VGND VGND VPWR VPWR sky130_fd_sc_hd__decap_8
XFILLER_112_77 VGND VGND VPWR VPWR sky130_fd_sc_hd__decap_6
XFILLER_72_15 VPWR VGND VPWR VGND sky130_ef_sc_hd__decap_12
XFILLER_71_225 VPWR VGND VPWR VGND sky130_ef_sc_hd__decap_12
XFILLER_25_653 VPWR VGND VPWR VGND sky130_ef_sc_hd__decap_12
XFILLER_37_491 VPWR VGND VPWR VGND sky130_ef_sc_hd__decap_12
XTAP_TAPCELL_ROW_121_2271 VGND VPWR sky130_fd_sc_hd__tapvpwrvgnd_1
XTAP_TAPCELL_ROW_121_2260 VGND VPWR sky130_fd_sc_hd__tapvpwrvgnd_1
XFILLER_12_303 VGND VGND VPWR VPWR sky130_fd_sc_hd__decap_4
XFILLER_24_141 VPWR VGND VPWR VGND sky130_ef_sc_hd__decap_12
XFILLER_40_601 VPWR VGND VPWR VGND sky130_ef_sc_hd__decap_12
XFILLER_80_781 VPWR VGND VPWR VGND sky130_ef_sc_hd__decap_12
XFILLER_52_494 VPWR VGND VPWR VGND sky130_ef_sc_hd__decap_12
XFILLER_25_697 VPWR VGND VPWR VGND sky130_ef_sc_hd__decap_12
XFILLER_40_645 VPWR VGND VPWR VGND sky130_ef_sc_hd__decap_12
XFILLER_8_307 VGND VGND VPWR VPWR sky130_fd_sc_hd__fill_1
XFILLER_138_533 VPWR VGND VPWR VGND sky130_ef_sc_hd__decap_12
XFILLER_122_3 VPWR VGND VPWR VGND sky130_ef_sc_hd__decap_12
XFILLER_125_205 VPWR VGND VPWR VGND sky130_ef_sc_hd__decap_12
XFILLER_141_709 VPWR VGND VPWR VGND sky130_ef_sc_hd__decap_12
XFILLER_125_249 VPWR VGND VPWR VGND sky130_ef_sc_hd__decap_12
XFILLER_133_293 VPWR VGND VPWR VGND sky130_ef_sc_hd__decap_12
XFILLER_0_741 VPWR VGND VPWR VGND sky130_ef_sc_hd__decap_12
XFILLER_94_317 VGND VGND VPWR VPWR sky130_fd_sc_hd__fill_1
XFILLER_88_881 VPWR VGND VPWR VGND sky130_ef_sc_hd__decap_12
XFILLER_48_701 VPWR VGND VPWR VGND sky130_ef_sc_hd__decap_12
XFILLER_87_391 VGND VGND VPWR VPWR sky130_fd_sc_hd__fill_1
XFILLER_48_745 VGND VGND VPWR VPWR sky130_fd_sc_hd__decap_8
XFILLER_0_785 VPWR VGND VPWR VGND sky130_ef_sc_hd__decap_12
XFILLER_75_553 VGND VGND VPWR VPWR sky130_fd_sc_hd__decap_6
XFILLER_90_501 VPWR VGND VPWR VGND sky130_ef_sc_hd__decap_12
XTAP_TAPCELL_ROW_18_615 VGND VPWR sky130_fd_sc_hd__tapvpwrvgnd_1
XTAP_TAPCELL_ROW_18_626 VGND VPWR sky130_fd_sc_hd__tapvpwrvgnd_1
XANTENNA__3309__CLK clknet_3_7__leaf_clk VGND VGND VPWR VPWR sky130_fd_sc_hd__diode_2
XFILLER_63_748 VGND VGND VPWR VPWR sky130_fd_sc_hd__fill_1
XANTENNA__2094__X _1354_ VGND VGND VPWR VPWR sky130_fd_sc_hd__diode_2
XFILLER_62_269 VPWR VGND VPWR VGND sky130_ef_sc_hd__decap_12
XFILLER_43_461 VPWR VGND VPWR VGND sky130_ef_sc_hd__decap_12
XFILLER_149_809 VPWR VGND VPWR VGND sky130_ef_sc_hd__decap_12
XTAP_TAPCELL_ROW_44_1037 VGND VPWR sky130_fd_sc_hd__tapvpwrvgnd_1
XTAP_TAPCELL_ROW_139_2554 VGND VPWR sky130_fd_sc_hd__tapvpwrvgnd_1
XFILLER_30_133 VGND VGND VPWR VPWR sky130_fd_sc_hd__decap_6
XFILLER_31_667 VGND VGND VPWR VPWR sky130_fd_sc_hd__decap_4
X_1810_ _1080_ _1082_ _1078_ VGND VGND VPWR VPWR _1083_ sky130_fd_sc_hd__a21oi_1
X_2790_ _0514_ _0519_ _0520_ _0529_ VGND VGND VPWR VPWR _0530_ sky130_fd_sc_hd__o22a_1
XFILLER_12_881 VPWR VGND VPWR VGND sky130_ef_sc_hd__decap_12
XFILLER_30_177 VPWR VGND VPWR VGND sky130_ef_sc_hd__decap_12
X_1741_ A_reg\[12\] _1007_ _1012_ _1013_ VGND VGND VPWR VPWR _1014_ sky130_fd_sc_hd__a31o_1
XTAP_TAPCELL_ROW_152_2765 VGND VPWR sky130_fd_sc_hd__tapvpwrvgnd_1
XFILLER_144_525 VGND VGND VPWR VPWR sky130_fd_sc_hd__decap_6
XFILLER_7_384 VGND VGND VPWR VPWR sky130_fd_sc_hd__fill_1
X_1672_ _0937_ _0946_ _0934_ VGND VGND VPWR VPWR _0948_ sky130_fd_sc_hd__o21ai_1
XFILLER_144_569 VPWR VGND VPWR VGND sky130_ef_sc_hd__decap_12
XFILLER_125_783 VGND VGND VPWR VPWR sky130_fd_sc_hd__fill_1
XFILLER_98_601 VPWR VGND VPWR VGND sky130_ef_sc_hd__decap_12
XTAP_TAPCELL_ROW_59_1280 VGND VPWR sky130_fd_sc_hd__tapvpwrvgnd_1
XFILLER_112_433 VPWR VGND VPWR VGND sky130_ef_sc_hd__decap_12
XFILLER_98_645 VPWR VGND VPWR VGND sky130_ef_sc_hd__decap_12
XFILLER_97_111 VGND VGND VPWR VPWR sky130_fd_sc_hd__fill_1
XFILLER_112_477 VPWR VGND VPWR VGND sky130_ef_sc_hd__decap_12
XTAP_TAPCELL_ROW_72_1480 VGND VPWR sky130_fd_sc_hd__tapvpwrvgnd_1
X_3273_ clknet_3_5__leaf_clk _0056_ net36 VGND VGND VPWR VPWR net44 sky130_fd_sc_hd__dfrtp_1
XFILLER_97_177 VGND VGND VPWR VPWR sky130_fd_sc_hd__fill_2
XTAP_TAPCELL_ROW_72_1491 VGND VPWR sky130_fd_sc_hd__tapvpwrvgnd_1
X_2224_ _1475_ _1476_ _1478_ A_reg\[5\] VGND VGND VPWR VPWR _1481_ sky130_fd_sc_hd__a2bb2o_1
XFILLER_66_531 VGND VGND VPWR VPWR sky130_fd_sc_hd__fill_1
X_2155_ _0927_ _1411_ VGND VGND VPWR VPWR _1412_ sky130_fd_sc_hd__nand2_1
XFILLER_38_233 VPWR VGND VPWR VGND sky130_ef_sc_hd__decap_12
XFILLER_93_361 VGND VGND VPWR VPWR sky130_fd_sc_hd__decap_3
XFILLER_54_737 VPWR VGND VPWR VGND sky130_ef_sc_hd__decap_12
XTAP_TAPCELL_ROW_37_924 VGND VPWR sky130_fd_sc_hd__tapvpwrvgnd_1
XFILLER_38_266 VPWR VGND VPWR VGND sky130_ef_sc_hd__decap_12
X_2086_ _1343_ _1338_ _1340_ VGND VGND VPWR VPWR _1348_ sky130_fd_sc_hd__mux2_1
XFILLER_53_225 VGND VGND VPWR VPWR sky130_fd_sc_hd__decap_8
XFILLER_22_601 VPWR VGND VPWR VGND sky130_ef_sc_hd__decap_12
XFILLER_41_409 VPWR VGND VPWR VGND sky130_ef_sc_hd__decap_12
XFILLER_62_781 VPWR VGND VPWR VGND sky130_ef_sc_hd__decap_12
XFILLER_21_111 VGND VGND VPWR VPWR sky130_fd_sc_hd__fill_1
XFILLER_22_645 VPWR VGND VPWR VGND sky130_ef_sc_hd__decap_12
XFILLER_42_29 VPWR VGND VPWR VGND sky130_ef_sc_hd__decap_12
XTAP_TAPCELL_ROW_79_1601 VGND VPWR sky130_fd_sc_hd__tapvpwrvgnd_1
X_2988_ _0624_ _0625_ VGND VGND VPWR VPWR _0676_ sky130_fd_sc_hd__xor2_1
XFILLER_135_503 VGND VGND VPWR VPWR sky130_fd_sc_hd__fill_1
XANTENNA__3293__RESET_B net36 VGND VGND VPWR VPWR sky130_fd_sc_hd__diode_2
X_1939_ _0902_ _1203_ VGND VGND VPWR VPWR _1204_ sky130_fd_sc_hd__xnor2_2
XFILLER_147_385 VGND VGND VPWR VPWR sky130_fd_sc_hd__decap_6
XFILLER_107_205 VPWR VGND VPWR VGND sky130_ef_sc_hd__decap_12
XANTENNA__3222__RESET_B net36 VGND VGND VPWR VPWR sky130_fd_sc_hd__diode_2
XFILLER_123_709 VPWR VGND VPWR VGND sky130_ef_sc_hd__decap_12
XFILLER_107_249 VPWR VGND VPWR VGND sky130_ef_sc_hd__decap_12
XTAP_TAPCELL_ROW_92_1801 VGND VPWR sky130_fd_sc_hd__tapvpwrvgnd_1
XFILLER_1_505 VPWR VGND VPWR VGND sky130_ef_sc_hd__decap_12
XFILLER_115_293 VPWR VGND VPWR VGND sky130_ef_sc_hd__decap_12
XFILLER_107_55 VGND VGND VPWR VPWR sky130_fd_sc_hd__fill_1
XFILLER_103_433 VPWR VGND VPWR VGND sky130_ef_sc_hd__decap_12
XFILLER_88_133 VGND VGND VPWR VPWR sky130_fd_sc_hd__decap_6
XFILLER_131_753 VPWR VGND VPWR VGND sky130_ef_sc_hd__decap_12
XFILLER_76_306 VGND VGND VPWR VPWR sky130_fd_sc_hd__fill_2
XFILLER_67_48 VGND VGND VPWR VPWR sky130_fd_sc_hd__decap_8
XFILLER_131_797 VPWR VGND VPWR VGND sky130_ef_sc_hd__decap_12
XFILLER_76_328 VPWR VGND VPWR VGND sky130_ef_sc_hd__decap_12
XFILLER_69_391 VGND VGND VPWR VPWR sky130_fd_sc_hd__fill_1
XFILLER_57_553 VGND VGND VPWR VPWR sky130_fd_sc_hd__decap_6
XTAP_TAPCELL_ROW_123_2300 VGND VPWR sky130_fd_sc_hd__tapvpwrvgnd_1
XFILLER_85_895 VGND VGND VPWR VPWR sky130_fd_sc_hd__fill_1
XTAP_TAPCELL_ROW_4_398 VGND VPWR sky130_fd_sc_hd__tapvpwrvgnd_1
XFILLER_17_417 VPWR VGND VPWR VGND sky130_ef_sc_hd__decap_12
XFILLER_29_255 VPWR VGND VPWR VGND sky130_ef_sc_hd__decap_12
XFILLER_72_545 VGND VGND VPWR VPWR sky130_fd_sc_hd__decap_3
XFILLER_72_589 VPWR VGND VPWR VGND sky130_ef_sc_hd__decap_12
XFILLER_72_567 VPWR VGND VPWR VGND sky130_ef_sc_hd__decap_12
XFILLER_16_41 VPWR VGND VPWR VGND sky130_ef_sc_hd__decap_12
XFILLER_25_461 VPWR VGND VPWR VGND sky130_ef_sc_hd__decap_12
XFILLER_53_781 VGND VGND VPWR VPWR sky130_fd_sc_hd__decap_3
XPHY_EDGE_ROW_11_Right_11 VGND VGND VPWR VPWR sky130_fd_sc_hd__decap_3
XFILLER_16_85 VPWR VGND VPWR VGND sky130_ef_sc_hd__decap_12
XTAP_TAPCELL_ROW_101_1952 VGND VPWR sky130_fd_sc_hd__tapvpwrvgnd_1
XTAP_TAPCELL_ROW_101_1941 VGND VPWR sky130_fd_sc_hd__tapvpwrvgnd_1
XFILLER_52_291 VGND VGND VPWR VPWR sky130_fd_sc_hd__decap_8
XFILLER_12_133 VGND VGND VPWR VPWR sky130_fd_sc_hd__decap_6
XFILLER_139_853 VPWR VGND VPWR VGND sky130_ef_sc_hd__decap_12
XFILLER_12_177 VPWR VGND VPWR VGND sky130_ef_sc_hd__decap_12
XFILLER_40_475 VGND VGND VPWR VPWR sky130_fd_sc_hd__fill_1
XTAP_TAPCELL_ROW_23_695 VGND VPWR sky130_fd_sc_hd__tapvpwrvgnd_1
XFILLER_139_897 VPWR VGND VPWR VGND sky130_ef_sc_hd__decap_12
XFILLER_138_363 VGND VGND VPWR VPWR sky130_fd_sc_hd__fill_1
XFILLER_126_525 VGND VGND VPWR VPWR sky130_fd_sc_hd__decap_6
XFILLER_5_833 VGND VGND VPWR VPWR sky130_fd_sc_hd__decap_6
XFILLER_153_333 VGND VGND VPWR VPWR sky130_fd_sc_hd__decap_3
XTAP_TAPCELL_ROW_134_2473 VGND VPWR sky130_fd_sc_hd__tapvpwrvgnd_1
XFILLER_126_569 VPWR VGND VPWR VGND sky130_ef_sc_hd__decap_12
XFILLER_153_377 VPWR VGND VPWR VGND sky130_ef_sc_hd__decap_12
XFILLER_141_517 VPWR VGND VPWR VGND sky130_ef_sc_hd__decap_12
XFILLER_107_783 VGND VGND VPWR VPWR sky130_fd_sc_hd__fill_1
XFILLER_5_877 VPWR VGND VPWR VGND sky130_ef_sc_hd__decap_12
XFILLER_79_111 VGND VGND VPWR VPWR sky130_fd_sc_hd__fill_1
XPHY_EDGE_ROW_20_Right_20 VGND VGND VPWR VPWR sky130_fd_sc_hd__decap_3
XFILLER_79_166 VGND VGND VPWR VPWR sky130_fd_sc_hd__fill_2
XFILLER_67_317 VGND VGND VPWR VPWR sky130_fd_sc_hd__decap_8
XFILLER_94_158 VPWR VGND VPWR VGND sky130_ef_sc_hd__decap_12
XFILLER_82_309 VPWR VGND VPWR VGND sky130_ef_sc_hd__decap_12
XFILLER_48_531 VGND VGND VPWR VPWR sky130_fd_sc_hd__fill_1
XFILLER_91_821 VPWR VGND VPWR VGND sky130_ef_sc_hd__decap_12
XFILLER_75_361 VPWR VGND VPWR VGND sky130_ef_sc_hd__decap_12
XFILLER_63_501 VGND VGND VPWR VPWR sky130_fd_sc_hd__decap_3
XFILLER_48_575 VPWR VGND VPWR VGND sky130_ef_sc_hd__decap_12
XANTENNA__2817__X _0553_ VGND VGND VPWR VPWR sky130_fd_sc_hd__diode_2
XFILLER_36_737 VPWR VGND VPWR VGND sky130_ef_sc_hd__decap_12
XFILLER_91_865 VPWR VGND VPWR VGND sky130_ef_sc_hd__decap_12
XFILLER_35_225 VGND VGND VPWR VPWR sky130_fd_sc_hd__decap_8
XFILLER_51_729 VPWR VGND VPWR VGND sky130_ef_sc_hd__decap_12
XANTENNA__3281__CLK clknet_3_1__leaf_clk VGND VGND VPWR VPWR sky130_fd_sc_hd__diode_2
X_2911_ _0595_ _0594_ VGND VGND VPWR VPWR _0599_ sky130_fd_sc_hd__nand2b_1
XFILLER_44_781 VPWR VGND VPWR VGND sky130_ef_sc_hd__decap_12
XFILLER_149_617 VPWR VGND VPWR VGND sky130_ef_sc_hd__decap_12
XFILLER_85_3 VGND VGND VPWR VPWR sky130_fd_sc_hd__decap_8
X_2842_ net15 A_reg\[8\] _0383_ VGND VGND VPWR VPWR _0065_ sky130_fd_sc_hd__mux2_1
X_2773_ _0436_ _0512_ VGND VGND VPWR VPWR _0513_ sky130_fd_sc_hd__and2_1
XANTENNA__3188__B2 CRT_Start VGND VGND VPWR VPWR sky130_fd_sc_hd__diode_2
XFILLER_31_497 VGND VGND VPWR VPWR sky130_fd_sc_hd__decap_6
XFILLER_129_385 VGND VGND VPWR VPWR sky130_fd_sc_hd__decap_6
XFILLER_117_503 VGND VGND VPWR VPWR sky130_fd_sc_hd__fill_1
X_1724_ _0911_ _0997_ VGND VGND VPWR VPWR _1000_ sky130_fd_sc_hd__nor2_1
XANTENNA__1609__A A_reg\[10\] VGND VGND VPWR VPWR sky130_fd_sc_hd__diode_2
XFILLER_144_333 VPWR VGND VPWR VGND sky130_ef_sc_hd__decap_12
XFILLER_105_709 VPWR VGND VPWR VGND sky130_ef_sc_hd__decap_12
XFILLER_8_693 VGND VGND VPWR VPWR sky130_fd_sc_hd__decap_6
XFILLER_7_181 VPWR VGND VPWR VGND sky130_ef_sc_hd__decap_12
XFILLER_145_889 VGND VGND VPWR VPWR sky130_fd_sc_hd__decap_6
XFILLER_144_377 VPWR VGND VPWR VGND sky130_ef_sc_hd__decap_12
XTAP_TAPCELL_ROW_74_1520 VGND VPWR sky130_fd_sc_hd__tapvpwrvgnd_1
XTAP_TAPCELL_ROW_57_1239 VGND VPWR sky130_fd_sc_hd__tapvpwrvgnd_1
X_1655_ _0921_ _0930_ VGND VGND VPWR VPWR _0931_ sky130_fd_sc_hd__nand2_1
XFILLER_113_753 VPWR VGND VPWR VGND sky130_ef_sc_hd__decap_12
XFILLER_98_475 VGND VGND VPWR VPWR sky130_fd_sc_hd__fill_1
XFILLER_113_797 VPWR VGND VPWR VGND sky130_ef_sc_hd__decap_12
X_3256_ clknet_3_6__leaf_clk _0039_ net36 VGND VGND VPWR VPWR u_crt.r3\[2\] sky130_fd_sc_hd__dfrtp_4
XFILLER_85_125 VPWR VGND VPWR VGND sky130_ef_sc_hd__decap_12
X_2207_ _1458_ _1459_ _1462_ VGND VGND VPWR VPWR _1464_ sky130_fd_sc_hd__mux2_1
XFILLER_39_553 VGND VGND VPWR VPWR sky130_fd_sc_hd__decap_6
XFILLER_94_681 VPWR VGND VPWR VGND sky130_ef_sc_hd__decap_12
XFILLER_85_169 VGND VGND VPWR VPWR sky130_fd_sc_hd__decap_4
XFILLER_67_895 VGND VGND VPWR VPWR sky130_fd_sc_hd__fill_1
X_3187_ _0867_ _0869_ _0912_ VGND VGND VPWR VPWR _0871_ sky130_fd_sc_hd__a21oi_1
X_2138_ B_reg\[2\] _1394_ _1395_ VGND VGND VPWR VPWR _1397_ sky130_fd_sc_hd__a21bo_1
XFILLER_66_394 VPWR VGND VPWR VGND sky130_ef_sc_hd__decap_12
XTAP_TAPCELL_ROW_1_346 VGND VPWR sky130_fd_sc_hd__tapvpwrvgnd_1
XFILLER_39_597 VPWR VGND VPWR VGND sky130_ef_sc_hd__decap_12
X_2069_ B_reg\[3\] _1330_ VGND VGND VPWR VPWR _1331_ sky130_fd_sc_hd__or2_1
XFILLER_54_589 VPWR VGND VPWR VGND sky130_ef_sc_hd__decap_12
XANTENNA__2175__A A_reg\[9\] VGND VGND VPWR VPWR sky130_fd_sc_hd__diode_2
XFILLER_26_247 VGND VGND VPWR VPWR sky130_fd_sc_hd__decap_4
XTAP_TAPCELL_ROW_85_1693 VGND VPWR sky130_fd_sc_hd__tapvpwrvgnd_1
XFILLER_81_397 VGND VGND VPWR VPWR sky130_fd_sc_hd__fill_1
XFILLER_81_386 VGND VGND VPWR VPWR sky130_fd_sc_hd__decap_6
XFILLER_53_28 VPWR VGND VPWR VGND sky130_ef_sc_hd__decap_12
XFILLER_139_105 VGND VGND VPWR VPWR sky130_fd_sc_hd__decap_6
XANTENNA__2600__A1_N OpSel_reg\[0\] VGND VGND VPWR VPWR sky130_fd_sc_hd__diode_2
XFILLER_139_149 VPWR VGND VPWR VGND sky130_ef_sc_hd__decap_12
XFILLER_10_637 VGND VGND VPWR VPWR sky130_fd_sc_hd__decap_6
XFILLER_108_525 VGND VGND VPWR VPWR sky130_fd_sc_hd__decap_6
XTAP_TAPCELL_ROW_20_654 VGND VPWR sky130_fd_sc_hd__tapvpwrvgnd_1
XFILLER_147_193 VPWR VGND VPWR VGND sky130_ef_sc_hd__decap_12
XFILLER_136_867 VGND VGND VPWR VPWR sky130_fd_sc_hd__fill_1
XFILLER_123_517 VPWR VGND VPWR VGND sky130_ef_sc_hd__decap_12
XFILLER_118_65 VPWR VGND VPWR VGND sky130_ef_sc_hd__decap_12
XTAP_TAPCELL_ROW_116_2192 VGND VPWR sky130_fd_sc_hd__tapvpwrvgnd_1
XTAP_TAPCELL_ROW_116_2181 VGND VPWR sky130_fd_sc_hd__tapvpwrvgnd_1
XFILLER_2_825 VPWR VGND VPWR VGND sky130_ef_sc_hd__decap_12
XTAP_TAPCELL_ROW_9_468 VGND VPWR sky130_fd_sc_hd__tapvpwrvgnd_1
XFILLER_131_561 VPWR VGND VPWR VGND sky130_ef_sc_hd__decap_12
XFILLER_77_615 VGND VGND VPWR VPWR sky130_fd_sc_hd__fill_1
XTAP_TAPCELL_ROW_9_479 VGND VPWR sky130_fd_sc_hd__tapvpwrvgnd_1
XFILLER_2_869 VPWR VGND VPWR VGND sky130_ef_sc_hd__decap_12
XFILLER_1_335 VGND VGND VPWR VPWR sky130_fd_sc_hd__fill_1
XFILLER_134_53 VPWR VGND VPWR VGND sky130_ef_sc_hd__decap_12
XFILLER_89_497 VGND VGND VPWR VPWR sky130_fd_sc_hd__decap_6
XFILLER_49_317 VPWR VGND VPWR VGND sky130_ef_sc_hd__decap_12
XFILLER_134_97 VPWR VGND VPWR VGND sky130_ef_sc_hd__decap_12
XFILLER_91_106 VGND VGND VPWR VPWR sky130_fd_sc_hd__fill_1
XFILLER_85_670 VGND VGND VPWR VPWR sky130_fd_sc_hd__fill_2
XFILLER_73_821 VPWR VGND VPWR VGND sky130_ef_sc_hd__decap_12
XFILLER_64_309 VPWR VGND VPWR VGND sky130_ef_sc_hd__decap_12
XFILLER_57_361 VPWR VGND VPWR VGND sky130_ef_sc_hd__decap_12
XFILLER_17_225 VPWR VGND VPWR VGND sky130_ef_sc_hd__decap_12
XFILLER_18_737 VPWR VGND VPWR VGND sky130_ef_sc_hd__decap_12
XFILLER_27_51 VGND VGND VPWR VPWR sky130_fd_sc_hd__decap_4
XFILLER_45_534 VGND VGND VPWR VPWR sky130_fd_sc_hd__fill_1
XFILLER_45_545 VGND VGND VPWR VPWR sky130_fd_sc_hd__decap_8
XFILLER_150_41 VPWR VGND VPWR VGND sky130_ef_sc_hd__decap_12
XFILLER_73_865 VPWR VGND VPWR VGND sky130_ef_sc_hd__decap_12
XTAP_TAPCELL_ROW_28_776 VGND VPWR sky130_fd_sc_hd__tapvpwrvgnd_1
XFILLER_33_729 VPWR VGND VPWR VGND sky130_ef_sc_hd__decap_12
XFILLER_150_85 VPWR VGND VPWR VGND sky130_ef_sc_hd__decap_12
XFILLER_26_781 VPWR VGND VPWR VGND sky130_ef_sc_hd__decap_12
XTAP_TAPCELL_ROW_28_787 VGND VPWR sky130_fd_sc_hd__tapvpwrvgnd_1
XTAP_TAPCELL_ROW_136_2513 VGND VPWR sky130_fd_sc_hd__tapvpwrvgnd_1
XTAP_TAPCELL_ROW_136_2502 VGND VPWR sky130_fd_sc_hd__tapvpwrvgnd_1
XANTENNA__2090__B2 Encode_EN VGND VGND VPWR VPWR sky130_fd_sc_hd__diode_2
XFILLER_13_464 VPWR VGND VPWR VGND sky130_ef_sc_hd__decap_12
XFILLER_40_283 VGND VGND VPWR VPWR sky130_fd_sc_hd__decap_8
XFILLER_126_333 VPWR VGND VPWR VGND sky130_ef_sc_hd__decap_12
XFILLER_153_141 VPWR VGND VPWR VGND sky130_ef_sc_hd__decap_12
XFILLER_142_837 VPWR VGND VPWR VGND sky130_ef_sc_hd__decap_12
XFILLER_127_889 VGND VGND VPWR VPWR sky130_fd_sc_hd__decap_6
XFILLER_126_377 VPWR VGND VPWR VGND sky130_ef_sc_hd__decap_12
XFILLER_5_685 VPWR VGND VPWR VGND sky130_ef_sc_hd__decap_12
XFILLER_110_701 VPWR VGND VPWR VGND sky130_ef_sc_hd__decap_12
XFILLER_4_195 VGND VGND VPWR VPWR sky130_fd_sc_hd__fill_1
XFILLER_4_77 VGND VGND VPWR VPWR sky130_fd_sc_hd__decap_6
XFILLER_150_881 VPWR VGND VPWR VGND sky130_ef_sc_hd__decap_12
X_3110_ _0773_ _0780_ _0797_ VGND VGND VPWR VPWR _0798_ sky130_fd_sc_hd__or3_4
XTAP_TAPCELL_ROW_52_1158 VGND VPWR sky130_fd_sc_hd__tapvpwrvgnd_1
XFILLER_95_434 VGND VGND VPWR VPWR sky130_fd_sc_hd__decap_4
XFILLER_67_125 VPWR VGND VPWR VGND sky130_ef_sc_hd__decap_12
XTAP_TAPCELL_ROW_52_1169 VGND VPWR sky130_fd_sc_hd__tapvpwrvgnd_1
XTAP_TAPCELL_ROW_147_2686 VGND VPWR sky130_fd_sc_hd__tapvpwrvgnd_1
XFILLER_83_629 VPWR VGND VPWR VGND sky130_ef_sc_hd__decap_12
XFILLER_67_169 VPWR VGND VPWR VGND sky130_ef_sc_hd__decap_12
X_3041_ _0718_ _0728_ VGND VGND VPWR VPWR _0729_ sky130_fd_sc_hd__nand2_1
XFILLER_49_884 VPWR VGND VPWR VGND sky130_ef_sc_hd__decap_12
XFILLER_36_512 VPWR VGND VPWR VGND sky130_ef_sc_hd__decap_12
XFILLER_63_331 VGND VGND VPWR VPWR sky130_fd_sc_hd__decap_4
XFILLER_36_545 VPWR VGND VPWR VGND sky130_ef_sc_hd__decap_12
XFILLER_91_673 VPWR VGND VPWR VGND sky130_ef_sc_hd__decap_12
XFILLER_90_150 VPWR VGND VPWR VGND sky130_ef_sc_hd__decap_12
XFILLER_23_217 VGND VGND VPWR VPWR sky130_fd_sc_hd__decap_6
XFILLER_36_589 VPWR VGND VPWR VGND sky130_ef_sc_hd__decap_12
XFILLER_90_194 VGND VGND VPWR VPWR sky130_fd_sc_hd__fill_2
XANTENNA__2605__B1 _0187_ VGND VGND VPWR VPWR sky130_fd_sc_hd__diode_2
XFILLER_51_559 VGND VGND VPWR VPWR sky130_fd_sc_hd__fill_1
XFILLER_149_447 VGND VGND VPWR VPWR sky130_fd_sc_hd__fill_1
XFILLER_31_261 VPWR VGND VPWR VGND sky130_ef_sc_hd__decap_12
XFILLER_137_609 VGND VGND VPWR VPWR sky130_fd_sc_hd__decap_6
Xclkbuf_3_2__f_clk clknet_0_clk VGND VGND VPWR VPWR clknet_3_2__leaf_clk sky130_fd_sc_hd__clkbuf_16
XFILLER_32_795 VGND VGND VPWR VPWR sky130_fd_sc_hd__decap_3
X_2825_ net51 X_crt\[7\] _0553_ VGND VGND VPWR VPWR _0048_ sky130_fd_sc_hd__mux2_1
XFILLER_145_653 VPWR VGND VPWR VGND sky130_ef_sc_hd__decap_12
XFILLER_129_193 VPWR VGND VPWR VGND sky130_ef_sc_hd__decap_12
XFILLER_118_867 VGND VGND VPWR VPWR sky130_fd_sc_hd__fill_1
X_2756_ _0476_ _0488_ _0494_ _0188_ VGND VGND VPWR VPWR _0496_ sky130_fd_sc_hd__a31o_1
XFILLER_144_141 VPWR VGND VPWR VGND sky130_ef_sc_hd__decap_12
XFILLER_105_517 VPWR VGND VPWR VGND sky130_ef_sc_hd__decap_12
X_2687_ _0425_ _0426_ VGND VGND VPWR VPWR _0427_ sky130_fd_sc_hd__xnor2_1
X_1707_ _0981_ _0982_ VGND VGND VPWR VPWR _0983_ sky130_fd_sc_hd__or2_1
XFILLER_145_697 VPWR VGND VPWR VGND sky130_ef_sc_hd__decap_12
X_1638_ A_reg\[13\] _0913_ VGND VGND VPWR VPWR _0914_ sky130_fd_sc_hd__and2_1
XFILLER_113_561 VPWR VGND VPWR VGND sky130_ef_sc_hd__decap_12
XFILLER_86_401 VPWR VGND VPWR VGND sky130_ef_sc_hd__decap_12
XFILLER_59_615 VGND VGND VPWR VPWR sky130_fd_sc_hd__fill_1
XTAP_TAPCELL_ROW_6_427 VGND VPWR sky130_fd_sc_hd__tapvpwrvgnd_1
XFILLER_86_445 VPWR VGND VPWR VGND sky130_ef_sc_hd__decap_12
XFILLER_74_607 VPWR VGND VPWR VGND sky130_ef_sc_hd__decap_12
X_3308_ clknet_3_7__leaf_clk _0091_ net36 VGND VGND VPWR VPWR X_crt\[2\] sky130_fd_sc_hd__dfrtp_1
XFILLER_100_277 VPWR VGND VPWR VGND sky130_ef_sc_hd__decap_12
X_3239_ clknet_3_3__leaf_clk _0026_ net36 VGND VGND VPWR VPWR b_r3\[3\] sky130_fd_sc_hd__dfrtp_4
XFILLER_39_361 VPWR VGND VPWR VGND sky130_ef_sc_hd__decap_12
XFILLER_46_309 VPWR VGND VPWR VGND sky130_ef_sc_hd__decap_12
XTAP_TAPCELL_ROW_87_1722 VGND VPWR sky130_fd_sc_hd__tapvpwrvgnd_1
XFILLER_64_27 VGND VGND VPWR VPWR sky130_fd_sc_hd__fill_1
XFILLER_70_813 VPWR VGND VPWR VGND sky130_ef_sc_hd__decap_12
XFILLER_55_887 VGND VGND VPWR VPWR sky130_fd_sc_hd__decap_8
XFILLER_54_386 VPWR VGND VPWR VGND sky130_ef_sc_hd__decap_12
XFILLER_15_729 VPWR VGND VPWR VGND sky130_ef_sc_hd__decap_12
XTAP_TAPCELL_ROW_25_724 VGND VPWR sky130_fd_sc_hd__tapvpwrvgnd_1
XFILLER_42_526 VGND VGND VPWR VPWR sky130_fd_sc_hd__decap_6
XFILLER_14_239 VGND VGND VPWR VPWR sky130_fd_sc_hd__fill_1
XTAP_TAPCELL_ROW_25_735 VGND VPWR sky130_fd_sc_hd__tapvpwrvgnd_1
XFILLER_120_77 VGND VGND VPWR VPWR sky130_fd_sc_hd__decap_6
XFILLER_80_15 VPWR VGND VPWR VGND sky130_ef_sc_hd__decap_12
XTAP_TAPCELL_ROW_118_2221 VGND VPWR sky130_fd_sc_hd__tapvpwrvgnd_1
XFILLER_10_445 VGND VGND VPWR VPWR sky130_fd_sc_hd__decap_8
XFILLER_6_416 VGND VGND VPWR VPWR sky130_fd_sc_hd__decap_4
XFILLER_108_333 VPWR VGND VPWR VGND sky130_ef_sc_hd__decap_12
XFILLER_10_489 VPWR VGND VPWR VGND sky130_ef_sc_hd__decap_12
XTAP_TAPCELL_ROW_131_2432 VGND VPWR sky130_fd_sc_hd__tapvpwrvgnd_1
XTAP_TAPCELL_ROW_131_2421 VGND VPWR sky130_fd_sc_hd__tapvpwrvgnd_1
XFILLER_109_889 VGND VGND VPWR VPWR sky130_fd_sc_hd__decap_6
XFILLER_108_377 VGND VGND VPWR VPWR sky130_fd_sc_hd__decap_6
XTAP_TAPCELL_ROW_98_1895 VGND VPWR sky130_fd_sc_hd__tapvpwrvgnd_1
XFILLER_89_57 VPWR VGND VPWR VGND sky130_ef_sc_hd__decap_12
XFILLER_89_46 VGND VGND VPWR VPWR sky130_fd_sc_hd__decap_8
XFILLER_124_837 VPWR VGND VPWR VGND sky130_ef_sc_hd__decap_12
XFILLER_150_133 VGND VGND VPWR VPWR sky130_fd_sc_hd__decap_6
XFILLER_96_209 VPWR VGND VPWR VGND sky130_ef_sc_hd__decap_12
XANTENNA__3183__B CRT_Start VGND VGND VPWR VPWR sky130_fd_sc_hd__diode_2
XFILLER_150_177 VPWR VGND VPWR VGND sky130_ef_sc_hd__decap_12
XFILLER_132_881 VPWR VGND VPWR VGND sky130_ef_sc_hd__decap_12
XFILLER_2_699 VGND VGND VPWR VPWR sky130_fd_sc_hd__fill_1
XFILLER_131_391 VGND VGND VPWR VPWR sky130_fd_sc_hd__fill_1
XANTENNA__1886__A1 A_reg\[1\] VGND VGND VPWR VPWR sky130_fd_sc_hd__diode_2
XFILLER_49_125 VPWR VGND VPWR VGND sky130_ef_sc_hd__decap_12
XTAP_TAPCELL_ROW_129_2394 VGND VPWR sky130_fd_sc_hd__tapvpwrvgnd_1
XFILLER_92_415 VGND VGND VPWR VPWR sky130_fd_sc_hd__decap_4
XFILLER_58_670 VPWR VGND VPWR VGND sky130_ef_sc_hd__decap_12
XFILLER_49_169 VPWR VGND VPWR VGND sky130_ef_sc_hd__decap_12
XFILLER_18_501 VPWR VGND VPWR VGND sky130_ef_sc_hd__decap_12
XANTENNA__2835__A0 net8 VGND VGND VPWR VPWR sky130_fd_sc_hd__diode_2
XFILLER_38_83 VGND VGND VPWR VPWR sky130_fd_sc_hd__fill_1
XFILLER_18_545 VPWR VGND VPWR VGND sky130_ef_sc_hd__decap_12
XFILLER_73_673 VPWR VGND VPWR VGND sky130_ef_sc_hd__decap_12
XFILLER_72_161 VPWR VGND VPWR VGND sky130_ef_sc_hd__decap_12
XFILLER_18_589 VPWR VGND VPWR VGND sky130_ef_sc_hd__decap_12
XFILLER_60_356 VGND VGND VPWR VPWR sky130_fd_sc_hd__decap_8
XFILLER_60_389 VPWR VGND VPWR VGND sky130_ef_sc_hd__decap_12
XFILLER_20_209 VPWR VGND VPWR VGND sky130_ef_sc_hd__decap_12
XFILLER_119_609 VGND VGND VPWR VPWR sky130_fd_sc_hd__decap_6
X_2610_ _0354_ _0352_ VGND VGND VPWR VPWR _0355_ sky130_fd_sc_hd__and2b_1
XFILLER_142_601 VPWR VGND VPWR VGND sky130_ef_sc_hd__decap_12
XFILLER_127_653 VPWR VGND VPWR VGND sky130_ef_sc_hd__decap_12
XFILLER_126_141 VPWR VGND VPWR VGND sky130_ef_sc_hd__decap_12
X_2541_ _0258_ _0268_ _0277_ VGND VGND VPWR VPWR _0289_ sky130_fd_sc_hd__mux2_1
XFILLER_142_645 VPWR VGND VPWR VGND sky130_ef_sc_hd__decap_12
XFILLER_141_111 VGND VGND VPWR VPWR sky130_fd_sc_hd__fill_1
XFILLER_127_697 VPWR VGND VPWR VGND sky130_ef_sc_hd__decap_12
X_2472_ _0185_ _0216_ _0217_ _0219_ VGND VGND VPWR VPWR _0220_ sky130_fd_sc_hd__a31o_1
XTAP_TAPCELL_ROW_149_2715 VGND VPWR sky130_fd_sc_hd__tapvpwrvgnd_1
XFILLER_48_3 VPWR VGND VPWR VGND sky130_ef_sc_hd__decap_12
XFILLER_68_401 VPWR VGND VPWR VGND sky130_ef_sc_hd__decap_12
XFILLER_84_905 VGND VGND VPWR VPWR sky130_fd_sc_hd__decap_4
XFILLER_68_489 VPWR VGND VPWR VGND sky130_ef_sc_hd__decap_12
XFILLER_56_629 VPWR VGND VPWR VGND sky130_ef_sc_hd__decap_12
XFILLER_49_670 VGND VGND VPWR VPWR sky130_fd_sc_hd__fill_2
XFILLER_28_309 VGND VGND VPWR VPWR sky130_fd_sc_hd__decap_4
XANTENNA__1622__A B_reg\[8\] VGND VGND VPWR VPWR sky130_fd_sc_hd__diode_2
XTAP_TAPCELL_ROW_69_1430 VGND VPWR sky130_fd_sc_hd__tapvpwrvgnd_1
X_3024_ _0621_ _0711_ _0710_ VGND VGND VPWR VPWR _0712_ sky130_fd_sc_hd__o21ba_1
XFILLER_37_821 VPWR VGND VPWR VGND sky130_ef_sc_hd__decap_12
XTAP_TAPCELL_ROW_69_1441 VGND VPWR sky130_fd_sc_hd__tapvpwrvgnd_1
XFILLER_37_865 VPWR VGND VPWR VGND sky130_ef_sc_hd__decap_12
XFILLER_52_813 VGND VGND VPWR VPWR sky130_fd_sc_hd__decap_4
XTAP_TAPCELL_ROW_82_1641 VGND VPWR sky130_fd_sc_hd__tapvpwrvgnd_1
XFILLER_63_194 VPWR VGND VPWR VGND sky130_ef_sc_hd__decap_12
XFILLER_52_857 VGND VGND VPWR VPWR sky130_fd_sc_hd__decap_8
XFILLER_51_356 VPWR VGND VPWR VGND sky130_ef_sc_hd__decap_12
XANTENNA__2453__A _0188_ VGND VGND VPWR VPWR sky130_fd_sc_hd__diode_2
XFILLER_137_417 VPWR VGND VPWR VGND sky130_ef_sc_hd__decap_12
XFILLER_50_29 VGND VGND VPWR VPWR sky130_fd_sc_hd__decap_8
X_2808_ u_crt.r3\[1\] _0910_ _0184_ _0546_ VGND VGND VPWR VPWR _0038_ sky130_fd_sc_hd__a22o_1
XFILLER_145_461 VPWR VGND VPWR VGND sky130_ef_sc_hd__decap_12
X_2739_ _0425_ _0451_ _0455_ VGND VGND VPWR VPWR _0479_ sky130_fd_sc_hd__and3_1
XFILLER_4_909 VGND VGND VPWR VPWR sky130_fd_sc_hd__fill_1
XTAP_TAPCELL_ROW_113_2140 VGND VPWR sky130_fd_sc_hd__tapvpwrvgnd_1
XFILLER_106_837 VPWR VGND VPWR VGND sky130_ef_sc_hd__decap_12
XFILLER_132_133 VGND VGND VPWR VPWR sky130_fd_sc_hd__decap_6
XFILLER_132_177 VPWR VGND VPWR VGND sky130_ef_sc_hd__decap_12
XFILLER_114_881 VPWR VGND VPWR VGND sky130_ef_sc_hd__decap_12
XFILLER_115_55 VGND VGND VPWR VPWR sky130_fd_sc_hd__fill_1
XFILLER_113_391 VGND VGND VPWR VPWR sky130_fd_sc_hd__fill_1
XFILLER_87_765 VPWR VGND VPWR VGND sky130_ef_sc_hd__decap_12
XFILLER_101_553 VGND VGND VPWR VPWR sky130_fd_sc_hd__fill_2
XFILLER_47_629 VPWR VGND VPWR VGND sky130_ef_sc_hd__decap_12
XFILLER_101_586 VPWR VGND VPWR VGND sky130_ef_sc_hd__decap_12
XFILLER_46_139 VGND VGND VPWR VPWR sky130_fd_sc_hd__fill_1
XFILLER_55_662 VGND VGND VPWR VPWR sky130_fd_sc_hd__fill_2
XFILLER_27_331 VGND VGND VPWR VPWR sky130_fd_sc_hd__decap_4
XFILLER_70_621 VGND VGND VPWR VPWR sky130_fd_sc_hd__decap_6
XFILLER_55_673 VPWR VGND VPWR VGND sky130_ef_sc_hd__decap_12
XFILLER_152_3 VPWR VGND VPWR VGND sky130_ef_sc_hd__decap_12
XFILLER_15_559 VGND VGND VPWR VPWR sky130_fd_sc_hd__fill_1
XFILLER_42_323 VGND VGND VPWR VPWR sky130_fd_sc_hd__decap_6
XFILLER_91_69 VGND VGND VPWR VPWR sky130_fd_sc_hd__decap_6
XFILLER_24_41 VPWR VGND VPWR VGND sky130_ef_sc_hd__decap_12
XFILLER_42_356 VGND VGND VPWR VPWR sky130_fd_sc_hd__decap_6
XPHY_EDGE_ROW_145_Right_145 VGND VGND VPWR VPWR sky130_fd_sc_hd__decap_3
XFILLER_11_721 VGND VGND VPWR VPWR sky130_fd_sc_hd__decap_6
XFILLER_24_85 VPWR VGND VPWR VGND sky130_ef_sc_hd__decap_12
XFILLER_10_253 VPWR VGND VPWR VGND sky130_ef_sc_hd__decap_12
XFILLER_11_765 VPWR VGND VPWR VGND sky130_ef_sc_hd__decap_12
XFILLER_124_601 VPWR VGND VPWR VGND sky130_ef_sc_hd__decap_12
XFILLER_109_653 VPWR VGND VPWR VGND sky130_ef_sc_hd__decap_12
XFILLER_108_141 VPWR VGND VPWR VGND sky130_ef_sc_hd__decap_12
XFILLER_123_111 VGND VGND VPWR VPWR sky130_fd_sc_hd__fill_1
XFILLER_109_697 VPWR VGND VPWR VGND sky130_ef_sc_hd__decap_12
XFILLER_124_645 VPWR VGND VPWR VGND sky130_ef_sc_hd__decap_12
XFILLER_151_497 VGND VGND VPWR VPWR sky130_fd_sc_hd__decap_6
XFILLER_111_317 VPWR VGND VPWR VGND sky130_ef_sc_hd__decap_12
XFILLER_66_905 VGND VGND VPWR VPWR sky130_fd_sc_hd__decap_4
XFILLER_49_93 VPWR VGND VPWR VGND sky130_ef_sc_hd__decap_12
XTAP_TAPCELL_ROW_144_2634 VGND VPWR sky130_fd_sc_hd__tapvpwrvgnd_1
XFILLER_19_821 VPWR VGND VPWR VGND sky130_ef_sc_hd__decap_12
XANTENNA__2808__B1 _0184_ VGND VGND VPWR VPWR sky130_fd_sc_hd__diode_2
XFILLER_92_245 VGND VGND VPWR VPWR sky130_fd_sc_hd__decap_6
XFILLER_19_865 VPWR VGND VPWR VGND sky130_ef_sc_hd__decap_12
XFILLER_92_289 VPWR VGND VPWR VGND sky130_ef_sc_hd__decap_12
XFILLER_65_81 VGND VGND VPWR VPWR sky130_fd_sc_hd__fill_1
XFILLER_33_312 VPWR VGND VPWR VGND sky130_ef_sc_hd__decap_12
XFILLER_34_813 VPWR VGND VPWR VGND sky130_ef_sc_hd__decap_12
XFILLER_45_161 VGND VGND VPWR VPWR sky130_fd_sc_hd__decap_6
XFILLER_33_345 VGND VGND VPWR VPWR sky130_fd_sc_hd__fill_1
XTAP_TAPCELL_ROW_64_1360 VGND VPWR sky130_fd_sc_hd__tapvpwrvgnd_1
XFILLER_60_153 VPWR VGND VPWR VGND sky130_ef_sc_hd__decap_12
XFILLER_33_378 VPWR VGND VPWR VGND sky130_ef_sc_hd__decap_12
XTAP_TAPCELL_ROW_47_1079 VGND VPWR sky130_fd_sc_hd__tapvpwrvgnd_1
X_1972_ _1229_ _1234_ VGND VGND VPWR VPWR _1237_ sky130_fd_sc_hd__and2_1
XFILLER_60_197 VPWR VGND VPWR VGND sky130_ef_sc_hd__decap_12
XFILLER_14_581 VGND VGND VPWR VPWR sky130_fd_sc_hd__decap_6
XTAP_TAPCELL_ROW_16_587 VGND VPWR sky130_fd_sc_hd__tapvpwrvgnd_1
XFILLER_21_529 VPWR VGND VPWR VGND sky130_ef_sc_hd__decap_12
XFILLER_119_417 VPWR VGND VPWR VGND sky130_ef_sc_hd__decap_12
XPHY_EDGE_ROW_112_Right_112 VGND VGND VPWR VPWR sky130_fd_sc_hd__decap_3
XFILLER_127_461 VPWR VGND VPWR VGND sky130_ef_sc_hd__decap_12
XPHY_EDGE_ROW_49_Right_49 VGND VGND VPWR VPWR sky130_fd_sc_hd__decap_3
XFILLER_114_133 VGND VGND VPWR VPWR sky130_fd_sc_hd__decap_6
X_2524_ _0265_ _0271_ VGND VGND VPWR VPWR _0272_ sky130_fd_sc_hd__nor2_1
XFILLER_142_475 VGND VGND VPWR VPWR sky130_fd_sc_hd__fill_1
XFILLER_114_177 VPWR VGND VPWR VGND sky130_ef_sc_hd__decap_12
X_2455_ a_r0\[0\] OpSel_reg\[0\] OpSel_reg\[1\] _0204_ VGND VGND VPWR VPWR _0205_
+ sky130_fd_sc_hd__or4b_1
XFILLER_69_721 VGND VGND VPWR VPWR sky130_fd_sc_hd__decap_6
XANTENNA__3215__CLK clknet_3_4__leaf_clk VGND VGND VPWR VPWR sky130_fd_sc_hd__diode_2
XFILLER_130_637 VGND VGND VPWR VPWR sky130_fd_sc_hd__decap_6
X_2386_ _0125_ _0136_ VGND VGND VPWR VPWR _0140_ sky130_fd_sc_hd__xnor2_1
XFILLER_68_231 VPWR VGND VPWR VGND sky130_ef_sc_hd__decap_12
XFILLER_84_713 VPWR VGND VPWR VGND sky130_ef_sc_hd__decap_12
XFILLER_69_765 VPWR VGND VPWR VGND sky130_ef_sc_hd__decap_12
XFILLER_68_253 VPWR VGND VPWR VGND sky130_ef_sc_hd__decap_12
XFILLER_29_629 VPWR VGND VPWR VGND sky130_ef_sc_hd__decap_12
XFILLER_111_895 VGND VGND VPWR VPWR sky130_fd_sc_hd__fill_1
XFILLER_84_757 VPWR VGND VPWR VGND sky130_ef_sc_hd__decap_12
XFILLER_83_223 VGND VGND VPWR VPWR sky130_fd_sc_hd__fill_1
XANTENNA__3247__RESET_B net36 VGND VGND VPWR VPWR sky130_fd_sc_hd__diode_2
XFILLER_28_139 VGND VGND VPWR VPWR sky130_fd_sc_hd__fill_1
XPHY_EDGE_ROW_58_Right_58 VGND VGND VPWR VPWR sky130_fd_sc_hd__decap_3
XFILLER_56_459 VPWR VGND VPWR VGND sky130_ef_sc_hd__decap_12
X_3007_ _0693_ _0694_ VGND VGND VPWR VPWR _0695_ sky130_fd_sc_hd__nand2b_1
XFILLER_24_301 VGND VGND VPWR VPWR sky130_fd_sc_hd__decap_6
XFILLER_37_673 VPWR VGND VPWR VGND sky130_ef_sc_hd__decap_12
XFILLER_52_643 VGND VGND VPWR VPWR sky130_fd_sc_hd__fill_1
XFILLER_101_57 VPWR VGND VPWR VGND sky130_ef_sc_hd__decap_12
XFILLER_52_665 VPWR VGND VPWR VGND sky130_ef_sc_hd__decap_12
XFILLER_51_164 VGND VGND VPWR VPWR sky130_fd_sc_hd__decap_4
XPHY_EDGE_ROW_49_Left_203 VGND VGND VPWR VPWR sky130_fd_sc_hd__decap_3
XFILLER_24_389 VPWR VGND VPWR VGND sky130_ef_sc_hd__decap_12
XTAP_TAPCELL_ROW_35_885 VGND VPWR sky130_fd_sc_hd__tapvpwrvgnd_1
XTAP_TAPCELL_ROW_35_896 VGND VPWR sky130_fd_sc_hd__tapvpwrvgnd_1
XFILLER_138_737 VPWR VGND VPWR VGND sky130_ef_sc_hd__decap_12
XFILLER_137_225 VPWR VGND VPWR VGND sky130_ef_sc_hd__decap_12
XFILLER_153_729 VPWR VGND VPWR VGND sky130_ef_sc_hd__decap_12
XFILLER_106_601 VPWR VGND VPWR VGND sky130_ef_sc_hd__decap_12
XPHY_EDGE_ROW_67_Right_67 VGND VGND VPWR VPWR sky130_fd_sc_hd__decap_3
XFILLER_146_781 VPWR VGND VPWR VGND sky130_ef_sc_hd__decap_12
XTAP_TAPCELL_ROW_95_1854 VGND VPWR sky130_fd_sc_hd__tapvpwrvgnd_1
XFILLER_3_205 VPWR VGND VPWR VGND sky130_ef_sc_hd__decap_12
XFILLER_106_645 VPWR VGND VPWR VGND sky130_ef_sc_hd__decap_12
XFILLER_105_111 VGND VGND VPWR VPWR sky130_fd_sc_hd__fill_1
XFILLER_121_615 VGND VGND VPWR VPWR sky130_fd_sc_hd__fill_1
XFILLER_79_529 VGND VGND VPWR VPWR sky130_fd_sc_hd__decap_8
XPHY_EDGE_ROW_58_Left_212 VGND VGND VPWR VPWR sky130_fd_sc_hd__decap_3
XFILLER_10_65 VPWR VGND VPWR VGND sky130_ef_sc_hd__decap_12
XFILLER_133_497 VGND VGND VPWR VPWR sky130_fd_sc_hd__decap_6
XFILLER_126_65 VPWR VGND VPWR VGND sky130_ef_sc_hd__decap_12
XTAP_TAPCELL_ROW_126_2342 VGND VPWR sky130_fd_sc_hd__tapvpwrvgnd_1
XFILLER_101_361 VGND VGND VPWR VPWR sky130_fd_sc_hd__decap_3
XPHY_EDGE_ROW_76_Right_76 VGND VGND VPWR VPWR sky130_fd_sc_hd__decap_3
XFILLER_142_53 VPWR VGND VPWR VGND sky130_ef_sc_hd__decap_12
XTAP_TAPCELL_ROW_126_2353 VGND VPWR sky130_fd_sc_hd__tapvpwrvgnd_1
XFILLER_74_245 VGND VGND VPWR VPWR sky130_fd_sc_hd__decap_6
XFILLER_142_97 VPWR VGND VPWR VGND sky130_ef_sc_hd__decap_12
XFILLER_90_749 VGND VGND VPWR VPWR sky130_fd_sc_hd__decap_6
XFILLER_74_289 VPWR VGND VPWR VGND sky130_ef_sc_hd__decap_12
XFILLER_16_813 VPWR VGND VPWR VGND sky130_ef_sc_hd__decap_12
XFILLER_27_161 VGND VGND VPWR VPWR sky130_fd_sc_hd__decap_6
XFILLER_34_109 VPWR VGND VPWR VGND sky130_ef_sc_hd__decap_12
XFILLER_35_51 VGND VGND VPWR VPWR sky130_fd_sc_hd__decap_4
XPHY_EDGE_ROW_67_Left_221 VGND VGND VPWR VPWR sky130_fd_sc_hd__decap_3
XFILLER_42_153 VGND VGND VPWR VPWR sky130_fd_sc_hd__decap_4
XTAP_TAPCELL_ROW_104_1994 VGND VPWR sky130_fd_sc_hd__tapvpwrvgnd_1
XFILLER_42_197 VPWR VGND VPWR VGND sky130_ef_sc_hd__decap_12
XTAP_TAPCELL_ROW_13_535 VGND VPWR sky130_fd_sc_hd__tapvpwrvgnd_1
XTAP_TAPCELL_ROW_13_546 VGND VPWR sky130_fd_sc_hd__tapvpwrvgnd_1
XFILLER_30_359 VGND VGND VPWR VPWR sky130_fd_sc_hd__decap_4
XPHY_EDGE_ROW_85_Right_85 VGND VGND VPWR VPWR sky130_fd_sc_hd__decap_3
XFILLER_51_72 VGND VGND VPWR VPWR sky130_fd_sc_hd__decap_8
XFILLER_51_94 VGND VGND VPWR VPWR sky130_fd_sc_hd__fill_1
XFILLER_143_217 VGND VGND VPWR VPWR sky130_fd_sc_hd__decap_6
XANTENNA__3238__CLK clknet_3_3__leaf_clk VGND VGND VPWR VPWR sky130_fd_sc_hd__diode_2
XFILLER_98_805 VGND VGND VPWR VPWR sky130_fd_sc_hd__decap_6
XPHY_EDGE_ROW_76_Left_230 VGND VGND VPWR VPWR sky130_fd_sc_hd__decap_3
XFILLER_151_261 VPWR VGND VPWR VGND sky130_ef_sc_hd__decap_12
XFILLER_124_475 VGND VGND VPWR VPWR sky130_fd_sc_hd__fill_1
XFILLER_98_849 VPWR VGND VPWR VGND sky130_ef_sc_hd__decap_12
XFILLER_112_637 VGND VGND VPWR VPWR sky130_fd_sc_hd__decap_6
XFILLER_111_125 VPWR VGND VPWR VGND sky130_ef_sc_hd__decap_12
XFILLER_97_337 VPWR VGND VPWR VGND sky130_ef_sc_hd__decap_12
XFILLER_3_783 VGND VGND VPWR VPWR sky130_fd_sc_hd__fill_1
X_2240_ _1491_ _1496_ VGND VGND VPWR VPWR _1497_ sky130_fd_sc_hd__nand2_1
XFILLER_111_169 VPWR VGND VPWR VGND sky130_ef_sc_hd__decap_12
XPHY_EDGE_ROW_94_Right_94 VGND VGND VPWR VPWR sky130_fd_sc_hd__decap_3
XFILLER_39_905 VGND VGND VPWR VPWR sky130_fd_sc_hd__fill_2
XFILLER_120_681 VPWR VGND VPWR VGND sky130_ef_sc_hd__decap_12
X_2171_ _1424_ _1425_ _1427_ VGND VGND VPWR VPWR _1428_ sky130_fd_sc_hd__a21o_1
XFILLER_38_415 VGND VGND VPWR VPWR sky130_fd_sc_hd__decap_4
XFILLER_66_757 VGND VGND VPWR VPWR sky130_fd_sc_hd__decap_6
XTAP_TAPCELL_ROW_49_1108 VGND VPWR sky130_fd_sc_hd__tapvpwrvgnd_1
XFILLER_81_727 VGND VGND VPWR VPWR sky130_fd_sc_hd__fill_1
XFILLER_53_429 VPWR VGND VPWR VGND sky130_ef_sc_hd__decap_12
XTAP_TAPCELL_ROW_49_1119 VGND VPWR sky130_fd_sc_hd__tapvpwrvgnd_1
XFILLER_19_673 VPWR VGND VPWR VGND sky130_ef_sc_hd__decap_12
XFILLER_80_226 VPWR VGND VPWR VGND sky130_ef_sc_hd__decap_12
XFILLER_74_790 VPWR VGND VPWR VGND sky130_ef_sc_hd__decap_12
XFILLER_34_643 VGND VGND VPWR VPWR sky130_fd_sc_hd__fill_1
XFILLER_46_492 VPWR VGND VPWR VGND sky130_ef_sc_hd__decap_12
XTAP_TAPCELL_ROW_62_1319 VGND VPWR sky130_fd_sc_hd__tapvpwrvgnd_1
XFILLER_22_805 VGND VGND VPWR VPWR sky130_fd_sc_hd__decap_6
XFILLER_61_473 VGND VGND VPWR VPWR sky130_fd_sc_hd__fill_1
XFILLER_21_337 VGND VGND VPWR VPWR sky130_fd_sc_hd__decap_8
XFILLER_22_849 VPWR VGND VPWR VGND sky130_ef_sc_hd__decap_12
X_1955_ B_reg\[5\] _1219_ VGND VGND VPWR VPWR _1220_ sky130_fd_sc_hd__nand2_1
XTAP_TAPCELL_ROW_32_844 VGND VPWR sky130_fd_sc_hd__tapvpwrvgnd_1
XFILLER_119_225 VPWR VGND VPWR VGND sky130_ef_sc_hd__decap_12
X_1886_ A_reg\[1\] _1153_ _1154_ VGND VGND VPWR VPWR _1156_ sky130_fd_sc_hd__o21a_1
XFILLER_135_729 VPWR VGND VPWR VGND sky130_ef_sc_hd__decap_12
XFILLER_128_781 VPWR VGND VPWR VGND sky130_ef_sc_hd__decap_12
XTAP_TAPCELL_ROW_77_1562 VGND VPWR sky130_fd_sc_hd__tapvpwrvgnd_1
XFILLER_1_709 VPWR VGND VPWR VGND sky130_ef_sc_hd__decap_12
XFILLER_130_401 VPWR VGND VPWR VGND sky130_ef_sc_hd__decap_12
X_2507_ _0224_ _0254_ VGND VGND VPWR VPWR _0255_ sky130_fd_sc_hd__xnor2_1
XFILLER_130_445 VPWR VGND VPWR VGND sky130_ef_sc_hd__decap_12
XFILLER_115_497 VGND VGND VPWR VPWR sky130_fd_sc_hd__decap_6
XANTENNA__1634__X _0912_ VGND VGND VPWR VPWR sky130_fd_sc_hd__diode_2
XTAP_TAPCELL_ROW_90_1773 VGND VPWR sky130_fd_sc_hd__tapvpwrvgnd_1
X_2438_ OpSel_reg\[0\] OpSel_reg\[1\] VGND VGND VPWR VPWR _0188_ sky130_fd_sc_hd__nand2b_4
XFILLER_130_489 VPWR VGND VPWR VGND sky130_ef_sc_hd__decap_12
X_2369_ _0120_ _0122_ _0905_ VGND VGND VPWR VPWR _0123_ sky130_fd_sc_hd__a21oi_1
XFILLER_69_573 VPWR VGND VPWR VGND sky130_ef_sc_hd__decap_12
XTAP_TAPCELL_ROW_108_2061 VGND VPWR sky130_fd_sc_hd__tapvpwrvgnd_1
XFILLER_56_245 VGND VGND VPWR VPWR sky130_fd_sc_hd__decap_6
XFILLER_16_109 VPWR VGND VPWR VGND sky130_ef_sc_hd__decap_12
XFILLER_71_237 VPWR VGND VPWR VGND sky130_ef_sc_hd__decap_12
XTAP_TAPCELL_ROW_121_2272 VGND VPWR sky130_fd_sc_hd__tapvpwrvgnd_1
XTAP_TAPCELL_ROW_121_2261 VGND VPWR sky130_fd_sc_hd__tapvpwrvgnd_1
XFILLER_72_27 VGND VGND VPWR VPWR sky130_fd_sc_hd__fill_1
XFILLER_24_153 VPWR VGND VPWR VGND sky130_ef_sc_hd__decap_12
XFILLER_25_665 VGND VGND VPWR VPWR sky130_fd_sc_hd__decap_6
XFILLER_80_793 VPWR VGND VPWR VGND sky130_ef_sc_hd__decap_12
XANTENNA__2117__S B_reg\[8\] VGND VGND VPWR VPWR sky130_fd_sc_hd__diode_2
XFILLER_9_809 VPWR VGND VPWR VGND sky130_ef_sc_hd__decap_12
XFILLER_40_613 VPWR VGND VPWR VGND sky130_ef_sc_hd__decap_12
XFILLER_138_501 VPWR VGND VPWR VGND sky130_ef_sc_hd__decap_12
XFILLER_24_197 VPWR VGND VPWR VGND sky130_ef_sc_hd__decap_12
XFILLER_138_545 VPWR VGND VPWR VGND sky130_ef_sc_hd__decap_12
XFILLER_138_589 VPWR VGND VPWR VGND sky130_ef_sc_hd__decap_12
XFILLER_125_217 VGND VGND VPWR VPWR sky130_fd_sc_hd__decap_6
XFILLER_115_3 VPWR VGND VPWR VGND sky130_ef_sc_hd__decap_12
XFILLER_140_209 VPWR VGND VPWR VGND sky130_ef_sc_hd__decap_12
XFILLER_133_261 VPWR VGND VPWR VGND sky130_ef_sc_hd__decap_12
XFILLER_97_57 VPWR VGND VPWR VGND sky130_ef_sc_hd__decap_12
XFILLER_79_337 VPWR VGND VPWR VGND sky130_ef_sc_hd__decap_12
XFILLER_153_41 VPWR VGND VPWR VGND sky130_ef_sc_hd__decap_12
XFILLER_94_307 VGND VGND VPWR VPWR sky130_fd_sc_hd__fill_1
XFILLER_0_753 VGND VGND VPWR VPWR sky130_fd_sc_hd__decap_3
XFILLER_153_85 VPWR VGND VPWR VGND sky130_ef_sc_hd__decap_12
XFILLER_102_681 VPWR VGND VPWR VGND sky130_ef_sc_hd__decap_12
XFILLER_88_893 VPWR VGND VPWR VGND sky130_ef_sc_hd__decap_12
XFILLER_48_713 VPWR VGND VPWR VGND sky130_ef_sc_hd__decap_12
XANTENNA_input35_A Start VGND VGND VPWR VPWR sky130_fd_sc_hd__diode_2
XFILLER_0_797 VPWR VGND VPWR VGND sky130_ef_sc_hd__decap_12
XFILLER_48_757 VPWR VGND VPWR VGND sky130_ef_sc_hd__decap_12
XFILLER_47_223 VGND VGND VPWR VPWR sky130_fd_sc_hd__fill_1
XFILLER_90_513 VPWR VGND VPWR VGND sky130_ef_sc_hd__decap_12
XFILLER_63_727 VGND VGND VPWR VPWR sky130_fd_sc_hd__fill_1
XFILLER_62_204 VPWR VGND VPWR VGND sky130_ef_sc_hd__decap_12
XTAP_TAPCELL_ROW_18_616 VGND VPWR sky130_fd_sc_hd__tapvpwrvgnd_1
XFILLER_90_546 VPWR VGND VPWR VGND sky130_ef_sc_hd__decap_12
XANTENNA__1720__A A_reg\[1\] VGND VGND VPWR VPWR sky130_fd_sc_hd__diode_2
XFILLER_16_643 VGND VGND VPWR VPWR sky130_fd_sc_hd__fill_1
XTAP_TAPCELL_ROW_18_627 VGND VPWR sky130_fd_sc_hd__tapvpwrvgnd_1
XFILLER_46_83 VGND VGND VPWR VPWR sky130_fd_sc_hd__fill_1
XFILLER_43_473 VPWR VGND VPWR VGND sky130_ef_sc_hd__decap_12
XTAP_TAPCELL_ROW_44_1038 VGND VPWR sky130_fd_sc_hd__tapvpwrvgnd_1
XFILLER_148_309 VPWR VGND VPWR VGND sky130_ef_sc_hd__decap_12
XTAP_TAPCELL_ROW_139_2555 VGND VPWR sky130_fd_sc_hd__tapvpwrvgnd_1
XFILLER_62_82 VGND VGND VPWR VPWR sky130_fd_sc_hd__fill_2
XFILLER_62_93 VPWR VGND VPWR VGND sky130_ef_sc_hd__decap_12
X_1740_ _1010_ _1011_ A_reg\[12\] VGND VGND VPWR VPWR _1013_ sky130_fd_sc_hd__o21ba_1
XFILLER_7_55 VGND VGND VPWR VPWR sky130_fd_sc_hd__fill_1
XFILLER_12_893 VPWR VGND VPWR VGND sky130_ef_sc_hd__decap_12
XFILLER_30_189 VGND VGND VPWR VPWR sky130_fd_sc_hd__decap_6
XTAP_TAPCELL_ROW_152_2766 VGND VPWR sky130_fd_sc_hd__tapvpwrvgnd_1
XFILLER_117_729 VPWR VGND VPWR VGND sky130_ef_sc_hd__decap_12
X_1671_ _0934_ _0937_ _0946_ VGND VGND VPWR VPWR _0947_ sky130_fd_sc_hd__or3_1
XFILLER_112_401 VPWR VGND VPWR VGND sky130_ef_sc_hd__decap_12
XFILLER_98_613 VPWR VGND VPWR VGND sky130_ef_sc_hd__decap_12
XTAP_TAPCELL_ROW_59_1281 VGND VPWR sky130_fd_sc_hd__tapvpwrvgnd_1
XTAP_TAPCELL_ROW_59_1270 VGND VPWR sky130_fd_sc_hd__tapvpwrvgnd_1
XFILLER_98_657 VPWR VGND VPWR VGND sky130_ef_sc_hd__decap_12
XFILLER_3_591 VGND VGND VPWR VPWR sky130_fd_sc_hd__fill_1
XFILLER_112_445 VPWR VGND VPWR VGND sky130_ef_sc_hd__decap_12
XFILLER_97_167 VGND VGND VPWR VPWR sky130_fd_sc_hd__fill_1
X_3272_ clknet_3_5__leaf_clk _0055_ net36 VGND VGND VPWR VPWR net43 sky130_fd_sc_hd__dfrtp_1
XFILLER_30_3 VPWR VGND VPWR VGND sky130_ef_sc_hd__decap_12
XFILLER_39_702 VGND VGND VPWR VPWR sky130_fd_sc_hd__decap_4
XFILLER_112_489 VPWR VGND VPWR VGND sky130_ef_sc_hd__decap_12
XFILLER_85_329 VGND VGND VPWR VPWR sky130_fd_sc_hd__fill_2
XTAP_TAPCELL_ROW_72_1481 VGND VPWR sky130_fd_sc_hd__tapvpwrvgnd_1
X_2223_ A_reg\[5\] _1478_ VGND VGND VPWR VPWR _1480_ sky130_fd_sc_hd__nand2_1
XFILLER_78_392 VGND VGND VPWR VPWR sky130_fd_sc_hd__decap_8
X_2154_ A_reg\[15\] A_reg\[14\] A_reg\[12\] A_reg\[13\] VGND VGND VPWR VPWR _1411_
+ sky130_fd_sc_hd__a31o_1
XFILLER_38_245 VGND VGND VPWR VPWR sky130_fd_sc_hd__decap_6
XFILLER_66_587 VGND VGND VPWR VPWR sky130_fd_sc_hd__fill_1
XFILLER_54_727 VGND VGND VPWR VPWR sky130_fd_sc_hd__decap_4
XTAP_TAPCELL_ROW_37_925 VGND VPWR sky130_fd_sc_hd__tapvpwrvgnd_1
XFILLER_38_278 VPWR VGND VPWR VGND sky130_ef_sc_hd__decap_12
XFILLER_81_557 VGND VGND VPWR VPWR sky130_fd_sc_hd__decap_3
X_2085_ _1339_ _1344_ VGND VGND VPWR VPWR _1347_ sky130_fd_sc_hd__xnor2_1
XFILLER_54_749 VGND VGND VPWR VPWR sky130_fd_sc_hd__decap_6
XFILLER_62_793 VPWR VGND VPWR VGND sky130_ef_sc_hd__decap_12
XFILLER_22_613 VPWR VGND VPWR VGND sky130_ef_sc_hd__decap_12
XFILLER_22_657 VPWR VGND VPWR VGND sky130_ef_sc_hd__decap_12
XTAP_TAPCELL_ROW_79_1602 VGND VPWR sky130_fd_sc_hd__tapvpwrvgnd_1
X_2987_ _0673_ _0674_ _0672_ VGND VGND VPWR VPWR _0675_ sky130_fd_sc_hd__o21ai_1
XFILLER_21_167 VGND VGND VPWR VPWR sky130_fd_sc_hd__fill_1
X_1938_ B_reg\[8\] _1190_ _1199_ _1198_ _1191_ VGND VGND VPWR VPWR _1203_ sky130_fd_sc_hd__a32o_1
XFILLER_107_217 VGND VGND VPWR VPWR sky130_fd_sc_hd__decap_6
X_1869_ A_reg\[5\] _1138_ VGND VGND VPWR VPWR _1139_ sky130_fd_sc_hd__and2_1
XFILLER_135_559 VGND VGND VPWR VPWR sky130_fd_sc_hd__fill_1
XTAP_TAPCELL_ROW_92_1802 VGND VPWR sky130_fd_sc_hd__tapvpwrvgnd_1
XFILLER_122_209 VPWR VGND VPWR VGND sky130_ef_sc_hd__decap_12
XFILLER_1_517 VPWR VGND VPWR VGND sky130_ef_sc_hd__decap_12
XFILLER_131_721 VGND VGND VPWR VPWR sky130_fd_sc_hd__decap_6
XFILLER_115_261 VPWR VGND VPWR VGND sky130_ef_sc_hd__decap_12
XANTENNA__3262__RESET_B net36 VGND VGND VPWR VPWR sky130_fd_sc_hd__diode_2
XFILLER_131_765 VPWR VGND VPWR VGND sky130_ef_sc_hd__decap_12
XFILLER_130_253 VPWR VGND VPWR VGND sky130_ef_sc_hd__decap_12
XFILLER_103_445 VGND VGND VPWR VPWR sky130_fd_sc_hd__decap_3
XFILLER_85_841 VPWR VGND VPWR VGND sky130_ef_sc_hd__decap_12
XTAP_TAPCELL_ROW_123_2301 VGND VPWR sky130_fd_sc_hd__tapvpwrvgnd_1
XFILLER_123_55 VGND VGND VPWR VPWR sky130_fd_sc_hd__fill_1
XFILLER_83_15 VGND VGND VPWR VPWR sky130_fd_sc_hd__fill_1
XTAP_TAPCELL_ROW_4_399 VGND VPWR sky130_fd_sc_hd__tapvpwrvgnd_1
XTAP_TAPCELL_ROW_4_388 VGND VPWR sky130_fd_sc_hd__tapvpwrvgnd_1
XFILLER_29_267 VPWR VGND VPWR VGND sky130_ef_sc_hd__decap_12
XFILLER_45_727 VGND VGND VPWR VPWR sky130_fd_sc_hd__fill_1
XFILLER_72_579 VGND VGND VPWR VPWR sky130_fd_sc_hd__decap_8
XFILLER_16_53 VPWR VGND VPWR VGND sky130_ef_sc_hd__decap_12
XFILLER_25_473 VPWR VGND VPWR VGND sky130_ef_sc_hd__decap_12
XTAP_TAPCELL_ROW_101_1942 VGND VPWR sky130_fd_sc_hd__tapvpwrvgnd_1
XFILLER_9_617 VPWR VGND VPWR VGND sky130_ef_sc_hd__decap_12
XFILLER_16_97 VPWR VGND VPWR VGND sky130_ef_sc_hd__decap_12
XFILLER_40_421 VPWR VGND VPWR VGND sky130_ef_sc_hd__decap_12
XFILLER_139_821 VPWR VGND VPWR VGND sky130_ef_sc_hd__decap_12
XTAP_TAPCELL_ROW_101_1953 VGND VPWR sky130_fd_sc_hd__tapvpwrvgnd_1
XFILLER_148_41 VPWR VGND VPWR VGND sky130_ef_sc_hd__decap_12
XFILLER_139_865 VPWR VGND VPWR VGND sky130_ef_sc_hd__decap_12
XFILLER_12_189 VGND VGND VPWR VPWR sky130_fd_sc_hd__decap_6
XTAP_TAPCELL_ROW_23_696 VGND VPWR sky130_fd_sc_hd__tapvpwrvgnd_1
XFILLER_32_41 VPWR VGND VPWR VGND sky130_ef_sc_hd__decap_12
XFILLER_32_85 VPWR VGND VPWR VGND sky130_ef_sc_hd__decap_12
XFILLER_148_85 VPWR VGND VPWR VGND sky130_ef_sc_hd__decap_12
XTAP_TAPCELL_ROW_134_2474 VGND VPWR sky130_fd_sc_hd__tapvpwrvgnd_1
XFILLER_153_389 VGND VGND VPWR VPWR sky130_fd_sc_hd__decap_3
XFILLER_141_529 VPWR VGND VPWR VGND sky130_ef_sc_hd__decap_12
XFILLER_5_889 VGND VGND VPWR VPWR sky130_fd_sc_hd__decap_6
XFILLER_4_344 VGND VGND VPWR VPWR sky130_fd_sc_hd__fill_1
XFILLER_134_581 VGND VGND VPWR VPWR sky130_fd_sc_hd__decap_6
XFILLER_110_905 VGND VGND VPWR VPWR sky130_fd_sc_hd__decap_4
XFILLER_94_104 VPWR VGND VPWR VGND sky130_ef_sc_hd__decap_12
XFILLER_88_690 VGND VGND VPWR VPWR sky130_fd_sc_hd__decap_8
XFILLER_75_373 VPWR VGND VPWR VGND sky130_ef_sc_hd__decap_12
XFILLER_48_587 VGND VGND VPWR VPWR sky130_fd_sc_hd__fill_1
XFILLER_91_833 VGND VGND VPWR VPWR sky130_fd_sc_hd__decap_6
XFILLER_90_321 VPWR VGND VPWR VGND sky130_ef_sc_hd__decap_12
XANTENNA_clkload0_A clknet_3_0__leaf_clk VGND VGND VPWR VPWR sky130_fd_sc_hd__diode_2
XFILLER_36_749 VGND VGND VPWR VPWR sky130_fd_sc_hd__decap_6
XFILLER_91_877 VPWR VGND VPWR VGND sky130_ef_sc_hd__decap_12
X_2910_ _0585_ _0596_ _0597_ VGND VGND VPWR VPWR _0598_ sky130_fd_sc_hd__nand3_1
XFILLER_73_92 VPWR VGND VPWR VGND sky130_ef_sc_hd__decap_12
XFILLER_73_81 VGND VGND VPWR VPWR sky130_fd_sc_hd__fill_1
XFILLER_44_771 VGND VGND VPWR VPWR sky130_fd_sc_hd__decap_6
XFILLER_44_793 VPWR VGND VPWR VGND sky130_ef_sc_hd__decap_12
XFILLER_149_629 VPWR VGND VPWR VGND sky130_ef_sc_hd__decap_12
XFILLER_43_281 VPWR VGND VPWR VGND sky130_ef_sc_hd__decap_12
XFILLER_148_139 VGND VGND VPWR VPWR sky130_fd_sc_hd__fill_1
X_2841_ net14 A_reg\[7\] _0383_ VGND VGND VPWR VPWR _0064_ sky130_fd_sc_hd__mux2_1
X_2772_ _0510_ _0511_ VGND VGND VPWR VPWR _0512_ sky130_fd_sc_hd__nor2_1
XFILLER_78_3 VPWR VGND VPWR VGND sky130_ef_sc_hd__decap_12
XFILLER_144_301 VGND VGND VPWR VPWR sky130_fd_sc_hd__decap_6
X_1723_ A_reg\[0\] _0995_ VGND VGND VPWR VPWR _0999_ sky130_fd_sc_hd__or2_1
XFILLER_144_345 VPWR VGND VPWR VGND sky130_ef_sc_hd__decap_12
XFILLER_117_559 VGND VGND VPWR VPWR sky130_fd_sc_hd__fill_1
XFILLER_7_193 VPWR VGND VPWR VGND sky130_ef_sc_hd__decap_12
XFILLER_104_209 VPWR VGND VPWR VGND sky130_ef_sc_hd__decap_12
XTAP_TAPCELL_ROW_74_1521 VGND VPWR sky130_fd_sc_hd__tapvpwrvgnd_1
XTAP_TAPCELL_ROW_74_1510 VGND VPWR sky130_fd_sc_hd__tapvpwrvgnd_1
X_1654_ A_reg\[11\] _0914_ _0919_ _0920_ _0929_ VGND VGND VPWR VPWR _0930_ sky130_fd_sc_hd__a41o_1
XFILLER_144_389 VPWR VGND VPWR VGND sky130_ef_sc_hd__decap_12
XFILLER_113_721 VGND VGND VPWR VPWR sky130_fd_sc_hd__decap_6
XANTENNA__2699__B2 a_r3\[1\] VGND VGND VPWR VPWR sky130_fd_sc_hd__diode_2
XANTENNA__2699__A1 a_r3\[0\] VGND VGND VPWR VPWR sky130_fd_sc_hd__diode_2
XANTENNA__1625__A B_reg\[5\] VGND VGND VPWR VPWR sky130_fd_sc_hd__diode_2
XFILLER_113_765 VPWR VGND VPWR VGND sky130_ef_sc_hd__decap_12
XFILLER_112_253 VPWR VGND VPWR VGND sky130_ef_sc_hd__decap_12
X_3255_ clknet_3_6__leaf_clk _0038_ net36 VGND VGND VPWR VPWR u_crt.r3\[1\] sky130_fd_sc_hd__dfrtp_2
XFILLER_85_137 VGND VGND VPWR VPWR sky130_fd_sc_hd__decap_8
XFILLER_67_841 VPWR VGND VPWR VGND sky130_ef_sc_hd__decap_12
XPHY_EDGE_ROW_13_Left_167 VGND VGND VPWR VPWR sky130_fd_sc_hd__decap_3
X_2206_ _0892_ _1462_ VGND VGND VPWR VPWR _1463_ sky130_fd_sc_hd__xnor2_1
XFILLER_82_811 VGND VGND VPWR VPWR sky130_fd_sc_hd__fill_1
XFILLER_27_727 VGND VGND VPWR VPWR sky130_fd_sc_hd__fill_1
X_3186_ _0808_ _0867_ VGND VGND VPWR VPWR _0870_ sky130_fd_sc_hd__or2_1
XFILLER_94_693 VGND VGND VPWR VPWR sky130_fd_sc_hd__decap_6
XFILLER_93_181 VPWR VGND VPWR VGND sky130_ef_sc_hd__decap_12
X_2137_ _0908_ _1395_ VGND VGND VPWR VPWR _1396_ sky130_fd_sc_hd__nor2_1
XTAP_TAPCELL_ROW_1_347 VGND VPWR sky130_fd_sc_hd__tapvpwrvgnd_1
X_2068_ _1327_ _1329_ _1324_ VGND VGND VPWR VPWR _1330_ sky130_fd_sc_hd__a21oi_1
XTAP_TAPCELL_ROW_85_1694 VGND VPWR sky130_fd_sc_hd__tapvpwrvgnd_1
XPHY_EDGE_ROW_22_Left_176 VGND VGND VPWR VPWR sky130_fd_sc_hd__decap_3
XFILLER_147_161 VGND VGND VPWR VPWR sky130_fd_sc_hd__decap_6
XFILLER_136_813 VPWR VGND VPWR VGND sky130_ef_sc_hd__decap_12
XTAP_TAPCELL_ROW_20_644 VGND VPWR sky130_fd_sc_hd__tapvpwrvgnd_1
XTAP_TAPCELL_ROW_20_655 VGND VPWR sky130_fd_sc_hd__tapvpwrvgnd_1
XTAP_TAPCELL_ROW_116_2193 VGND VPWR sky130_fd_sc_hd__tapvpwrvgnd_1
XTAP_TAPCELL_ROW_116_2182 VGND VPWR sky130_fd_sc_hd__tapvpwrvgnd_1
XFILLER_78_15 VPWR VGND VPWR VGND sky130_ef_sc_hd__decap_12
XFILLER_123_529 VPWR VGND VPWR VGND sky130_ef_sc_hd__decap_12
XFILLER_118_77 VGND VGND VPWR VPWR sky130_fd_sc_hd__decap_6
XFILLER_116_581 VGND VGND VPWR VPWR sky130_fd_sc_hd__decap_6
XFILLER_2_837 VPWR VGND VPWR VGND sky130_ef_sc_hd__decap_12
XTAP_TAPCELL_ROW_9_469 VGND VPWR sky130_fd_sc_hd__tapvpwrvgnd_1
XPHY_EDGE_ROW_31_Left_185 VGND VGND VPWR VPWR sky130_fd_sc_hd__decap_3
XFILLER_131_573 VPWR VGND VPWR VGND sky130_ef_sc_hd__decap_12
XFILLER_49_329 VGND VGND VPWR VPWR sky130_fd_sc_hd__decap_6
XFILLER_134_65 VPWR VGND VPWR VGND sky130_ef_sc_hd__decap_12
XFILLER_76_137 VGND VGND VPWR VPWR sky130_fd_sc_hd__decap_3
XFILLER_58_852 VPWR VGND VPWR VGND sky130_ef_sc_hd__decap_12
XFILLER_94_58 VGND VGND VPWR VPWR sky130_fd_sc_hd__decap_3
XFILLER_92_619 VPWR VGND VPWR VGND sky130_ef_sc_hd__decap_12
XFILLER_85_693 VGND VGND VPWR VPWR sky130_fd_sc_hd__decap_3
XFILLER_73_833 VGND VGND VPWR VPWR sky130_fd_sc_hd__decap_6
XFILLER_72_321 VPWR VGND VPWR VGND sky130_ef_sc_hd__decap_12
XFILLER_57_373 VPWR VGND VPWR VGND sky130_ef_sc_hd__decap_12
XFILLER_17_237 VPWR VGND VPWR VGND sky130_ef_sc_hd__decap_12
XFILLER_18_749 VGND VGND VPWR VPWR sky130_fd_sc_hd__decap_6
XFILLER_150_53 VPWR VGND VPWR VGND sky130_ef_sc_hd__decap_12
XFILLER_73_877 VPWR VGND VPWR VGND sky130_ef_sc_hd__decap_12
XFILLER_72_365 VGND VGND VPWR VPWR sky130_fd_sc_hd__decap_8
XFILLER_150_97 VPWR VGND VPWR VGND sky130_ef_sc_hd__decap_12
XFILLER_26_793 VPWR VGND VPWR VGND sky130_ef_sc_hd__decap_12
XTAP_TAPCELL_ROW_28_777 VGND VPWR sky130_fd_sc_hd__tapvpwrvgnd_1
XFILLER_13_443 VGND VGND VPWR VPWR sky130_fd_sc_hd__decap_4
XFILLER_25_281 VPWR VGND VPWR VGND sky130_ef_sc_hd__decap_12
XPHY_EDGE_ROW_40_Left_194 VGND VGND VPWR VPWR sky130_fd_sc_hd__decap_3
XTAP_TAPCELL_ROW_136_2503 VGND VPWR sky130_fd_sc_hd__tapvpwrvgnd_1
XFILLER_13_476 VPWR VGND VPWR VGND sky130_ef_sc_hd__decap_12
XFILLER_41_785 VGND VGND VPWR VPWR sky130_fd_sc_hd__decap_3
XFILLER_43_51 VGND VGND VPWR VPWR sky130_fd_sc_hd__decap_4
XTAP_TAPCELL_ROW_136_2514 VGND VPWR sky130_fd_sc_hd__tapvpwrvgnd_1
XFILLER_9_447 VGND VGND VPWR VPWR sky130_fd_sc_hd__fill_1
XFILLER_139_673 VPWR VGND VPWR VGND sky130_ef_sc_hd__decap_12
XFILLER_126_301 VGND VGND VPWR VPWR sky130_fd_sc_hd__decap_6
XFILLER_126_345 VPWR VGND VPWR VGND sky130_ef_sc_hd__decap_12
XFILLER_153_153 VPWR VGND VPWR VGND sky130_ef_sc_hd__decap_12
XFILLER_142_805 VGND VGND VPWR VPWR sky130_fd_sc_hd__decap_6
XFILLER_57_8 VGND VGND VPWR VPWR sky130_fd_sc_hd__decap_3
XFILLER_4_141 VPWR VGND VPWR VGND sky130_ef_sc_hd__decap_12
XFILLER_153_197 VPWR VGND VPWR VGND sky130_ef_sc_hd__decap_12
XFILLER_142_849 VPWR VGND VPWR VGND sky130_ef_sc_hd__decap_12
XFILLER_141_337 VPWR VGND VPWR VGND sky130_ef_sc_hd__decap_12
XFILLER_126_389 VPWR VGND VPWR VGND sky130_ef_sc_hd__decap_12
XFILLER_5_697 VPWR VGND VPWR VGND sky130_ef_sc_hd__decap_12
XFILLER_150_893 VPWR VGND VPWR VGND sky130_ef_sc_hd__decap_12
XFILLER_110_713 VPWR VGND VPWR VGND sky130_ef_sc_hd__decap_12
XFILLER_95_413 VGND VGND VPWR VPWR sky130_fd_sc_hd__fill_2
XFILLER_110_757 VPWR VGND VPWR VGND sky130_ef_sc_hd__decap_12
XFILLER_67_137 VPWR VGND VPWR VGND sky130_ef_sc_hd__decap_12
XTAP_TAPCELL_ROW_52_1159 VGND VPWR sky130_fd_sc_hd__tapvpwrvgnd_1
XFILLER_49_841 VGND VGND VPWR VPWR sky130_fd_sc_hd__decap_6
XTAP_TAPCELL_ROW_147_2687 VGND VPWR sky130_fd_sc_hd__tapvpwrvgnd_1
XTAP_TAPCELL_ROW_147_2676 VGND VPWR sky130_fd_sc_hd__tapvpwrvgnd_1
XFILLER_76_660 VGND VGND VPWR VPWR sky130_fd_sc_hd__fill_2
XFILLER_64_811 VGND VGND VPWR VPWR sky130_fd_sc_hd__fill_1
X_3040_ _0714_ _0716_ _0717_ VGND VGND VPWR VPWR _0728_ sky130_fd_sc_hd__or3_1
XFILLER_48_362 VGND VGND VPWR VPWR sky130_fd_sc_hd__fill_2
XANTENNA__2853__A1 B_reg\[3\] VGND VGND VPWR VPWR sky130_fd_sc_hd__diode_2
XFILLER_75_181 VPWR VGND VPWR VGND sky130_ef_sc_hd__decap_12
XFILLER_36_524 VGND VGND VPWR VPWR sky130_fd_sc_hd__decap_8
XFILLER_91_641 VPWR VGND VPWR VGND sky130_ef_sc_hd__decap_12
XFILLER_51_505 VPWR VGND VPWR VGND sky130_ef_sc_hd__decap_12
XFILLER_36_557 VGND VGND VPWR VPWR sky130_fd_sc_hd__fill_2
XFILLER_91_685 VPWR VGND VPWR VGND sky130_ef_sc_hd__decap_12
XFILLER_90_162 VPWR VGND VPWR VGND sky130_ef_sc_hd__decap_12
XANTENNA__2723__B b_r3\[3\] VGND VGND VPWR VPWR sky130_fd_sc_hd__diode_2
X_2824_ net50 X_crt\[6\] _0553_ VGND VGND VPWR VPWR _0047_ sky130_fd_sc_hd__mux2_1
XFILLER_31_273 VGND VGND VPWR VPWR sky130_fd_sc_hd__decap_6
XFILLER_136_109 VPWR VGND VPWR VGND sky130_ef_sc_hd__decap_12
XFILLER_129_161 VGND VGND VPWR VPWR sky130_fd_sc_hd__decap_6
XFILLER_118_813 VPWR VGND VPWR VGND sky130_ef_sc_hd__decap_12
X_2755_ _0476_ _0488_ _0494_ VGND VGND VPWR VPWR _0495_ sky130_fd_sc_hd__a21oi_1
XFILLER_145_665 VGND VGND VPWR VPWR sky130_fd_sc_hd__decap_6
XFILLER_144_153 VPWR VGND VPWR VGND sky130_ef_sc_hd__decap_12
X_2686_ _0411_ _0413_ VGND VGND VPWR VPWR _0426_ sky130_fd_sc_hd__or2_1
X_1706_ A_reg\[3\] _0977_ VGND VGND VPWR VPWR _0982_ sky130_fd_sc_hd__nor2_1
XFILLER_144_197 VPWR VGND VPWR VGND sky130_ef_sc_hd__decap_12
XFILLER_105_529 VPWR VGND VPWR VGND sky130_ef_sc_hd__decap_12
X_1637_ A_reg\[15\] A_reg\[14\] VGND VGND VPWR VPWR _0913_ sky130_fd_sc_hd__nand2_1
XFILLER_99_741 VPWR VGND VPWR VGND sky130_ef_sc_hd__decap_12
XFILLER_113_573 VPWR VGND VPWR VGND sky130_ef_sc_hd__decap_12
XFILLER_99_785 VPWR VGND VPWR VGND sky130_ef_sc_hd__decap_12
XFILLER_100_201 VGND VGND VPWR VPWR sky130_fd_sc_hd__fill_1
XFILLER_86_413 VGND VGND VPWR VPWR sky130_fd_sc_hd__decap_6
X_3307_ clknet_3_7__leaf_clk _0090_ net36 VGND VGND VPWR VPWR X_crt\[1\] sky130_fd_sc_hd__dfrtp_1
XFILLER_48_29 VGND VGND VPWR VPWR sky130_fd_sc_hd__decap_6
XTAP_TAPCELL_ROW_6_428 VGND VPWR sky130_fd_sc_hd__tapvpwrvgnd_1
XFILLER_86_457 VPWR VGND VPWR VGND sky130_ef_sc_hd__decap_12
XFILLER_58_126 VPWR VGND VPWR VGND sky130_ef_sc_hd__decap_12
X_3238_ clknet_3_3__leaf_clk _0025_ net36 VGND VGND VPWR VPWR b_r3\[2\] sky130_fd_sc_hd__dfrtp_4
XFILLER_74_619 VPWR VGND VPWR VGND sky130_ef_sc_hd__decap_12
XFILLER_100_289 VPWR VGND VPWR VGND sky130_ef_sc_hd__decap_12
XTAP_TAPCELL_ROW_87_1723 VGND VPWR sky130_fd_sc_hd__tapvpwrvgnd_1
XFILLER_66_181 VGND VGND VPWR VPWR sky130_fd_sc_hd__fill_1
X_3169_ _0855_ _0856_ VGND VGND VPWR VPWR _0857_ sky130_fd_sc_hd__or2_1
XFILLER_55_822 VPWR VGND VPWR VGND sky130_ef_sc_hd__decap_12
XANTENNA__2844__A1 A_reg\[10\] VGND VGND VPWR VPWR sky130_fd_sc_hd__diode_2
XANTENNA__2186__A A_reg\[9\] VGND VGND VPWR VPWR sky130_fd_sc_hd__diode_2
XFILLER_39_373 VPWR VGND VPWR VGND sky130_ef_sc_hd__decap_12
XPHY_EDGE_ROW_126_Right_126 VGND VGND VPWR VPWR sky130_fd_sc_hd__decap_3
XFILLER_27_546 VPWR VGND VPWR VGND sky130_ef_sc_hd__decap_12
XFILLER_70_825 VPWR VGND VPWR VGND sky130_ef_sc_hd__decap_12
XTAP_TAPCELL_ROW_25_725 VGND VPWR sky130_fd_sc_hd__tapvpwrvgnd_1
XFILLER_70_869 VPWR VGND VPWR VGND sky130_ef_sc_hd__decap_12
XFILLER_54_398 VPWR VGND VPWR VGND sky130_ef_sc_hd__decap_12
XFILLER_23_741 VPWR VGND VPWR VGND sky130_ef_sc_hd__decap_12
XTAP_TAPCELL_ROW_25_736 VGND VPWR sky130_fd_sc_hd__tapvpwrvgnd_1
XFILLER_80_27 VGND VGND VPWR VPWR sky130_fd_sc_hd__fill_1
XFILLER_10_402 VPWR VGND VPWR VGND sky130_ef_sc_hd__decap_12
XFILLER_23_785 VPWR VGND VPWR VGND sky130_ef_sc_hd__decap_12
XTAP_TAPCELL_ROW_118_2222 VGND VPWR sky130_fd_sc_hd__tapvpwrvgnd_1
XFILLER_108_301 VGND VGND VPWR VPWR sky130_fd_sc_hd__decap_6
XFILLER_136_643 VGND VGND VPWR VPWR sky130_fd_sc_hd__fill_1
XTAP_TAPCELL_ROW_131_2433 VGND VPWR sky130_fd_sc_hd__tapvpwrvgnd_1
XTAP_TAPCELL_ROW_131_2422 VGND VPWR sky130_fd_sc_hd__tapvpwrvgnd_1
XFILLER_124_805 VGND VGND VPWR VPWR sky130_fd_sc_hd__decap_6
XFILLER_108_345 VPWR VGND VPWR VGND sky130_ef_sc_hd__decap_12
XTAP_TAPCELL_ROW_98_1896 VGND VPWR sky130_fd_sc_hd__tapvpwrvgnd_1
XFILLER_124_849 VPWR VGND VPWR VGND sky130_ef_sc_hd__decap_12
XFILLER_123_337 VPWR VGND VPWR VGND sky130_ef_sc_hd__decap_12
XFILLER_89_69 VGND VGND VPWR VPWR sky130_fd_sc_hd__decap_3
XFILLER_89_240 VGND VGND VPWR VPWR sky130_fd_sc_hd__decap_3
XFILLER_8_3 VPWR VGND VPWR VGND sky130_ef_sc_hd__decap_12
XANTENNA__3271__CLK clknet_3_5__leaf_clk VGND VGND VPWR VPWR sky130_fd_sc_hd__diode_2
XFILLER_2_645 VPWR VGND VPWR VGND sky130_ef_sc_hd__decap_12
XFILLER_1_111 VGND VGND VPWR VPWR sky130_fd_sc_hd__fill_1
XFILLER_150_189 VGND VGND VPWR VPWR sky130_fd_sc_hd__decap_6
XFILLER_132_893 VPWR VGND VPWR VGND sky130_ef_sc_hd__decap_12
XFILLER_49_137 VPWR VGND VPWR VGND sky130_ef_sc_hd__decap_12
XTAP_TAPCELL_ROW_129_2395 VGND VPWR sky130_fd_sc_hd__tapvpwrvgnd_1
XANTENNA__2835__A1 A_reg\[1\] VGND VGND VPWR VPWR sky130_fd_sc_hd__diode_2
XFILLER_64_129 VGND VGND VPWR VPWR sky130_fd_sc_hd__fill_2
XFILLER_58_682 VPWR VGND VPWR VGND sky130_ef_sc_hd__decap_12
XFILLER_18_513 VPWR VGND VPWR VGND sky130_ef_sc_hd__decap_12
XFILLER_73_641 VPWR VGND VPWR VGND sky130_ef_sc_hd__decap_12
XFILLER_57_181 VGND VGND VPWR VPWR sky130_fd_sc_hd__fill_2
XFILLER_18_557 VPWR VGND VPWR VGND sky130_ef_sc_hd__decap_12
XFILLER_73_685 VPWR VGND VPWR VGND sky130_ef_sc_hd__decap_12
XFILLER_72_173 VGND VGND VPWR VPWR sky130_fd_sc_hd__decap_6
XFILLER_33_527 VPWR VGND VPWR VGND sky130_ef_sc_hd__decap_12
XFILLER_72_184 VGND VGND VPWR VPWR sky130_fd_sc_hd__fill_2
XFILLER_54_83 VGND VGND VPWR VPWR sky130_fd_sc_hd__fill_1
XFILLER_118_109 VPWR VGND VPWR VGND sky130_ef_sc_hd__decap_12
XFILLER_70_93 VPWR VGND VPWR VGND sky130_ef_sc_hd__decap_12
XFILLER_127_665 VGND VGND VPWR VPWR sky130_fd_sc_hd__decap_6
XFILLER_126_153 VPWR VGND VPWR VGND sky130_ef_sc_hd__decap_12
X_2540_ _0286_ _0287_ VGND VGND VPWR VPWR _0288_ sky130_fd_sc_hd__nand2_1
XFILLER_142_613 VPWR VGND VPWR VGND sky130_ef_sc_hd__decap_12
X_2471_ OpSel_reg\[0\] b_r1\[0\] _0186_ _0218_ VGND VGND VPWR VPWR _0219_ sky130_fd_sc_hd__o211a_1
XFILLER_5_461 VPWR VGND VPWR VGND sky130_ef_sc_hd__decap_12
XTAP_TAPCELL_ROW_149_2716 VGND VPWR sky130_fd_sc_hd__tapvpwrvgnd_1
XFILLER_142_657 VPWR VGND VPWR VGND sky130_ef_sc_hd__decap_12
XFILLER_126_197 VPWR VGND VPWR VGND sky130_ef_sc_hd__decap_12
XFILLER_141_167 VGND VGND VPWR VPWR sky130_fd_sc_hd__fill_1
XFILLER_68_413 VGND VGND VPWR VPWR sky130_fd_sc_hd__fill_2
XFILLER_96_755 VGND VGND VPWR VPWR sky130_fd_sc_hd__fill_1
XFILLER_95_221 VGND VGND VPWR VPWR sky130_fd_sc_hd__decap_3
XFILLER_83_405 VPWR VGND VPWR VGND sky130_ef_sc_hd__decap_12
XFILLER_110_587 VGND VGND VPWR VPWR sky130_fd_sc_hd__fill_1
XFILLER_83_449 VPWR VGND VPWR VGND sky130_ef_sc_hd__decap_12
XTAP_TAPCELL_ROW_69_1431 VGND VPWR sky130_fd_sc_hd__tapvpwrvgnd_1
X_3023_ _0708_ _0709_ VGND VGND VPWR VPWR _0711_ sky130_fd_sc_hd__xor2_1
XFILLER_49_693 VGND VGND VPWR VPWR sky130_fd_sc_hd__fill_1
XFILLER_37_833 VGND VGND VPWR VPWR sky130_fd_sc_hd__decap_6
XTAP_TAPCELL_ROW_69_1442 VGND VPWR sky130_fd_sc_hd__tapvpwrvgnd_1
XFILLER_36_321 VPWR VGND VPWR VGND sky130_ef_sc_hd__decap_12
XFILLER_37_877 VPWR VGND VPWR VGND sky130_ef_sc_hd__decap_12
XFILLER_63_151 VPWR VGND VPWR VGND sky130_ef_sc_hd__decap_12
XFILLER_36_365 VPWR VGND VPWR VGND sky130_ef_sc_hd__decap_12
XANTENNA__2039__C1 B_reg\[6\] VGND VGND VPWR VPWR sky130_fd_sc_hd__diode_2
XTAP_TAPCELL_ROW_82_1642 VGND VPWR sky130_fd_sc_hd__tapvpwrvgnd_1
XFILLER_52_869 VGND VGND VPWR VPWR sky130_fd_sc_hd__decap_8
XFILLER_51_368 VPWR VGND VPWR VGND sky130_ef_sc_hd__decap_12
XFILLER_149_223 VGND VGND VPWR VPWR sky130_fd_sc_hd__fill_1
XFILLER_137_429 VPWR VGND VPWR VGND sky130_ef_sc_hd__decap_12
XFILLER_20_755 VGND VGND VPWR VPWR sky130_fd_sc_hd__fill_1
XFILLER_118_643 VGND VGND VPWR VPWR sky130_fd_sc_hd__fill_1
X_2807_ _0534_ _0545_ VGND VGND VPWR VPWR _0546_ sky130_fd_sc_hd__xor2_1
XANTENNA__3294__CLK clknet_3_2__leaf_clk VGND VGND VPWR VPWR sky130_fd_sc_hd__diode_2
X_2738_ _0465_ _0468_ _0471_ _0472_ VGND VGND VPWR VPWR _0478_ sky130_fd_sc_hd__o211a_1
XFILLER_106_805 VGND VGND VPWR VPWR sky130_fd_sc_hd__decap_6
XFILLER_145_473 VPWR VGND VPWR VGND sky130_ef_sc_hd__decap_12
XTAP_TAPCELL_ROW_113_2141 VGND VPWR sky130_fd_sc_hd__tapvpwrvgnd_1
XFILLER_106_849 VPWR VGND VPWR VGND sky130_ef_sc_hd__decap_12
XFILLER_105_337 VPWR VGND VPWR VGND sky130_ef_sc_hd__decap_12
X_2669_ _0394_ _0408_ VGND VGND VPWR VPWR _0409_ sky130_fd_sc_hd__and2_1
XFILLER_120_307 VGND VGND VPWR VPWR sky130_fd_sc_hd__fill_1
XFILLER_99_571 VPWR VGND VPWR VGND sky130_ef_sc_hd__decap_12
XFILLER_132_189 VGND VGND VPWR VPWR sky130_fd_sc_hd__decap_6
XFILLER_114_893 VPWR VGND VPWR VGND sky130_ef_sc_hd__decap_12
XFILLER_86_221 VPWR VGND VPWR VGND sky130_ef_sc_hd__decap_12
XANTENNA__1813__A A_reg\[2\] VGND VGND VPWR VPWR sky130_fd_sc_hd__diode_2
XFILLER_87_777 VGND VGND VPWR VPWR sky130_fd_sc_hd__decap_6
XFILLER_101_598 VPWR VGND VPWR VGND sky130_ef_sc_hd__decap_12
XFILLER_28_811 VGND VGND VPWR VPWR sky130_fd_sc_hd__fill_1
XFILLER_90_909 VGND VGND VPWR VPWR sky130_fd_sc_hd__fill_1
XFILLER_39_181 VPWR VGND VPWR VGND sky130_ef_sc_hd__decap_12
XFILLER_131_55 VGND VGND VPWR VPWR sky130_fd_sc_hd__fill_1
XFILLER_55_685 VPWR VGND VPWR VGND sky130_ef_sc_hd__decap_12
XFILLER_15_505 VPWR VGND VPWR VGND sky130_ef_sc_hd__decap_12
XFILLER_43_825 VGND VGND VPWR VPWR sky130_fd_sc_hd__fill_1
XFILLER_145_3 VPWR VGND VPWR VGND sky130_ef_sc_hd__decap_12
XFILLER_70_699 VGND VGND VPWR VPWR sky130_fd_sc_hd__fill_1
XFILLER_24_53 VPWR VGND VPWR VGND sky130_ef_sc_hd__decap_12
XFILLER_10_221 VPWR VGND VPWR VGND sky130_ef_sc_hd__decap_12
XFILLER_24_97 VPWR VGND VPWR VGND sky130_ef_sc_hd__decap_12
XFILLER_10_265 VPWR VGND VPWR VGND sky130_ef_sc_hd__decap_12
XFILLER_11_777 VGND VGND VPWR VPWR sky130_fd_sc_hd__decap_6
XFILLER_109_665 VGND VGND VPWR VPWR sky130_fd_sc_hd__decap_6
XFILLER_40_41 VPWR VGND VPWR VGND sky130_ef_sc_hd__decap_12
XFILLER_124_613 VPWR VGND VPWR VGND sky130_ef_sc_hd__decap_12
XFILLER_108_153 VPWR VGND VPWR VGND sky130_ef_sc_hd__decap_12
XFILLER_40_85 VPWR VGND VPWR VGND sky130_ef_sc_hd__decap_12
XFILLER_124_657 VPWR VGND VPWR VGND sky130_ef_sc_hd__decap_12
XFILLER_108_197 VPWR VGND VPWR VGND sky130_ef_sc_hd__decap_12
XFILLER_123_167 VGND VGND VPWR VPWR sky130_fd_sc_hd__fill_1
XFILLER_111_329 VGND VGND VPWR VPWR sky130_fd_sc_hd__decap_6
XFILLER_78_744 VPWR VGND VPWR VGND sky130_ef_sc_hd__decap_12
XFILLER_77_243 VGND VGND VPWR VPWR sky130_fd_sc_hd__fill_1
XFILLER_65_405 VPWR VGND VPWR VGND sky130_ef_sc_hd__decap_12
XANTENNA__1723__A A_reg\[0\] VGND VGND VPWR VPWR sky130_fd_sc_hd__diode_2
XTAP_TAPCELL_ROW_144_2635 VGND VPWR sky130_fd_sc_hd__tapvpwrvgnd_1
XFILLER_19_833 VGND VGND VPWR VPWR sky130_fd_sc_hd__decap_6
XFILLER_81_909 VGND VGND VPWR VPWR sky130_fd_sc_hd__fill_1
XFILLER_65_449 VGND VGND VPWR VPWR sky130_fd_sc_hd__fill_2
XFILLER_1_57 VPWR VGND VPWR VGND sky130_ef_sc_hd__decap_12
XFILLER_18_321 VPWR VGND VPWR VGND sky130_ef_sc_hd__decap_12
XFILLER_80_419 VGND VGND VPWR VPWR sky130_fd_sc_hd__fill_1
XFILLER_18_365 VGND VGND VPWR VPWR sky130_fd_sc_hd__decap_3
XFILLER_19_877 VPWR VGND VPWR VGND sky130_ef_sc_hd__decap_12
XFILLER_34_825 VPWR VGND VPWR VGND sky130_ef_sc_hd__decap_12
XFILLER_60_121 VGND VGND VPWR VPWR sky130_fd_sc_hd__decap_4
XFILLER_33_324 VPWR VGND VPWR VGND sky130_ef_sc_hd__decap_12
XFILLER_34_869 VPWR VGND VPWR VGND sky130_ef_sc_hd__decap_12
XTAP_TAPCELL_ROW_64_1361 VGND VPWR sky130_fd_sc_hd__tapvpwrvgnd_1
XTAP_TAPCELL_ROW_64_1350 VGND VPWR sky130_fd_sc_hd__tapvpwrvgnd_1
XFILLER_60_165 VPWR VGND VPWR VGND sky130_ef_sc_hd__decap_12
XFILLER_81_81 VPWR VGND VPWR VGND sky130_ef_sc_hd__decap_12
X_1971_ _1223_ _1235_ VGND VGND VPWR VPWR _1236_ sky130_fd_sc_hd__xnor2_1
XTAP_TAPCELL_ROW_16_588 VGND VPWR sky130_fd_sc_hd__tapvpwrvgnd_1
XFILLER_147_727 VGND VGND VPWR VPWR sky130_fd_sc_hd__fill_1
XFILLER_119_429 VPWR VGND VPWR VGND sky130_ef_sc_hd__decap_12
XFILLER_127_473 VPWR VGND VPWR VGND sky130_ef_sc_hd__decap_12
XANTENNA__2744__B1 _0187_ VGND VGND VPWR VPWR sky130_fd_sc_hd__diode_2
XFILLER_6_781 VPWR VGND VPWR VGND sky130_ef_sc_hd__decap_12
X_2523_ _0224_ _0254_ _0264_ VGND VGND VPWR VPWR _0271_ sky130_fd_sc_hd__a21oi_1
XFILLER_142_421 VPWR VGND VPWR VGND sky130_ef_sc_hd__decap_12
XFILLER_102_307 VGND VGND VPWR VPWR sky130_fd_sc_hd__fill_1
X_2454_ _0198_ _0199_ _0187_ _0197_ VGND VGND VPWR VPWR _0204_ sky130_fd_sc_hd__a211o_1
XFILLER_114_189 VGND VGND VPWR VPWR sky130_fd_sc_hd__decap_6
XFILLER_111_841 VPWR VGND VPWR VGND sky130_ef_sc_hd__decap_12
X_2385_ _0907_ _0136_ _0137_ VGND VGND VPWR VPWR _0139_ sky130_fd_sc_hd__or3_1
XFILLER_69_777 VGND VGND VPWR VPWR sky130_fd_sc_hd__decap_6
XFILLER_68_265 VPWR VGND VPWR VGND sky130_ef_sc_hd__decap_12
XFILLER_68_243 VGND VGND VPWR VPWR sky130_fd_sc_hd__decap_8
XANTENNA__1633__A _0911_ VGND VGND VPWR VPWR sky130_fd_sc_hd__diode_2
Xinput1 A_in[0] VGND VGND VPWR VPWR net1 sky130_fd_sc_hd__buf_1
XFILLER_84_769 VPWR VGND VPWR VGND sky130_ef_sc_hd__decap_12
XFILLER_72_909 VGND VGND VPWR VPWR sky130_fd_sc_hd__fill_1
XFILLER_37_641 VPWR VGND VPWR VGND sky130_ef_sc_hd__decap_12
XFILLER_83_279 VGND VGND VPWR VPWR sky130_fd_sc_hd__fill_1
X_3006_ _0673_ _0674_ VGND VGND VPWR VPWR _0694_ sky130_fd_sc_hd__xor2_1
XANTENNA__3287__RESET_B net36 VGND VGND VPWR VPWR sky130_fd_sc_hd__diode_2
XFILLER_37_685 VPWR VGND VPWR VGND sky130_ef_sc_hd__decap_12
XFILLER_51_110 VGND VGND VPWR VPWR sky130_fd_sc_hd__fill_2
XFILLER_36_195 VGND VGND VPWR VPWR sky130_fd_sc_hd__fill_1
XANTENNA__3216__RESET_B net36 VGND VGND VPWR VPWR sky130_fd_sc_hd__diode_2
XFILLER_52_677 VPWR VGND VPWR VGND sky130_ef_sc_hd__decap_12
XFILLER_101_69 VPWR VGND VPWR VGND sky130_ef_sc_hd__decap_12
XFILLER_33_880 VGND VGND VPWR VPWR sky130_fd_sc_hd__decap_4
XTAP_TAPCELL_ROW_35_886 VGND VPWR sky130_fd_sc_hd__tapvpwrvgnd_1
XTAP_TAPCELL_ROW_35_897 VGND VPWR sky130_fd_sc_hd__tapvpwrvgnd_1
XFILLER_138_749 VGND VGND VPWR VPWR sky130_fd_sc_hd__decap_6
XFILLER_137_237 VPWR VGND VPWR VGND sky130_ef_sc_hd__decap_12
XFILLER_146_793 VPWR VGND VPWR VGND sky130_ef_sc_hd__decap_12
XFILLER_106_613 VPWR VGND VPWR VGND sky130_ef_sc_hd__decap_12
XTAP_TAPCELL_ROW_95_1855 VGND VPWR sky130_fd_sc_hd__tapvpwrvgnd_1
XTAP_TAPCELL_ROW_95_1844 VGND VPWR sky130_fd_sc_hd__tapvpwrvgnd_1
XFILLER_3_217 VGND VGND VPWR VPWR sky130_fd_sc_hd__decap_6
XFILLER_145_281 VPWR VGND VPWR VGND sky130_ef_sc_hd__decap_12
XFILLER_106_657 VPWR VGND VPWR VGND sky130_ef_sc_hd__decap_12
XFILLER_105_167 VGND VGND VPWR VPWR sky130_fd_sc_hd__fill_1
XFILLER_10_77 VGND VGND VPWR VPWR sky130_fd_sc_hd__decap_6
XPHY_EDGE_ROW_5_Left_159 VGND VGND VPWR VPWR sky130_fd_sc_hd__decap_3
XFILLER_126_77 VGND VGND VPWR VPWR sky130_fd_sc_hd__decap_6
XFILLER_86_15 VPWR VGND VPWR VGND sky130_ef_sc_hd__decap_12
XFILLER_87_541 VPWR VGND VPWR VGND sky130_ef_sc_hd__decap_12
XFILLER_75_703 VGND VGND VPWR VPWR sky130_fd_sc_hd__fill_1
XFILLER_47_405 VPWR VGND VPWR VGND sky130_ef_sc_hd__decap_12
XFILLER_142_65 VPWR VGND VPWR VGND sky130_ef_sc_hd__decap_12
XTAP_TAPCELL_ROW_126_2354 VGND VPWR sky130_fd_sc_hd__tapvpwrvgnd_1
XTAP_TAPCELL_ROW_126_2343 VGND VPWR sky130_fd_sc_hd__tapvpwrvgnd_1
XFILLER_63_909 VGND VGND VPWR VPWR sky130_fd_sc_hd__fill_1
XFILLER_62_419 VGND VGND VPWR VPWR sky130_fd_sc_hd__fill_1
XFILLER_16_825 VPWR VGND VPWR VGND sky130_ef_sc_hd__decap_12
XFILLER_55_482 VPWR VGND VPWR VGND sky130_ef_sc_hd__decap_12
XFILLER_15_335 VGND VGND VPWR VPWR sky130_fd_sc_hd__fill_1
XFILLER_42_121 VPWR VGND VPWR VGND sky130_ef_sc_hd__decap_12
XFILLER_16_869 VPWR VGND VPWR VGND sky130_ef_sc_hd__decap_12
XTAP_TAPCELL_ROW_104_1995 VGND VPWR sky130_fd_sc_hd__tapvpwrvgnd_1
XFILLER_129_727 VGND VGND VPWR VPWR sky130_fd_sc_hd__fill_1
XFILLER_11_541 VPWR VGND VPWR VGND sky130_ef_sc_hd__decap_12
XTAP_TAPCELL_ROW_13_536 VGND VPWR sky130_fd_sc_hd__tapvpwrvgnd_1
XTAP_TAPCELL_ROW_13_547 VGND VPWR sky130_fd_sc_hd__tapvpwrvgnd_1
XFILLER_7_578 VPWR VGND VPWR VGND sky130_ef_sc_hd__decap_12
XFILLER_124_421 VPWR VGND VPWR VGND sky130_ef_sc_hd__decap_12
XFILLER_151_273 VGND VGND VPWR VPWR sky130_fd_sc_hd__decap_6
XFILLER_97_349 VPWR VGND VPWR VGND sky130_ef_sc_hd__decap_12
XFILLER_111_137 VPWR VGND VPWR VGND sky130_ef_sc_hd__decap_12
XFILLER_78_563 VPWR VGND VPWR VGND sky130_ef_sc_hd__decap_12
XFILLER_120_693 VGND VGND VPWR VPWR sky130_fd_sc_hd__decap_6
X_2170_ _1414_ _1422_ _1426_ VGND VGND VPWR VPWR _1427_ sky130_fd_sc_hd__o21ai_1
XFILLER_19_641 VPWR VGND VPWR VGND sky130_ef_sc_hd__decap_12
XTAP_TAPCELL_ROW_49_1109 VGND VPWR sky130_fd_sc_hd__tapvpwrvgnd_1
XFILLER_19_685 VPWR VGND VPWR VGND sky130_ef_sc_hd__decap_12
XFILLER_80_238 VPWR VGND VPWR VGND sky130_ef_sc_hd__decap_12
XANTENNA__2284__A A_reg\[0\] VGND VGND VPWR VPWR sky130_fd_sc_hd__diode_2
XFILLER_18_195 VGND VGND VPWR VPWR sky130_fd_sc_hd__fill_1
XANTENNA__3206__A1 CRT_Start VGND VGND VPWR VPWR sky130_fd_sc_hd__diode_2
XFILLER_21_305 VPWR VGND VPWR VGND sky130_ef_sc_hd__decap_12
XFILLER_34_699 VGND VGND VPWR VPWR sky130_fd_sc_hd__fill_1
X_1954_ B_reg\[5\] _1207_ _1215_ _1218_ VGND VGND VPWR VPWR _1219_ sky130_fd_sc_hd__a31o_1
XTAP_TAPCELL_ROW_32_845 VGND VPWR sky130_fd_sc_hd__tapvpwrvgnd_1
XFILLER_119_237 VPWR VGND VPWR VGND sky130_ef_sc_hd__decap_12
XANTENNA__1768__A1 A_reg\[9\] VGND VGND VPWR VPWR sky130_fd_sc_hd__diode_2
XANTENNA__1628__A B_reg\[2\] VGND VGND VPWR VPWR sky130_fd_sc_hd__diode_2
X_1885_ _1154_ A_reg\[1\] _1152_ VGND VGND VPWR VPWR _1155_ sky130_fd_sc_hd__mux2_1
XFILLER_128_793 VPWR VGND VPWR VGND sky130_ef_sc_hd__decap_12
XFILLER_143_741 VPWR VGND VPWR VGND sky130_ef_sc_hd__decap_12
XFILLER_127_281 VPWR VGND VPWR VGND sky130_ef_sc_hd__decap_12
XTAP_TAPCELL_ROW_77_1563 VGND VPWR sky130_fd_sc_hd__tapvpwrvgnd_1
XFILLER_143_785 VPWR VGND VPWR VGND sky130_ef_sc_hd__decap_12
XFILLER_142_251 VGND VGND VPWR VPWR sky130_fd_sc_hd__fill_1
XFILLER_89_839 VGND VGND VPWR VPWR sky130_fd_sc_hd__fill_1
XFILLER_0_209 VPWR VGND VPWR VGND sky130_ef_sc_hd__decap_12
X_2506_ _0252_ _0253_ VGND VGND VPWR VPWR _0254_ sky130_fd_sc_hd__nor2_1
XFILLER_130_413 VGND VGND VPWR VPWR sky130_fd_sc_hd__decap_6
X_2437_ OpSel_reg\[0\] OpSel_reg\[1\] VGND VGND VPWR VPWR _0187_ sky130_fd_sc_hd__and2b_4
XANTENNA__1940__A1 B_reg\[7\] VGND VGND VPWR VPWR sky130_fd_sc_hd__diode_2
XFILLER_130_457 VPWR VGND VPWR VGND sky130_ef_sc_hd__decap_12
XTAP_TAPCELL_ROW_90_1774 VGND VPWR sky130_fd_sc_hd__tapvpwrvgnd_1
XFILLER_111_671 VGND VGND VPWR VPWR sky130_fd_sc_hd__fill_1
X_2368_ _0108_ _0121_ _0109_ VGND VGND VPWR VPWR _0122_ sky130_fd_sc_hd__a21bo_1
XFILLER_69_585 VPWR VGND VPWR VGND sky130_ef_sc_hd__decap_12
XFILLER_56_29 VGND VGND VPWR VPWR sky130_fd_sc_hd__decap_4
XFILLER_29_405 VPWR VGND VPWR VGND sky130_ef_sc_hd__decap_12
X_2299_ _1175_ _1549_ _1551_ VGND VGND VPWR VPWR _1552_ sky130_fd_sc_hd__or3_1
XFILLER_29_449 VPWR VGND VPWR VGND sky130_ef_sc_hd__decap_12
XFILLER_45_909 VGND VGND VPWR VPWR sky130_fd_sc_hd__fill_1
XTAP_TAPCELL_ROW_108_2062 VGND VPWR sky130_fd_sc_hd__tapvpwrvgnd_1
XFILLER_71_205 VGND VGND VPWR VPWR sky130_fd_sc_hd__decap_4
XFILLER_44_419 VGND VGND VPWR VPWR sky130_fd_sc_hd__fill_1
XTAP_TAPCELL_ROW_121_2262 VGND VPWR sky130_fd_sc_hd__tapvpwrvgnd_1
XFILLER_24_121 VPWR VGND VPWR VGND sky130_ef_sc_hd__decap_12
XTAP_TAPCELL_ROW_121_2273 VGND VPWR sky130_fd_sc_hd__tapvpwrvgnd_1
XFILLER_52_474 VGND VGND VPWR VPWR sky130_fd_sc_hd__fill_2
XFILLER_13_839 VGND VGND VPWR VPWR sky130_fd_sc_hd__fill_1
XFILLER_24_165 VPWR VGND VPWR VGND sky130_ef_sc_hd__decap_12
XFILLER_40_625 VPWR VGND VPWR VGND sky130_ef_sc_hd__decap_12
XFILLER_138_513 VPWR VGND VPWR VGND sky130_ef_sc_hd__decap_12
XFILLER_138_557 VPWR VGND VPWR VGND sky130_ef_sc_hd__decap_12
XFILLER_153_505 VPWR VGND VPWR VGND sky130_ef_sc_hd__decap_12
XFILLER_108_3 VPWR VGND VPWR VGND sky130_ef_sc_hd__decap_12
XFILLER_106_410 VGND VGND VPWR VPWR sky130_fd_sc_hd__decap_8
XFILLER_4_559 VGND VGND VPWR VPWR sky130_fd_sc_hd__decap_3
XFILLER_133_273 VGND VGND VPWR VPWR sky130_fd_sc_hd__decap_6
XFILLER_97_69 VPWR VGND VPWR VGND sky130_ef_sc_hd__decap_12
XFILLER_79_349 VPWR VGND VPWR VGND sky130_ef_sc_hd__decap_12
XFILLER_95_809 VPWR VGND VPWR VGND sky130_ef_sc_hd__decap_12
XFILLER_88_861 VGND VGND VPWR VPWR sky130_fd_sc_hd__decap_6
XFILLER_153_53 VGND VGND VPWR VPWR sky130_fd_sc_hd__decap_3
XFILLER_48_725 VGND VGND VPWR VPWR sky130_fd_sc_hd__decap_6
XFILLER_153_97 VPWR VGND VPWR VGND sky130_ef_sc_hd__decap_12
XANTENNA_input28_A B_in[5] VGND VGND VPWR VPWR sky130_fd_sc_hd__diode_2
XFILLER_102_693 VGND VGND VPWR VPWR sky130_fd_sc_hd__decap_6
XFILLER_101_181 VPWR VGND VPWR VGND sky130_ef_sc_hd__decap_12
XFILLER_87_393 VPWR VGND VPWR VGND sky130_ef_sc_hd__decap_12
XFILLER_48_769 VGND VGND VPWR VPWR sky130_fd_sc_hd__decap_8
XFILLER_36_909 VGND VGND VPWR VPWR sky130_fd_sc_hd__fill_1
XTAP_TAPCELL_ROW_18_617 VGND VPWR sky130_fd_sc_hd__tapvpwrvgnd_1
XFILLER_47_279 VGND VGND VPWR VPWR sky130_fd_sc_hd__fill_1
XFILLER_90_525 VGND VGND VPWR VPWR sky130_fd_sc_hd__decap_6
XFILLER_62_216 VGND VGND VPWR VPWR sky130_fd_sc_hd__decap_8
XFILLER_90_558 VGND VGND VPWR VPWR sky130_fd_sc_hd__decap_4
XFILLER_43_441 VGND VGND VPWR VPWR sky130_fd_sc_hd__decap_6
XFILLER_71_783 VGND VGND VPWR VPWR sky130_fd_sc_hd__fill_1
XFILLER_16_699 VGND VGND VPWR VPWR sky130_fd_sc_hd__fill_1
XFILLER_43_485 VGND VGND VPWR VPWR sky130_fd_sc_hd__decap_6
XTAP_TAPCELL_ROW_44_1028 VGND VPWR sky130_fd_sc_hd__tapvpwrvgnd_1
XTAP_TAPCELL_ROW_139_2556 VGND VPWR sky130_fd_sc_hd__tapvpwrvgnd_1
XTAP_TAPCELL_ROW_44_1039 VGND VPWR sky130_fd_sc_hd__tapvpwrvgnd_1
XFILLER_12_861 VGND VGND VPWR VPWR sky130_fd_sc_hd__decap_6
XTAP_TAPCELL_ROW_152_2767 VGND VPWR sky130_fd_sc_hd__tapvpwrvgnd_1
XTAP_TAPCELL_ROW_152_2756 VGND VPWR sky130_fd_sc_hd__tapvpwrvgnd_1
XFILLER_7_364 VPWR VGND VPWR VGND sky130_ef_sc_hd__decap_12
XFILLER_7_353 VGND VGND VPWR VPWR sky130_fd_sc_hd__fill_1
X_1670_ _0938_ _0945_ VGND VGND VPWR VPWR _0946_ sky130_fd_sc_hd__nor2_1
XFILLER_125_741 VPWR VGND VPWR VGND sky130_ef_sc_hd__decap_12
XFILLER_109_281 VPWR VGND VPWR VGND sky130_ef_sc_hd__decap_12
XFILLER_125_785 VPWR VGND VPWR VGND sky130_ef_sc_hd__decap_12
XFILLER_124_251 VGND VGND VPWR VPWR sky130_fd_sc_hd__fill_1
XTAP_TAPCELL_ROW_59_1282 VGND VPWR sky130_fd_sc_hd__tapvpwrvgnd_1
XTAP_TAPCELL_ROW_59_1271 VGND VPWR sky130_fd_sc_hd__tapvpwrvgnd_1
XFILLER_112_413 VGND VGND VPWR VPWR sky130_fd_sc_hd__decap_6
XFILLER_98_625 VPWR VGND VPWR VGND sky130_ef_sc_hd__decap_12
XFILLER_97_113 VPWR VGND VPWR VGND sky130_ef_sc_hd__decap_12
XFILLER_140_755 VGND VGND VPWR VPWR sky130_fd_sc_hd__fill_1
XFILLER_112_457 VPWR VGND VPWR VGND sky130_ef_sc_hd__decap_12
XFILLER_98_669 VPWR VGND VPWR VGND sky130_ef_sc_hd__decap_12
X_3271_ clknet_3_5__leaf_clk _0054_ net36 VGND VGND VPWR VPWR net42 sky130_fd_sc_hd__dfrtp_1
XTAP_TAPCELL_ROW_72_1482 VGND VPWR sky130_fd_sc_hd__tapvpwrvgnd_1
XFILLER_23_3 VPWR VGND VPWR VGND sky130_ef_sc_hd__decap_12
X_2222_ A_reg\[6\] _1474_ VGND VGND VPWR VPWR _1479_ sky130_fd_sc_hd__xnor2_1
XFILLER_39_736 VPWR VGND VPWR VGND sky130_ef_sc_hd__decap_12
XFILLER_66_533 VPWR VGND VPWR VGND sky130_ef_sc_hd__decap_12
X_2153_ _1408_ _1409_ VGND VGND VPWR VPWR _1410_ sky130_fd_sc_hd__and2_1
XFILLER_27_909 VGND VGND VPWR VPWR sky130_fd_sc_hd__fill_1
XFILLER_53_205 VPWR VGND VPWR VGND sky130_ef_sc_hd__decap_12
X_2084_ B_reg\[0\] _1345_ VGND VGND VPWR VPWR _1346_ sky130_fd_sc_hd__nor2_1
XTAP_TAPCELL_ROW_37_926 VGND VPWR sky130_fd_sc_hd__tapvpwrvgnd_1
XFILLER_22_625 VPWR VGND VPWR VGND sky130_ef_sc_hd__decap_12
XFILLER_21_113 VPWR VGND VPWR VGND sky130_ef_sc_hd__decap_12
XFILLER_22_669 VPWR VGND VPWR VGND sky130_ef_sc_hd__decap_12
XFILLER_148_811 VGND VGND VPWR VPWR sky130_fd_sc_hd__fill_1
X_2986_ _0670_ _0671_ VGND VGND VPWR VPWR _0674_ sky130_fd_sc_hd__xnor2_1
XTAP_TAPCELL_ROW_79_1603 VGND VPWR sky130_fd_sc_hd__tapvpwrvgnd_1
X_1937_ B_reg\[8\] _1191_ _1198_ _1199_ _1201_ VGND VGND VPWR VPWR _1202_ sky130_fd_sc_hd__a41o_1
XFILLER_135_505 VPWR VGND VPWR VGND sky130_ef_sc_hd__decap_12
X_1868_ _0893_ _1134_ _1137_ A_reg\[5\] _1136_ VGND VGND VPWR VPWR _1138_ sky130_fd_sc_hd__a221o_1
XTAP_TAPCELL_ROW_92_1803 VGND VPWR sky130_fd_sc_hd__tapvpwrvgnd_1
X_1799_ _1063_ _1068_ _1070_ _1067_ VGND VGND VPWR VPWR _1072_ sky130_fd_sc_hd__a22o_1
XFILLER_115_273 VGND VGND VPWR VPWR sky130_fd_sc_hd__decap_6
XFILLER_107_57 VPWR VGND VPWR VGND sky130_ef_sc_hd__decap_12
XFILLER_1_529 VPWR VGND VPWR VGND sky130_ef_sc_hd__decap_12
XFILLER_131_777 VGND VGND VPWR VPWR sky130_fd_sc_hd__decap_6
XFILLER_130_221 VPWR VGND VPWR VGND sky130_ef_sc_hd__decap_12
XFILLER_77_809 VPWR VGND VPWR VGND sky130_ef_sc_hd__decap_12
XFILLER_130_265 VPWR VGND VPWR VGND sky130_ef_sc_hd__decap_12
XPHY_EDGE_ROW_95_Left_249 VGND VGND VPWR VPWR sky130_fd_sc_hd__decap_3
XFILLER_85_853 VPWR VGND VPWR VGND sky130_ef_sc_hd__decap_12
XANTENNA__2917__A _0554_ VGND VGND VPWR VPWR sky130_fd_sc_hd__diode_2
XFILLER_69_393 VPWR VGND VPWR VGND sky130_ef_sc_hd__decap_12
XFILLER_18_909 VGND VGND VPWR VPWR sky130_fd_sc_hd__fill_1
XTAP_TAPCELL_ROW_123_2302 VGND VPWR sky130_fd_sc_hd__tapvpwrvgnd_1
XFILLER_85_897 VPWR VGND VPWR VGND sky130_ef_sc_hd__decap_12
XANTENNA__3231__RESET_B net36 VGND VGND VPWR VPWR sky130_fd_sc_hd__diode_2
XTAP_TAPCELL_ROW_4_389 VGND VPWR sky130_fd_sc_hd__tapvpwrvgnd_1
XFILLER_29_279 VGND VGND VPWR VPWR sky130_fd_sc_hd__fill_1
XANTENNA__1821__A A_reg\[2\] VGND VGND VPWR VPWR sky130_fd_sc_hd__diode_2
XANTENNA__3228__CLK clknet_3_1__leaf_clk VGND VGND VPWR VPWR sky130_fd_sc_hd__diode_2
XFILLER_16_65 VPWR VGND VPWR VGND sky130_ef_sc_hd__decap_12
XFILLER_25_485 VPWR VGND VPWR VGND sky130_ef_sc_hd__decap_12
XTAP_TAPCELL_ROW_101_1943 VGND VPWR sky130_fd_sc_hd__tapvpwrvgnd_1
XANTENNA__2652__A a_r3\[0\] VGND VGND VPWR VPWR sky130_fd_sc_hd__diode_2
XFILLER_40_433 VPWR VGND VPWR VGND sky130_ef_sc_hd__decap_12
XFILLER_139_833 VGND VGND VPWR VPWR sky130_fd_sc_hd__decap_6
XTAP_TAPCELL_ROW_101_1954 VGND VPWR sky130_fd_sc_hd__tapvpwrvgnd_1
XFILLER_9_629 VPWR VGND VPWR VGND sky130_ef_sc_hd__decap_12
XFILLER_40_477 VPWR VGND VPWR VGND sky130_ef_sc_hd__decap_12
XFILLER_139_877 VPWR VGND VPWR VGND sky130_ef_sc_hd__decap_12
XFILLER_138_321 VPWR VGND VPWR VGND sky130_ef_sc_hd__decap_12
XFILLER_8_139 VGND VGND VPWR VPWR sky130_fd_sc_hd__fill_1
XTAP_TAPCELL_ROW_23_697 VGND VPWR sky130_fd_sc_hd__tapvpwrvgnd_1
XFILLER_32_53 VPWR VGND VPWR VGND sky130_ef_sc_hd__decap_12
XFILLER_148_53 VPWR VGND VPWR VGND sky130_ef_sc_hd__decap_12
XFILLER_138_365 VPWR VGND VPWR VGND sky130_ef_sc_hd__decap_12
XFILLER_32_97 VPWR VGND VPWR VGND sky130_ef_sc_hd__decap_12
XFILLER_148_97 VPWR VGND VPWR VGND sky130_ef_sc_hd__decap_12
XTAP_TAPCELL_ROW_134_2475 VGND VPWR sky130_fd_sc_hd__tapvpwrvgnd_1
XFILLER_107_741 VPWR VGND VPWR VGND sky130_ef_sc_hd__decap_12
XFILLER_106_251 VGND VGND VPWR VPWR sky130_fd_sc_hd__fill_1
XFILLER_4_367 VGND VGND VPWR VPWR sky130_fd_sc_hd__decap_8
XFILLER_107_785 VPWR VGND VPWR VGND sky130_ef_sc_hd__decap_12
XFILLER_79_113 VPWR VGND VPWR VGND sky130_ef_sc_hd__decap_12
XFILLER_122_755 VGND VGND VPWR VPWR sky130_fd_sc_hd__fill_1
XFILLER_79_146 VPWR VGND VPWR VGND sky130_ef_sc_hd__decap_12
XANTENNA__3319__RESET_B net36 VGND VGND VPWR VPWR sky130_fd_sc_hd__diode_2
XFILLER_95_617 VPWR VGND VPWR VGND sky130_ef_sc_hd__decap_12
XFILLER_94_116 VPWR VGND VPWR VGND sky130_ef_sc_hd__decap_12
XTAP_TAPCELL_ROW_54_1190 VGND VPWR sky130_fd_sc_hd__tapvpwrvgnd_1
XFILLER_0_573 VGND VGND VPWR VPWR sky130_fd_sc_hd__decap_8
XFILLER_57_50 VGND VGND VPWR VPWR sky130_fd_sc_hd__decap_6
XFILLER_48_533 VPWR VGND VPWR VGND sky130_ef_sc_hd__decap_12
XFILLER_75_385 VGND VGND VPWR VPWR sky130_fd_sc_hd__decap_6
XFILLER_63_525 VGND VGND VPWR VPWR sky130_fd_sc_hd__fill_1
XFILLER_35_205 VGND VGND VPWR VPWR sky130_fd_sc_hd__decap_4
XFILLER_91_889 VGND VGND VPWR VPWR sky130_fd_sc_hd__decap_6
XFILLER_90_333 VPWR VGND VPWR VGND sky130_ef_sc_hd__decap_12
X_2840_ net13 A_reg\[6\] _0383_ VGND VGND VPWR VPWR _0063_ sky130_fd_sc_hd__mux2_1
XFILLER_43_293 VGND VGND VPWR VPWR sky130_fd_sc_hd__decap_3
X_2771_ _0461_ _0499_ _0508_ VGND VGND VPWR VPWR _0511_ sky130_fd_sc_hd__and3_1
XFILLER_117_505 VPWR VGND VPWR VGND sky130_ef_sc_hd__decap_12
X_1722_ _0995_ _0997_ VGND VGND VPWR VPWR _0998_ sky130_fd_sc_hd__or2_1
X_1653_ _0915_ _0922_ _0926_ A_reg\[14\] A_reg\[11\] VGND VGND VPWR VPWR _0929_ sky130_fd_sc_hd__o221a_1
XFILLER_7_161 VGND VGND VPWR VPWR sky130_fd_sc_hd__decap_6
XFILLER_144_357 VGND VGND VPWR VPWR sky130_fd_sc_hd__decap_6
XTAP_TAPCELL_ROW_74_1522 VGND VPWR sky130_fd_sc_hd__tapvpwrvgnd_1
XTAP_TAPCELL_ROW_74_1511 VGND VPWR sky130_fd_sc_hd__tapvpwrvgnd_1
XPHY_EDGE_ROW_9_Right_9 VGND VGND VPWR VPWR sky130_fd_sc_hd__decap_3
XANTENNA__2699__A2 b_r3\[3\] VGND VGND VPWR VPWR sky130_fd_sc_hd__diode_2
XFILLER_112_221 VPWR VGND VPWR VGND sky130_ef_sc_hd__decap_12
XFILLER_59_809 VPWR VGND VPWR VGND sky130_ef_sc_hd__decap_12
XFILLER_113_777 VGND VGND VPWR VPWR sky130_fd_sc_hd__decap_6
XFILLER_112_265 VPWR VGND VPWR VGND sky130_ef_sc_hd__decap_12
XPHY_EDGE_ROW_107_Right_107 VGND VGND VPWR VPWR sky130_fd_sc_hd__decap_3
XFILLER_98_477 VPWR VGND VPWR VGND sky130_ef_sc_hd__decap_12
X_3254_ clknet_3_6__leaf_clk _0037_ net36 VGND VGND VPWR VPWR u_crt.r3\[0\] sky130_fd_sc_hd__dfrtp_4
XFILLER_85_105 VGND VGND VPWR VPWR sky130_fd_sc_hd__decap_6
XFILLER_67_853 VPWR VGND VPWR VGND sky130_ef_sc_hd__decap_12
X_2205_ _1459_ _1461_ _1454_ VGND VGND VPWR VPWR _1462_ sky130_fd_sc_hd__a21o_1
X_3185_ _0837_ _0843_ VGND VGND VPWR VPWR _0869_ sky130_fd_sc_hd__nand2_1
XTAP_TAPCELL_ROW_105_2010 VGND VPWR sky130_fd_sc_hd__tapvpwrvgnd_1
X_2136_ B_reg\[3\] _1393_ _1392_ VGND VGND VPWR VPWR _1395_ sky130_fd_sc_hd__mux2_1
XFILLER_67_897 VPWR VGND VPWR VGND sky130_ef_sc_hd__decap_12
XTAP_TAPCELL_ROW_1_348 VGND VPWR sky130_fd_sc_hd__tapvpwrvgnd_1
XFILLER_93_193 VPWR VGND VPWR VGND sky130_ef_sc_hd__decap_12
X_2067_ _1315_ _1325_ VGND VGND VPWR VPWR _1329_ sky130_fd_sc_hd__xnor2_1
XFILLER_82_867 VGND VGND VPWR VPWR sky130_fd_sc_hd__fill_1
XFILLER_81_333 VGND VGND VPWR VPWR sky130_fd_sc_hd__fill_1
XTAP_TAPCELL_ROW_85_1684 VGND VPWR sky130_fd_sc_hd__tapvpwrvgnd_1
XFILLER_35_783 VGND VGND VPWR VPWR sky130_fd_sc_hd__fill_1
XTAP_TAPCELL_ROW_85_1695 VGND VPWR sky130_fd_sc_hd__tapvpwrvgnd_1
XFILLER_50_786 VGND VGND VPWR VPWR sky130_fd_sc_hd__decap_6
XFILLER_22_477 VPWR VGND VPWR VGND sky130_ef_sc_hd__decap_12
X_2969_ _0640_ _0655_ VGND VGND VPWR VPWR _0657_ sky130_fd_sc_hd__nand2_1
XFILLER_50_797 VPWR VGND VPWR VGND sky130_ef_sc_hd__decap_12
XFILLER_136_825 VPWR VGND VPWR VGND sky130_ef_sc_hd__decap_12
XTAP_TAPCELL_ROW_20_645 VGND VPWR sky130_fd_sc_hd__tapvpwrvgnd_1
XTAP_TAPCELL_ROW_20_656 VGND VPWR sky130_fd_sc_hd__tapvpwrvgnd_1
XFILLER_136_869 VPWR VGND VPWR VGND sky130_ef_sc_hd__decap_12
XFILLER_135_335 VGND VGND VPWR VPWR sky130_fd_sc_hd__fill_1
XTAP_TAPCELL_ROW_116_2194 VGND VPWR sky130_fd_sc_hd__tapvpwrvgnd_1
XTAP_TAPCELL_ROW_116_2183 VGND VPWR sky130_fd_sc_hd__tapvpwrvgnd_1
XFILLER_2_805 VGND VGND VPWR VPWR sky130_fd_sc_hd__decap_6
XFILLER_151_839 VGND VGND VPWR VPWR sky130_fd_sc_hd__fill_1
XFILLER_78_27 VGND VGND VPWR VPWR sky130_fd_sc_hd__fill_1
XFILLER_2_849 VPWR VGND VPWR VGND sky130_ef_sc_hd__decap_12
XFILLER_131_541 VPWR VGND VPWR VGND sky130_ef_sc_hd__decap_12
XFILLER_104_755 VGND VGND VPWR VPWR sky130_fd_sc_hd__fill_1
XFILLER_1_337 VPWR VGND VPWR VGND sky130_ef_sc_hd__decap_12
XANTENNA__1898__B1 net37 VGND VGND VPWR VPWR sky130_fd_sc_hd__diode_2
XFILLER_131_585 VPWR VGND VPWR VGND sky130_ef_sc_hd__decap_12
XFILLER_77_617 VPWR VGND VPWR VGND sky130_ef_sc_hd__decap_12
XFILLER_76_105 VPWR VGND VPWR VGND sky130_ef_sc_hd__decap_12
XFILLER_134_77 VGND VGND VPWR VPWR sky130_fd_sc_hd__decap_6
XFILLER_94_15 VGND VGND VPWR VPWR sky130_fd_sc_hd__decap_8
XFILLER_58_864 VGND VGND VPWR VPWR sky130_fd_sc_hd__decap_4
XFILLER_45_503 VGND VGND VPWR VPWR sky130_fd_sc_hd__fill_1
XFILLER_57_385 VGND VGND VPWR VPWR sky130_fd_sc_hd__decap_6
XFILLER_17_205 VPWR VGND VPWR VGND sky130_ef_sc_hd__decap_12
XFILLER_150_65 VPWR VGND VPWR VGND sky130_ef_sc_hd__decap_12
XFILLER_72_333 VPWR VGND VPWR VGND sky130_ef_sc_hd__decap_12
XFILLER_17_249 VPWR VGND VPWR VGND sky130_ef_sc_hd__decap_12
XFILLER_33_709 VPWR VGND VPWR VGND sky130_ef_sc_hd__decap_12
XFILLER_73_889 VGND VGND VPWR VPWR sky130_fd_sc_hd__decap_6
XTAP_TAPCELL_ROW_28_778 VGND VPWR sky130_fd_sc_hd__tapvpwrvgnd_1
XFILLER_25_293 VPWR VGND VPWR VGND sky130_ef_sc_hd__decap_12
XTAP_TAPCELL_ROW_136_2504 VGND VPWR sky130_fd_sc_hd__tapvpwrvgnd_1
XFILLER_139_641 VPWR VGND VPWR VGND sky130_ef_sc_hd__decap_12
XTAP_TAPCELL_ROW_136_2515 VGND VPWR sky130_fd_sc_hd__tapvpwrvgnd_1
XFILLER_13_488 VPWR VGND VPWR VGND sky130_ef_sc_hd__decap_12
XFILLER_139_685 VPWR VGND VPWR VGND sky130_ef_sc_hd__decap_12
XFILLER_138_195 VGND VGND VPWR VPWR sky130_fd_sc_hd__fill_1
XFILLER_126_357 VGND VGND VPWR VPWR sky130_fd_sc_hd__decap_6
XANTENNA__1726__A _0911_ VGND VGND VPWR VPWR sky130_fd_sc_hd__diode_2
XFILLER_5_665 VGND VGND VPWR VPWR sky130_fd_sc_hd__decap_6
XFILLER_153_165 VGND VGND VPWR VPWR sky130_fd_sc_hd__decap_3
XFILLER_141_305 VPWR VGND VPWR VGND sky130_ef_sc_hd__decap_12
XTAP_TAPCELL_ROW_56_1230 VGND VPWR sky130_fd_sc_hd__tapvpwrvgnd_1
XFILLER_4_153 VPWR VGND VPWR VGND sky130_ef_sc_hd__decap_12
XFILLER_141_349 VPWR VGND VPWR VGND sky130_ef_sc_hd__decap_12
XFILLER_4_197 VPWR VGND VPWR VGND sky130_ef_sc_hd__decap_12
XFILLER_150_861 VGND VGND VPWR VPWR sky130_fd_sc_hd__decap_6
XFILLER_110_725 VPWR VGND VPWR VGND sky130_ef_sc_hd__decap_12
XFILLER_68_71 VPWR VGND VPWR VGND sky130_ef_sc_hd__decap_12
XFILLER_95_447 VGND VGND VPWR VPWR sky130_fd_sc_hd__fill_1
XFILLER_67_149 VPWR VGND VPWR VGND sky130_ef_sc_hd__decap_12
XFILLER_49_831 VGND VGND VPWR VPWR sky130_fd_sc_hd__decap_8
XTAP_TAPCELL_ROW_147_2688 VGND VPWR sky130_fd_sc_hd__tapvpwrvgnd_1
XTAP_TAPCELL_ROW_147_2677 VGND VPWR sky130_fd_sc_hd__tapvpwrvgnd_1
XFILLER_110_769 VPWR VGND VPWR VGND sky130_ef_sc_hd__decap_12
XFILLER_83_609 VGND VGND VPWR VPWR sky130_fd_sc_hd__decap_6
XFILLER_49_897 VGND VGND VPWR VPWR sky130_fd_sc_hd__decap_8
XFILLER_91_653 VPWR VGND VPWR VGND sky130_ef_sc_hd__decap_12
XFILLER_75_193 VPWR VGND VPWR VGND sky130_ef_sc_hd__decap_12
XFILLER_64_867 VGND VGND VPWR VPWR sky130_fd_sc_hd__fill_1
XFILLER_91_697 VPWR VGND VPWR VGND sky130_ef_sc_hd__decap_12
XFILLER_90_174 VPWR VGND VPWR VGND sky130_ef_sc_hd__decap_12
XFILLER_51_517 VPWR VGND VPWR VGND sky130_ef_sc_hd__decap_12
XFILLER_17_783 VGND VGND VPWR VPWR sky130_fd_sc_hd__fill_1
XFILLER_149_405 VPWR VGND VPWR VGND sky130_ef_sc_hd__decap_12
XFILLER_149_449 VPWR VGND VPWR VGND sky130_ef_sc_hd__decap_12
X_2823_ net49 X_crt\[5\] _0553_ VGND VGND VPWR VPWR _0046_ sky130_fd_sc_hd__mux2_1
XFILLER_118_825 VPWR VGND VPWR VGND sky130_ef_sc_hd__decap_12
X_2754_ _0473_ _0478_ VGND VGND VPWR VPWR _0494_ sky130_fd_sc_hd__or2_1
XFILLER_144_121 VPWR VGND VPWR VGND sky130_ef_sc_hd__decap_12
XFILLER_117_335 VGND VGND VPWR VPWR sky130_fd_sc_hd__fill_1
X_1705_ _0977_ _0980_ A_reg\[3\] VGND VGND VPWR VPWR _0981_ sky130_fd_sc_hd__o21a_1
XFILLER_118_869 VPWR VGND VPWR VGND sky130_ef_sc_hd__decap_12
X_2685_ _0422_ _0424_ VGND VGND VPWR VPWR _0425_ sky130_fd_sc_hd__nor2_1
XFILLER_144_165 VPWR VGND VPWR VGND sky130_ef_sc_hd__decap_12
XFILLER_133_839 VGND VGND VPWR VPWR sky130_fd_sc_hd__fill_1
X_1636_ CU_state_dbg\[2\] _0884_ CU_state_dbg\[1\] VGND VGND VPWR VPWR net37 sky130_fd_sc_hd__and3_1
XFILLER_113_541 VPWR VGND VPWR VGND sky130_ef_sc_hd__decap_12
XFILLER_99_753 VPWR VGND VPWR VGND sky130_ef_sc_hd__decap_12
XFILLER_98_230 VGND VGND VPWR VPWR sky130_fd_sc_hd__fill_1
XFILLER_99_797 VPWR VGND VPWR VGND sky130_ef_sc_hd__decap_12
X_3306_ clknet_3_7__leaf_clk _0089_ net36 VGND VGND VPWR VPWR X_crt\[0\] sky130_fd_sc_hd__dfrtp_1
XTAP_TAPCELL_ROW_6_429 VGND VPWR sky130_fd_sc_hd__tapvpwrvgnd_1
XFILLER_113_585 VPWR VGND VPWR VGND sky130_ef_sc_hd__decap_12
XFILLER_58_138 VGND VGND VPWR VPWR sky130_fd_sc_hd__fill_2
X_3237_ clknet_3_3__leaf_clk _0024_ net36 VGND VGND VPWR VPWR b_r3\[1\] sky130_fd_sc_hd__dfrtp_4
XFILLER_86_469 VGND VGND VPWR VPWR sky130_fd_sc_hd__decap_6
XTAP_TAPCELL_ROW_87_1724 VGND VPWR sky130_fd_sc_hd__tapvpwrvgnd_1
X_3168_ _0818_ _0852_ _0824_ _0822_ VGND VGND VPWR VPWR _0856_ sky130_fd_sc_hd__o2bb2a_1
XFILLER_55_834 VGND VGND VPWR VPWR sky130_fd_sc_hd__decap_6
XFILLER_39_385 VGND VGND VPWR VPWR sky130_fd_sc_hd__decap_6
X_2119_ B_reg\[7\] _1376_ VGND VGND VPWR VPWR _1378_ sky130_fd_sc_hd__nand2_1
XFILLER_70_804 VGND VGND VPWR VPWR sky130_fd_sc_hd__decap_8
XFILLER_66_193 VGND VGND VPWR VPWR sky130_fd_sc_hd__decap_3
XFILLER_64_29 VPWR VGND VPWR VGND sky130_ef_sc_hd__decap_12
XFILLER_54_355 VGND VGND VPWR VPWR sky130_fd_sc_hd__fill_1
XFILLER_15_709 VPWR VGND VPWR VGND sky130_ef_sc_hd__decap_12
XFILLER_27_558 VGND VGND VPWR VPWR sky130_fd_sc_hd__fill_2
XFILLER_70_837 VPWR VGND VPWR VGND sky130_ef_sc_hd__decap_12
X_3099_ _0731_ _0741_ _0760_ VGND VGND VPWR VPWR _0787_ sky130_fd_sc_hd__and3_1
XTAP_TAPCELL_ROW_25_726 VGND VPWR sky130_fd_sc_hd__tapvpwrvgnd_1
XTAP_TAPCELL_ROW_25_737 VGND VPWR sky130_fd_sc_hd__tapvpwrvgnd_1
XFILLER_23_753 VPWR VGND VPWR VGND sky130_ef_sc_hd__decap_12
XTAP_TAPCELL_ROW_118_2223 VGND VPWR sky130_fd_sc_hd__tapvpwrvgnd_1
XTAP_TAPCELL_ROW_118_2212 VGND VPWR sky130_fd_sc_hd__tapvpwrvgnd_1
XFILLER_10_414 VGND VGND VPWR VPWR sky130_fd_sc_hd__decap_6
XFILLER_23_797 VPWR VGND VPWR VGND sky130_ef_sc_hd__decap_12
XFILLER_13_55 VGND VGND VPWR VPWR sky130_fd_sc_hd__fill_1
XFILLER_129_55 VGND VGND VPWR VPWR sky130_fd_sc_hd__fill_1
XFILLER_89_15 VGND VGND VPWR VPWR sky130_fd_sc_hd__fill_2
XTAP_TAPCELL_ROW_131_2434 VGND VPWR sky130_fd_sc_hd__tapvpwrvgnd_1
XTAP_TAPCELL_ROW_131_2423 VGND VPWR sky130_fd_sc_hd__tapvpwrvgnd_1
XFILLER_108_357 VGND VGND VPWR VPWR sky130_fd_sc_hd__decap_6
XTAP_TAPCELL_ROW_98_1897 VGND VPWR sky130_fd_sc_hd__tapvpwrvgnd_1
XFILLER_136_699 VGND VGND VPWR VPWR sky130_fd_sc_hd__fill_1
XFILLER_123_305 VPWR VGND VPWR VGND sky130_ef_sc_hd__decap_12
XFILLER_123_349 VPWR VGND VPWR VGND sky130_ef_sc_hd__decap_12
XFILLER_2_657 VPWR VGND VPWR VGND sky130_ef_sc_hd__decap_12
XFILLER_132_861 VGND VGND VPWR VPWR sky130_fd_sc_hd__decap_6
XFILLER_49_105 VGND VGND VPWR VPWR sky130_fd_sc_hd__decap_6
XFILLER_1_167 VGND VGND VPWR VPWR sky130_fd_sc_hd__fill_1
XFILLER_131_393 VPWR VGND VPWR VGND sky130_ef_sc_hd__decap_12
XFILLER_77_447 VGND VGND VPWR VPWR sky130_fd_sc_hd__fill_1
XFILLER_49_149 VPWR VGND VPWR VGND sky130_ef_sc_hd__decap_12
XFILLER_38_41 VPWR VGND VPWR VGND sky130_ef_sc_hd__decap_12
XTAP_TAPCELL_ROW_129_2396 VGND VPWR sky130_fd_sc_hd__tapvpwrvgnd_1
XFILLER_58_694 VGND VGND VPWR VPWR sky130_fd_sc_hd__decap_6
XFILLER_18_525 VGND VGND VPWR VPWR sky130_fd_sc_hd__decap_6
XFILLER_38_85 VPWR VGND VPWR VGND sky130_ef_sc_hd__decap_12
XFILLER_73_653 VPWR VGND VPWR VGND sky130_ef_sc_hd__decap_12
XANTENNA_input10_A A_in[3] VGND VGND VPWR VPWR sky130_fd_sc_hd__diode_2
XFILLER_18_569 VPWR VGND VPWR VGND sky130_ef_sc_hd__decap_12
XTAP_TAPCELL_ROW_142_2596 VGND VPWR sky130_fd_sc_hd__tapvpwrvgnd_1
XFILLER_73_697 VGND VGND VPWR VPWR sky130_fd_sc_hd__decap_8
XFILLER_33_539 VGND VGND VPWR VPWR sky130_fd_sc_hd__decap_8
XFILLER_41_561 VPWR VGND VPWR VGND sky130_ef_sc_hd__decap_12
XFILLER_147_909 VGND VGND VPWR VPWR sky130_fd_sc_hd__fill_1
XFILLER_9_223 VGND VGND VPWR VPWR sky130_fd_sc_hd__fill_1
XFILLER_146_419 VGND VGND VPWR VPWR sky130_fd_sc_hd__fill_1
XFILLER_126_121 VPWR VGND VPWR VGND sky130_ef_sc_hd__decap_12
XFILLER_142_625 VPWR VGND VPWR VGND sky130_ef_sc_hd__decap_12
XFILLER_126_165 VPWR VGND VPWR VGND sky130_ef_sc_hd__decap_12
XFILLER_115_839 VGND VGND VPWR VPWR sky130_fd_sc_hd__fill_1
X_2470_ _0216_ _0217_ VGND VGND VPWR VPWR _0218_ sky130_fd_sc_hd__nand2_1
XFILLER_5_473 VPWR VGND VPWR VGND sky130_ef_sc_hd__decap_12
XTAP_TAPCELL_ROW_149_2717 VGND VPWR sky130_fd_sc_hd__tapvpwrvgnd_1
XFILLER_142_669 VPWR VGND VPWR VGND sky130_ef_sc_hd__decap_12
XFILLER_141_113 VPWR VGND VPWR VGND sky130_ef_sc_hd__decap_12
XFILLER_79_81 VPWR VGND VPWR VGND sky130_ef_sc_hd__decap_12
XFILLER_96_701 VPWR VGND VPWR VGND sky130_ef_sc_hd__decap_12
XANTENNA__1890__S Encode_EN VGND VGND VPWR VPWR sky130_fd_sc_hd__diode_2
XFILLER_110_533 VPWR VGND VPWR VGND sky130_ef_sc_hd__decap_12
XFILLER_56_609 VGND VGND VPWR VPWR sky130_fd_sc_hd__decap_3
XFILLER_83_417 VPWR VGND VPWR VGND sky130_ef_sc_hd__decap_12
X_3022_ _0708_ _0709_ VGND VGND VPWR VPWR _0710_ sky130_fd_sc_hd__and2b_1
XTAP_TAPCELL_ROW_69_1443 VGND VPWR sky130_fd_sc_hd__tapvpwrvgnd_1
XTAP_TAPCELL_ROW_69_1432 VGND VPWR sky130_fd_sc_hd__tapvpwrvgnd_1
XFILLER_36_333 VPWR VGND VPWR VGND sky130_ef_sc_hd__decap_12
XFILLER_91_461 VGND VGND VPWR VPWR sky130_fd_sc_hd__decap_8
XFILLER_63_163 VGND VGND VPWR VPWR sky130_fd_sc_hd__decap_4
XFILLER_36_377 VPWR VGND VPWR VGND sky130_ef_sc_hd__decap_12
XFILLER_37_889 VGND VGND VPWR VPWR sky130_fd_sc_hd__decap_6
XTAP_TAPCELL_ROW_82_1643 VGND VPWR sky130_fd_sc_hd__tapvpwrvgnd_1
XFILLER_138_909 VGND VGND VPWR VPWR sky130_fd_sc_hd__fill_1
XFILLER_20_701 VPWR VGND VPWR VGND sky130_ef_sc_hd__decap_12
XFILLER_149_279 VGND VGND VPWR VPWR sky130_fd_sc_hd__fill_1
X_2806_ _0410_ _0544_ VGND VGND VPWR VPWR _0545_ sky130_fd_sc_hd__nand2_1
XFILLER_145_441 VGND VGND VPWR VPWR sky130_fd_sc_hd__decap_6
X_2737_ _0473_ _0476_ VGND VGND VPWR VPWR _0477_ sky130_fd_sc_hd__nor2_1
XFILLER_145_485 VPWR VGND VPWR VGND sky130_ef_sc_hd__decap_12
XFILLER_118_699 VGND VGND VPWR VPWR sky130_fd_sc_hd__fill_1
XTAP_TAPCELL_ROW_113_2142 VGND VPWR sky130_fd_sc_hd__tapvpwrvgnd_1
XFILLER_105_305 VPWR VGND VPWR VGND sky130_ef_sc_hd__decap_12
X_2668_ b_r3\[3\] _0395_ _0406_ OpSel_reg\[0\] VGND VGND VPWR VPWR _0408_ sky130_fd_sc_hd__o211a_1
XFILLER_121_809 VPWR VGND VPWR VGND sky130_ef_sc_hd__decap_12
XFILLER_105_349 VPWR VGND VPWR VGND sky130_ef_sc_hd__decap_12
X_1619_ B_reg\[11\] VGND VGND VPWR VPWR _0899_ sky130_fd_sc_hd__inv_2
XFILLER_114_861 VGND VGND VPWR VPWR sky130_fd_sc_hd__decap_6
XFILLER_87_712 VPWR VGND VPWR VGND sky130_ef_sc_hd__decap_12
X_2599_ _0321_ _0323_ VGND VGND VPWR VPWR _0344_ sky130_fd_sc_hd__xor2_1
XFILLER_113_393 VPWR VGND VPWR VGND sky130_ef_sc_hd__decap_12
XFILLER_99_583 VPWR VGND VPWR VGND sky130_ef_sc_hd__decap_12
XFILLER_59_447 VGND VGND VPWR VPWR sky130_fd_sc_hd__fill_1
XFILLER_115_57 VPWR VGND VPWR VGND sky130_ef_sc_hd__decap_12
XFILLER_86_233 VGND VGND VPWR VPWR sky130_fd_sc_hd__decap_8
XFILLER_74_406 VPWR VGND VPWR VGND sky130_ef_sc_hd__decap_12
XFILLER_47_609 VGND VGND VPWR VPWR sky130_fd_sc_hd__decap_6
XANTENNA_input2_A A_in[10] VGND VGND VPWR VPWR sky130_fd_sc_hd__diode_2
XFILLER_28_867 VGND VGND VPWR VPWR sky130_fd_sc_hd__fill_1
XFILLER_39_193 VPWR VGND VPWR VGND sky130_ef_sc_hd__decap_12
XFILLER_82_450 VGND VGND VPWR VPWR sky130_fd_sc_hd__fill_1
XFILLER_70_601 VPWR VGND VPWR VGND sky130_ef_sc_hd__decap_12
XFILLER_15_517 VPWR VGND VPWR VGND sky130_ef_sc_hd__decap_12
XANTENNA__2644__B a_r3\[0\] VGND VGND VPWR VPWR sky130_fd_sc_hd__diode_2
XFILLER_91_16 VGND VGND VPWR VPWR sky130_fd_sc_hd__fill_2
XFILLER_70_645 VPWR VGND VPWR VGND sky130_ef_sc_hd__decap_12
XFILLER_55_697 VGND VGND VPWR VPWR sky130_fd_sc_hd__decap_8
XFILLER_129_909 VGND VGND VPWR VPWR sky130_fd_sc_hd__fill_1
XFILLER_23_561 VPWR VGND VPWR VGND sky130_ef_sc_hd__decap_12
XFILLER_24_65 VPWR VGND VPWR VGND sky130_ef_sc_hd__decap_12
XFILLER_138_3 VPWR VGND VPWR VGND sky130_ef_sc_hd__decap_12
XFILLER_128_419 VGND VGND VPWR VPWR sky130_fd_sc_hd__fill_1
XFILLER_10_233 VPWR VGND VPWR VGND sky130_ef_sc_hd__decap_12
XFILLER_10_277 VGND VGND VPWR VPWR sky130_fd_sc_hd__fill_2
XFILLER_7_727 VGND VGND VPWR VPWR sky130_fd_sc_hd__fill_1
XFILLER_108_121 VPWR VGND VPWR VGND sky130_ef_sc_hd__decap_12
XFILLER_40_53 VPWR VGND VPWR VGND sky130_ef_sc_hd__decap_12
XFILLER_124_625 VPWR VGND VPWR VGND sky130_ef_sc_hd__decap_12
XFILLER_108_165 VPWR VGND VPWR VGND sky130_ef_sc_hd__decap_12
XFILLER_40_97 VPWR VGND VPWR VGND sky130_ef_sc_hd__decap_12
XFILLER_124_669 VPWR VGND VPWR VGND sky130_ef_sc_hd__decap_12
XFILLER_123_113 VPWR VGND VPWR VGND sky130_ef_sc_hd__decap_12
XFILLER_2_421 VPWR VGND VPWR VGND sky130_ef_sc_hd__decap_12
XFILLER_2_465 VGND VGND VPWR VPWR sky130_fd_sc_hd__decap_6
XANTENNA__2505__A1 a_r1\[0\] VGND VGND VPWR VPWR sky130_fd_sc_hd__diode_2
XFILLER_49_51 VGND VGND VPWR VPWR sky130_fd_sc_hd__decap_4
XFILLER_77_233 VGND VGND VPWR VPWR sky130_fd_sc_hd__fill_2
XTAP_TAPCELL_ROW_144_2636 VGND VPWR sky130_fd_sc_hd__tapvpwrvgnd_1
XFILLER_65_417 VPWR VGND VPWR VGND sky130_ef_sc_hd__decap_12
XANTENNA__2808__A2 _0910_ VGND VGND VPWR VPWR sky130_fd_sc_hd__diode_2
XFILLER_1_69 VPWR VGND VPWR VGND sky130_ef_sc_hd__decap_12
XFILLER_18_333 VPWR VGND VPWR VGND sky130_ef_sc_hd__decap_12
XFILLER_73_461 VPWR VGND VPWR VGND sky130_ef_sc_hd__decap_12
XFILLER_18_355 VGND VGND VPWR VPWR sky130_fd_sc_hd__decap_8
XFILLER_19_889 VGND VGND VPWR VPWR sky130_fd_sc_hd__decap_6
XFILLER_34_837 VPWR VGND VPWR VGND sky130_ef_sc_hd__decap_12
X_1970_ _1228_ _1232_ _1225_ VGND VGND VPWR VPWR _1235_ sky130_fd_sc_hd__o21a_1
XTAP_TAPCELL_ROW_64_1351 VGND VPWR sky130_fd_sc_hd__tapvpwrvgnd_1
XFILLER_61_667 VGND VGND VPWR VPWR sky130_fd_sc_hd__decap_4
XTAP_TAPCELL_ROW_64_1362 VGND VPWR sky130_fd_sc_hd__tapvpwrvgnd_1
XFILLER_60_177 VPWR VGND VPWR VGND sky130_ef_sc_hd__decap_12
XTAP_TAPCELL_ROW_16_589 VGND VPWR sky130_fd_sc_hd__tapvpwrvgnd_1
XFILLER_42_881 VPWR VGND VPWR VGND sky130_ef_sc_hd__decap_12
XFILLER_81_93 VPWR VGND VPWR VGND sky130_ef_sc_hd__decap_12
XFILLER_127_441 VGND VGND VPWR VPWR sky130_fd_sc_hd__decap_6
XFILLER_127_485 VPWR VGND VPWR VGND sky130_ef_sc_hd__decap_12
XFILLER_53_3 VPWR VGND VPWR VGND sky130_ef_sc_hd__decap_12
X_2522_ _0233_ _0269_ VGND VGND VPWR VPWR _0270_ sky130_fd_sc_hd__xnor2_1
XFILLER_142_433 VPWR VGND VPWR VGND sky130_ef_sc_hd__decap_12
XFILLER_103_809 VPWR VGND VPWR VGND sky130_ef_sc_hd__decap_12
XFILLER_6_793 VPWR VGND VPWR VGND sky130_ef_sc_hd__decap_12
XFILLER_5_281 VGND VGND VPWR VPWR sky130_fd_sc_hd__decap_4
XFILLER_142_477 VPWR VGND VPWR VGND sky130_ef_sc_hd__decap_12
X_2453_ _0188_ _0200_ _0202_ VGND VGND VPWR VPWR _0203_ sky130_fd_sc_hd__or3b_1
XANTENNA_clkbuf_3_0__f_clk_A clknet_0_clk VGND VGND VPWR VPWR sky130_fd_sc_hd__diode_2
X_2384_ _0136_ _0137_ VGND VGND VPWR VPWR _0138_ sky130_fd_sc_hd__nor2_1
XFILLER_111_853 VPWR VGND VPWR VGND sky130_ef_sc_hd__decap_12
XFILLER_111_897 VPWR VGND VPWR VGND sky130_ef_sc_hd__decap_12
XFILLER_110_363 VGND VGND VPWR VPWR sky130_fd_sc_hd__fill_1
XFILLER_96_586 VGND VGND VPWR VPWR sky130_fd_sc_hd__fill_2
XFILLER_68_277 VPWR VGND VPWR VGND sky130_ef_sc_hd__decap_12
Xinput2 A_in[10] VGND VGND VPWR VPWR net2 sky130_fd_sc_hd__clkbuf_1
XFILLER_83_225 VPWR VGND VPWR VGND sky130_ef_sc_hd__decap_12
X_3005_ _0688_ _0691_ _0687_ VGND VGND VPWR VPWR _0693_ sky130_fd_sc_hd__o21a_1
XFILLER_52_601 VPWR VGND VPWR VGND sky130_ef_sc_hd__decap_12
XFILLER_36_141 VPWR VGND VPWR VGND sky130_ef_sc_hd__decap_12
XFILLER_37_653 VPWR VGND VPWR VGND sky130_ef_sc_hd__decap_12
XFILLER_101_15 VPWR VGND VPWR VGND sky130_ef_sc_hd__decap_12
XFILLER_92_781 VPWR VGND VPWR VGND sky130_ef_sc_hd__decap_12
XFILLER_52_645 VGND VGND VPWR VPWR sky130_fd_sc_hd__decap_3
XFILLER_37_697 VPWR VGND VPWR VGND sky130_ef_sc_hd__decap_12
XANTENNA__3261__CLK clknet_3_7__leaf_clk VGND VGND VPWR VPWR sky130_fd_sc_hd__diode_2
XFILLER_52_689 VGND VGND VPWR VPWR sky130_fd_sc_hd__decap_8
XTAP_TAPCELL_ROW_35_887 VGND VPWR sky130_fd_sc_hd__tapvpwrvgnd_1
XTAP_TAPCELL_ROW_35_898 VGND VPWR sky130_fd_sc_hd__tapvpwrvgnd_1
XANTENNA__3256__RESET_B net36 VGND VGND VPWR VPWR sky130_fd_sc_hd__diode_2
XFILLER_20_531 VGND VGND VPWR VPWR sky130_fd_sc_hd__fill_1
XFILLER_137_205 VPWR VGND VPWR VGND sky130_ef_sc_hd__decap_12
XFILLER_137_249 VPWR VGND VPWR VGND sky130_ef_sc_hd__decap_12
XFILLER_106_625 VPWR VGND VPWR VGND sky130_ef_sc_hd__decap_12
XTAP_TAPCELL_ROW_95_1856 VGND VPWR sky130_fd_sc_hd__tapvpwrvgnd_1
XTAP_TAPCELL_ROW_95_1845 VGND VPWR sky130_fd_sc_hd__tapvpwrvgnd_1
XFILLER_145_293 VPWR VGND VPWR VGND sky130_ef_sc_hd__decap_12
XFILLER_105_113 VPWR VGND VPWR VGND sky130_ef_sc_hd__decap_12
XFILLER_121_617 VPWR VGND VPWR VGND sky130_ef_sc_hd__decap_12
XFILLER_106_669 VPWR VGND VPWR VGND sky130_ef_sc_hd__decap_12
XFILLER_86_27 VGND VGND VPWR VPWR sky130_fd_sc_hd__fill_1
XFILLER_59_200 VPWR VGND VPWR VGND sky130_ef_sc_hd__decap_12
XFILLER_99_391 VGND VGND VPWR VPWR sky130_fd_sc_hd__fill_1
XFILLER_87_553 VGND VGND VPWR VPWR sky130_fd_sc_hd__decap_6
XFILLER_87_586 VGND VGND VPWR VPWR sky130_fd_sc_hd__decap_8
XFILLER_59_288 VPWR VGND VPWR VGND sky130_ef_sc_hd__decap_12
XFILLER_47_417 VGND VGND VPWR VPWR sky130_fd_sc_hd__decap_8
XTAP_TAPCELL_ROW_126_2355 VGND VPWR sky130_fd_sc_hd__tapvpwrvgnd_1
XTAP_TAPCELL_ROW_126_2344 VGND VPWR sky130_fd_sc_hd__tapvpwrvgnd_1
XFILLER_101_396 VPWR VGND VPWR VGND sky130_ef_sc_hd__decap_12
XFILLER_142_77 VGND VGND VPWR VPWR sky130_fd_sc_hd__decap_6
XANTENNA__2655__A a_r3\[3\] VGND VGND VPWR VPWR sky130_fd_sc_hd__diode_2
XFILLER_55_461 VPWR VGND VPWR VGND sky130_ef_sc_hd__decap_12
XFILLER_55_494 VGND VGND VPWR VPWR sky130_fd_sc_hd__decap_8
XFILLER_16_837 VPWR VGND VPWR VGND sky130_ef_sc_hd__decap_12
XFILLER_42_133 VGND VGND VPWR VPWR sky130_fd_sc_hd__decap_6
XTAP_TAPCELL_ROW_46_1070 VGND VPWR sky130_fd_sc_hd__tapvpwrvgnd_1
XFILLER_24_881 VPWR VGND VPWR VGND sky130_ef_sc_hd__decap_12
XTAP_TAPCELL_ROW_104_1996 VGND VPWR sky130_fd_sc_hd__tapvpwrvgnd_1
XTAP_TAPCELL_ROW_13_537 VGND VPWR sky130_fd_sc_hd__tapvpwrvgnd_1
XFILLER_23_391 VGND VGND VPWR VPWR sky130_fd_sc_hd__fill_1
XFILLER_7_502 VGND VGND VPWR VPWR sky130_fd_sc_hd__fill_2
XFILLER_11_553 VGND VGND VPWR VPWR sky130_fd_sc_hd__decap_6
XFILLER_137_783 VGND VGND VPWR VPWR sky130_fd_sc_hd__fill_1
XFILLER_124_433 VPWR VGND VPWR VGND sky130_ef_sc_hd__decap_12
XFILLER_124_477 VPWR VGND VPWR VGND sky130_ef_sc_hd__decap_12
XPHY_EDGE_ROW_115_Left_269 VGND VGND VPWR VPWR sky130_fd_sc_hd__decap_3
XFILLER_3_741 VPWR VGND VPWR VGND sky130_ef_sc_hd__decap_12
XFILLER_111_105 VGND VGND VPWR VPWR sky130_fd_sc_hd__decap_6
XFILLER_3_785 VPWR VGND VPWR VGND sky130_ef_sc_hd__decap_12
XFILLER_111_149 VPWR VGND VPWR VGND sky130_ef_sc_hd__decap_12
XFILLER_78_531 VGND VGND VPWR VPWR sky130_fd_sc_hd__fill_1
XFILLER_78_597 VGND VGND VPWR VPWR sky130_fd_sc_hd__decap_3
XFILLER_78_575 VPWR VGND VPWR VGND sky130_ef_sc_hd__decap_12
XFILLER_76_93 VPWR VGND VPWR VGND sky130_ef_sc_hd__decap_12
XFILLER_65_225 VGND VGND VPWR VPWR sky130_fd_sc_hd__decap_8
XFILLER_81_729 VPWR VGND VPWR VGND sky130_ef_sc_hd__decap_12
XANTENNA__3284__CLK clknet_3_5__leaf_clk VGND VGND VPWR VPWR sky130_fd_sc_hd__diode_2
XFILLER_18_141 VPWR VGND VPWR VGND sky130_ef_sc_hd__decap_12
XFILLER_19_653 VPWR VGND VPWR VGND sky130_ef_sc_hd__decap_12
XFILLER_34_601 VPWR VGND VPWR VGND sky130_ef_sc_hd__decap_12
XFILLER_46_450 VGND VGND VPWR VPWR sky130_fd_sc_hd__fill_1
XFILLER_19_697 VPWR VGND VPWR VGND sky130_ef_sc_hd__decap_12
XFILLER_33_111 VGND VGND VPWR VPWR sky130_fd_sc_hd__fill_1
XPHY_EDGE_ROW_124_Left_278 VGND VGND VPWR VPWR sky130_fd_sc_hd__decap_3
XFILLER_34_645 VPWR VGND VPWR VGND sky130_ef_sc_hd__decap_12
XFILLER_21_317 VPWR VGND VPWR VGND sky130_ef_sc_hd__decap_12
XFILLER_147_503 VGND VGND VPWR VPWR sky130_fd_sc_hd__fill_1
X_1953_ _1216_ _1217_ _1209_ VGND VGND VPWR VPWR _1218_ sky130_fd_sc_hd__o21a_1
XTAP_TAPCELL_ROW_32_846 VGND VPWR sky130_fd_sc_hd__tapvpwrvgnd_1
XFILLER_119_205 VPWR VGND VPWR VGND sky130_ef_sc_hd__decap_12
X_1884_ _1152_ _1153_ A_reg\[1\] VGND VGND VPWR VPWR _1154_ sky130_fd_sc_hd__o21ai_1
XFILLER_135_709 VPWR VGND VPWR VGND sky130_ef_sc_hd__decap_12
XFILLER_119_249 VPWR VGND VPWR VGND sky130_ef_sc_hd__decap_12
XPHY_EDGE_ROW_133_Left_287 VGND VGND VPWR VPWR sky130_fd_sc_hd__decap_3
XFILLER_127_293 VPWR VGND VPWR VGND sky130_ef_sc_hd__decap_12
XTAP_TAPCELL_ROW_77_1564 VGND VPWR sky130_fd_sc_hd__tapvpwrvgnd_1
XFILLER_143_753 VPWR VGND VPWR VGND sky130_ef_sc_hd__decap_12
XFILLER_103_617 VPWR VGND VPWR VGND sky130_ef_sc_hd__decap_12
XFILLER_88_306 VGND VGND VPWR VPWR sky130_fd_sc_hd__fill_2
X_2505_ a_r1\[0\] b_r1\[2\] _0250_ _0251_ VGND VGND VPWR VPWR _0253_ sky130_fd_sc_hd__a22oi_1
XFILLER_143_797 VPWR VGND VPWR VGND sky130_ef_sc_hd__decap_12
X_2436_ OpSel_reg\[0\] OpSel_reg\[1\] VGND VGND VPWR VPWR _0186_ sky130_fd_sc_hd__or2_4
XFILLER_130_469 VGND VGND VPWR VPWR sky130_fd_sc_hd__decap_6
XTAP_TAPCELL_ROW_90_1775 VGND VPWR sky130_fd_sc_hd__tapvpwrvgnd_1
XTAP_TAPCELL_ROW_90_1764 VGND VPWR sky130_fd_sc_hd__tapvpwrvgnd_1
XFILLER_97_895 VGND VGND VPWR VPWR sky130_fd_sc_hd__fill_1
XFILLER_84_501 VGND VGND VPWR VPWR sky130_fd_sc_hd__decap_8
X_2367_ _1602_ _0106_ _0111_ VGND VGND VPWR VPWR _0121_ sky130_fd_sc_hd__a21o_1
XFILLER_69_597 VGND VGND VPWR VPWR sky130_fd_sc_hd__decap_4
XFILLER_57_704 VPWR VGND VPWR VGND sky130_ef_sc_hd__decap_12
XFILLER_29_417 VPWR VGND VPWR VGND sky130_ef_sc_hd__decap_12
XTAP_TAPCELL_ROW_108_2052 VGND VPWR sky130_fd_sc_hd__tapvpwrvgnd_1
X_2298_ B_reg\[15\] B_reg\[14\] B_reg\[12\] VGND VGND VPWR VPWR _1551_ sky130_fd_sc_hd__a21oi_1
XPHY_EDGE_ROW_142_Left_296 VGND VGND VPWR VPWR sky130_fd_sc_hd__decap_3
XTAP_TAPCELL_ROW_108_2063 VGND VPWR sky130_fd_sc_hd__tapvpwrvgnd_1
XFILLER_84_589 VGND VGND VPWR VPWR sky130_fd_sc_hd__decap_8
XFILLER_56_269 VGND VGND VPWR VPWR sky130_fd_sc_hd__fill_1
XFILLER_37_461 VPWR VGND VPWR VGND sky130_ef_sc_hd__decap_12
XTAP_TAPCELL_ROW_121_2263 VGND VPWR sky130_fd_sc_hd__tapvpwrvgnd_1
XFILLER_72_29 VGND VGND VPWR VPWR sky130_fd_sc_hd__decap_3
XFILLER_52_453 VGND VGND VPWR VPWR sky130_fd_sc_hd__fill_1
XFILLER_24_133 VGND VGND VPWR VPWR sky130_fd_sc_hd__decap_6
XTAP_TAPCELL_ROW_121_2274 VGND VPWR sky130_fd_sc_hd__tapvpwrvgnd_1
XFILLER_24_177 VPWR VGND VPWR VGND sky130_ef_sc_hd__decap_12
XFILLER_40_637 VGND VGND VPWR VPWR sky130_fd_sc_hd__decap_6
XFILLER_138_525 VGND VGND VPWR VPWR sky130_fd_sc_hd__decap_6
XANTENNA__1819__A A_reg\[2\] VGND VGND VPWR VPWR sky130_fd_sc_hd__diode_2
XFILLER_138_569 VPWR VGND VPWR VGND sky130_ef_sc_hd__decap_12
XFILLER_21_895 VGND VGND VPWR VPWR sky130_fd_sc_hd__fill_1
XFILLER_153_517 VPWR VGND VPWR VGND sky130_ef_sc_hd__decap_12
XFILLER_119_783 VGND VGND VPWR VPWR sky130_fd_sc_hd__fill_1
XFILLER_21_55 VGND VGND VPWR VPWR sky130_fd_sc_hd__fill_1
XFILLER_137_55 VGND VGND VPWR VPWR sky130_fd_sc_hd__fill_1
XFILLER_79_306 VPWR VGND VPWR VGND sky130_ef_sc_hd__decap_12
XFILLER_106_477 VPWR VGND VPWR VGND sky130_ef_sc_hd__decap_12
XFILLER_121_447 VGND VGND VPWR VPWR sky130_fd_sc_hd__fill_1
XFILLER_94_309 VGND VGND VPWR VPWR sky130_fd_sc_hd__decap_8
XFILLER_87_361 VPWR VGND VPWR VGND sky130_ef_sc_hd__decap_12
XFILLER_47_225 VGND VGND VPWR VPWR sky130_fd_sc_hd__decap_4
XFILLER_101_193 VPWR VGND VPWR VGND sky130_ef_sc_hd__decap_12
XFILLER_46_41 VPWR VGND VPWR VGND sky130_ef_sc_hd__decap_12
XFILLER_16_601 VPWR VGND VPWR VGND sky130_ef_sc_hd__decap_12
XTAP_TAPCELL_ROW_18_618 VGND VPWR sky130_fd_sc_hd__tapvpwrvgnd_1
XFILLER_46_85 VPWR VGND VPWR VGND sky130_ef_sc_hd__decap_12
XFILLER_15_111 VGND VGND VPWR VPWR sky130_fd_sc_hd__fill_1
XFILLER_16_645 VPWR VGND VPWR VGND sky130_ef_sc_hd__decap_12
XTAP_TAPCELL_ROW_44_1029 VGND VPWR sky130_fd_sc_hd__tapvpwrvgnd_1
XFILLER_62_73 VGND VGND VPWR VPWR sky130_fd_sc_hd__decap_3
XTAP_TAPCELL_ROW_61_1310 VGND VPWR sky130_fd_sc_hd__tapvpwrvgnd_1
XTAP_TAPCELL_ROW_139_2557 VGND VPWR sky130_fd_sc_hd__tapvpwrvgnd_1
XFILLER_129_503 VGND VGND VPWR VPWR sky130_fd_sc_hd__fill_1
XFILLER_8_811 VGND VGND VPWR VPWR sky130_fd_sc_hd__fill_1
XFILLER_117_709 VPWR VGND VPWR VGND sky130_ef_sc_hd__decap_12
XFILLER_11_361 VPWR VGND VPWR VGND sky130_ef_sc_hd__decap_12
XTAP_TAPCELL_ROW_152_2757 VGND VPWR sky130_fd_sc_hd__tapvpwrvgnd_1
XFILLER_7_57 VPWR VGND VPWR VGND sky130_ef_sc_hd__decap_12
XTAP_TAPCELL_ROW_152_2768 VGND VPWR sky130_fd_sc_hd__tapvpwrvgnd_1
XFILLER_109_293 VPWR VGND VPWR VGND sky130_ef_sc_hd__decap_12
XFILLER_7_376 VGND VGND VPWR VPWR sky130_fd_sc_hd__decap_8
XFILLER_140_701 VPWR VGND VPWR VGND sky130_ef_sc_hd__decap_12
XFILLER_125_753 VPWR VGND VPWR VGND sky130_ef_sc_hd__decap_12
XTAP_TAPCELL_ROW_59_1283 VGND VPWR sky130_fd_sc_hd__tapvpwrvgnd_1
XTAP_TAPCELL_ROW_59_1272 VGND VPWR sky130_fd_sc_hd__tapvpwrvgnd_1
XFILLER_125_797 VPWR VGND VPWR VGND sky130_ef_sc_hd__decap_12
XFILLER_98_637 VGND VGND VPWR VPWR sky130_fd_sc_hd__decap_6
XFILLER_97_125 VPWR VGND VPWR VGND sky130_ef_sc_hd__decap_12
X_3270_ clknet_3_5__leaf_clk _0053_ net36 VGND VGND VPWR VPWR net41 sky130_fd_sc_hd__dfrtp_1
X_2221_ _0893_ _1474_ VGND VGND VPWR VPWR _1478_ sky130_fd_sc_hd__xnor2_1
XFILLER_112_469 VGND VGND VPWR VPWR sky130_fd_sc_hd__decap_6
XFILLER_97_169 VGND VGND VPWR VPWR sky130_fd_sc_hd__decap_8
XFILLER_79_895 VGND VGND VPWR VPWR sky130_fd_sc_hd__fill_1
XTAP_TAPCELL_ROW_72_1483 VGND VPWR sky130_fd_sc_hd__tapvpwrvgnd_1
XFILLER_66_501 VPWR VGND VPWR VGND sky130_ef_sc_hd__decap_12
XFILLER_66_545 VPWR VGND VPWR VGND sky130_ef_sc_hd__decap_12
X_2152_ A_reg\[14\] A_reg\[13\] A_reg\[12\] A_reg\[15\] VGND VGND VPWR VPWR _1409_
+ sky130_fd_sc_hd__o211ai_1
XFILLER_16_3 VPWR VGND VPWR VGND sky130_ef_sc_hd__decap_12
XFILLER_39_748 VPWR VGND VPWR VGND sky130_ef_sc_hd__decap_12
XFILLER_93_353 VGND VGND VPWR VPWR sky130_fd_sc_hd__decap_8
X_2083_ B_reg\[1\] _1338_ _1343_ _1344_ VGND VGND VPWR VPWR _1345_ sky130_fd_sc_hd__a31o_1
XFILLER_66_589 VPWR VGND VPWR VGND sky130_ef_sc_hd__decap_12
XTAP_TAPCELL_ROW_37_916 VGND VPWR sky130_fd_sc_hd__tapvpwrvgnd_1
XFILLER_53_217 VGND VGND VPWR VPWR sky130_fd_sc_hd__decap_6
XFILLER_47_781 VGND VGND VPWR VPWR sky130_fd_sc_hd__decap_3
XFILLER_19_461 VPWR VGND VPWR VGND sky130_ef_sc_hd__decap_12
XTAP_TAPCELL_ROW_37_927 VGND VPWR sky130_fd_sc_hd__tapvpwrvgnd_1
XFILLER_61_261 VPWR VGND VPWR VGND sky130_ef_sc_hd__decap_12
XFILLER_34_475 VGND VGND VPWR VPWR sky130_fd_sc_hd__fill_1
XFILLER_21_125 VPWR VGND VPWR VGND sky130_ef_sc_hd__decap_12
XFILLER_22_637 VGND VGND VPWR VPWR sky130_fd_sc_hd__decap_6
X_2985_ _0556_ _0557_ VGND VGND VPWR VPWR _0673_ sky130_fd_sc_hd__nor2_1
XFILLER_21_169 VPWR VGND VPWR VGND sky130_ef_sc_hd__decap_12
XFILLER_148_867 VGND VGND VPWR VPWR sky130_fd_sc_hd__fill_1
X_1936_ B_reg\[8\] _1199_ _1200_ _1196_ VGND VGND VPWR VPWR _1201_ sky130_fd_sc_hd__a211oi_1
XFILLER_30_681 VPWR VGND VPWR VGND sky130_ef_sc_hd__decap_12
XFILLER_135_517 VPWR VGND VPWR VGND sky130_ef_sc_hd__decap_12
X_1867_ A_reg\[6\] _1133_ _1135_ VGND VGND VPWR VPWR _1137_ sky130_fd_sc_hd__o21a_1
XTAP_TAPCELL_ROW_92_1804 VGND VPWR sky130_fd_sc_hd__tapvpwrvgnd_1
X_1798_ _0894_ _1063_ _1066_ _1070_ VGND VGND VPWR VPWR _1071_ sky130_fd_sc_hd__o31ai_2
XFILLER_143_561 VPWR VGND VPWR VGND sky130_ef_sc_hd__decap_12
XFILLER_89_615 VGND VGND VPWR VPWR sky130_fd_sc_hd__fill_1
XFILLER_130_233 VPWR VGND VPWR VGND sky130_ef_sc_hd__decap_12
XFILLER_107_69 VPWR VGND VPWR VGND sky130_ef_sc_hd__decap_12
XFILLER_130_277 VPWR VGND VPWR VGND sky130_ef_sc_hd__decap_12
X_2419_ _0172_ _0159_ _0165_ VGND VGND VPWR VPWR _0173_ sky130_fd_sc_hd__mux2_1
XFILLER_85_821 VPWR VGND VPWR VGND sky130_ef_sc_hd__decap_12
XFILLER_69_361 VPWR VGND VPWR VGND sky130_ef_sc_hd__decap_12
XPHY_EDGE_ROW_150_Left_304 VGND VGND VPWR VPWR sky130_fd_sc_hd__decap_3
XANTENNA__2917__B _0604_ VGND VGND VPWR VPWR sky130_fd_sc_hd__diode_2
XTAP_TAPCELL_ROW_123_2303 VGND VPWR sky130_fd_sc_hd__tapvpwrvgnd_1
XFILLER_123_57 VPWR VGND VPWR VGND sky130_ef_sc_hd__decap_12
XFILLER_96_191 VGND VGND VPWR VPWR sky130_fd_sc_hd__decap_4
XFILLER_85_865 VPWR VGND VPWR VGND sky130_ef_sc_hd__decap_12
XFILLER_38_781 VPWR VGND VPWR VGND sky130_ef_sc_hd__decap_12
XFILLER_45_729 VPWR VGND VPWR VGND sky130_ef_sc_hd__decap_12
XANTENNA__3271__RESET_B net36 VGND VGND VPWR VPWR sky130_fd_sc_hd__diode_2
XFILLER_53_773 VGND VGND VPWR VPWR sky130_fd_sc_hd__fill_1
XFILLER_13_615 VGND VGND VPWR VPWR sky130_fd_sc_hd__fill_1
XFILLER_16_77 VGND VGND VPWR VPWR sky130_fd_sc_hd__decap_6
XANTENNA__2652__B a_r3\[1\] VGND VGND VPWR VPWR sky130_fd_sc_hd__diode_2
XFILLER_25_497 VGND VGND VPWR VPWR sky130_fd_sc_hd__decap_6
XFILLER_40_445 VPWR VGND VPWR VGND sky130_ef_sc_hd__decap_12
XTAP_TAPCELL_ROW_101_1955 VGND VPWR sky130_fd_sc_hd__tapvpwrvgnd_1
XTAP_TAPCELL_ROW_101_1944 VGND VPWR sky130_fd_sc_hd__tapvpwrvgnd_1
XFILLER_138_333 VPWR VGND VPWR VGND sky130_ef_sc_hd__decap_12
XTAP_TAPCELL_ROW_23_698 VGND VPWR sky130_fd_sc_hd__tapvpwrvgnd_1
XFILLER_32_65 VPWR VGND VPWR VGND sky130_ef_sc_hd__decap_12
XFILLER_40_489 VGND VGND VPWR VPWR sky130_fd_sc_hd__decap_6
XFILLER_148_65 VPWR VGND VPWR VGND sky130_ef_sc_hd__decap_12
XFILLER_139_889 VGND VGND VPWR VPWR sky130_fd_sc_hd__decap_6
XFILLER_138_377 VPWR VGND VPWR VGND sky130_ef_sc_hd__decap_12
XFILLER_120_3 VPWR VGND VPWR VGND sky130_ef_sc_hd__decap_12
XTAP_TAPCELL_ROW_134_2476 VGND VPWR sky130_fd_sc_hd__tapvpwrvgnd_1
XFILLER_107_753 VPWR VGND VPWR VGND sky130_ef_sc_hd__decap_12
XFILLER_122_701 VPWR VGND VPWR VGND sky130_ef_sc_hd__decap_12
XFILLER_107_797 VPWR VGND VPWR VGND sky130_ef_sc_hd__decap_12
XFILLER_79_125 VGND VGND VPWR VPWR sky130_fd_sc_hd__fill_2
XFILLER_95_629 VPWR VGND VPWR VGND sky130_ef_sc_hd__decap_12
XFILLER_79_169 VPWR VGND VPWR VGND sky130_ef_sc_hd__decap_12
XFILLER_79_158 VGND VGND VPWR VPWR sky130_fd_sc_hd__decap_8
XFILLER_76_810 VGND VGND VPWR VPWR sky130_fd_sc_hd__fill_2
XFILLER_48_501 VGND VGND VPWR VPWR sky130_fd_sc_hd__decap_6
XFILLER_0_552 VGND VGND VPWR VPWR sky130_fd_sc_hd__fill_2
XFILLER_94_128 VPWR VGND VPWR VGND sky130_ef_sc_hd__decap_12
XTAP_TAPCELL_ROW_54_1191 VGND VPWR sky130_fd_sc_hd__tapvpwrvgnd_1
XFILLER_48_545 VPWR VGND VPWR VGND sky130_ef_sc_hd__decap_12
XFILLER_87_191 VPWR VGND VPWR VGND sky130_ef_sc_hd__decap_12
XFILLER_48_589 VPWR VGND VPWR VGND sky130_ef_sc_hd__decap_12
XFILLER_90_345 VPWR VGND VPWR VGND sky130_ef_sc_hd__decap_12
XFILLER_44_740 VPWR VGND VPWR VGND sky130_ef_sc_hd__decap_12
XFILLER_16_475 VGND VGND VPWR VPWR sky130_fd_sc_hd__fill_1
XFILLER_43_261 VPWR VGND VPWR VGND sky130_ef_sc_hd__decap_12
XFILLER_149_609 VGND VGND VPWR VPWR sky130_fd_sc_hd__decap_6
X_2770_ _0499_ _0508_ _0461_ VGND VGND VPWR VPWR _0510_ sky130_fd_sc_hd__a21oi_1
XFILLER_12_681 VPWR VGND VPWR VGND sky130_ef_sc_hd__decap_12
XTAP_TAPCELL_ROW_42_996 VGND VPWR sky130_fd_sc_hd__tapvpwrvgnd_1
XFILLER_117_517 VPWR VGND VPWR VGND sky130_ef_sc_hd__decap_12
X_1721_ A_reg\[0\] _0989_ _0996_ VGND VGND VPWR VPWR _0997_ sky130_fd_sc_hd__and3_1
X_1652_ _0915_ _0922_ _0926_ A_reg\[14\] VGND VGND VPWR VPWR _0928_ sky130_fd_sc_hd__o22a_1
XANTENNA__2148__A2 _0911_ VGND VGND VPWR VPWR sky130_fd_sc_hd__diode_2
XTAP_TAPCELL_ROW_74_1523 VGND VPWR sky130_fd_sc_hd__tapvpwrvgnd_1
XTAP_TAPCELL_ROW_74_1512 VGND VPWR sky130_fd_sc_hd__tapvpwrvgnd_1
XFILLER_153_881 VPWR VGND VPWR VGND sky130_ef_sc_hd__decap_12
XFILLER_125_561 VPWR VGND VPWR VGND sky130_ef_sc_hd__decap_12
XFILLER_98_401 VGND VGND VPWR VPWR sky130_fd_sc_hd__decap_3
XFILLER_140_531 VGND VGND VPWR VPWR sky130_fd_sc_hd__fill_1
XFILLER_112_233 VPWR VGND VPWR VGND sky130_ef_sc_hd__decap_12
XFILLER_112_277 VPWR VGND VPWR VGND sky130_ef_sc_hd__decap_12
XFILLER_98_489 VPWR VGND VPWR VGND sky130_ef_sc_hd__decap_12
XFILLER_98_467 VGND VGND VPWR VPWR sky130_fd_sc_hd__decap_8
X_3253_ clknet_3_6__leaf_clk _0036_ net36 VGND VGND VPWR VPWR OpSel_reg\[1\] sky130_fd_sc_hd__dfrtp_4
XFILLER_86_629 VPWR VGND VPWR VGND sky130_ef_sc_hd__decap_12
XFILLER_86_618 VGND VGND VPWR VPWR sky130_fd_sc_hd__decap_4
XFILLER_79_670 VGND VGND VPWR VPWR sky130_fd_sc_hd__fill_2
XFILLER_58_309 VPWR VGND VPWR VGND sky130_ef_sc_hd__decap_12
XFILLER_67_821 VPWR VGND VPWR VGND sky130_ef_sc_hd__decap_12
X_2204_ _1453_ _1460_ _1446_ _1452_ VGND VGND VPWR VPWR _1461_ sky130_fd_sc_hd__o2bb2a_1
X_3184_ CRT_Start _0866_ _0867_ _0868_ VGND VGND VPWR VPWR _0092_ sky130_fd_sc_hd__a31oi_1
X_2135_ _0907_ _1390_ _1393_ VGND VGND VPWR VPWR _1394_ sky130_fd_sc_hd__a21boi_1
XFILLER_82_813 VPWR VGND VPWR VGND sky130_ef_sc_hd__decap_12
XFILLER_67_865 VPWR VGND VPWR VGND sky130_ef_sc_hd__decap_12
XTAP_TAPCELL_ROW_105_2011 VGND VPWR sky130_fd_sc_hd__tapvpwrvgnd_1
XFILLER_93_161 VGND VGND VPWR VPWR sky130_fd_sc_hd__decap_6
XTAP_TAPCELL_ROW_1_349 VGND VPWR sky130_fd_sc_hd__tapvpwrvgnd_1
XFILLER_27_729 VPWR VGND VPWR VGND sky130_ef_sc_hd__decap_12
X_2066_ _1327_ VGND VGND VPWR VPWR _1328_ sky130_fd_sc_hd__inv_2
XTAP_TAPCELL_ROW_85_1685 VGND VPWR sky130_fd_sc_hd__tapvpwrvgnd_1
XFILLER_22_401 VPWR VGND VPWR VGND sky130_ef_sc_hd__decap_12
XTAP_TAPCELL_ROW_85_1696 VGND VPWR sky130_fd_sc_hd__tapvpwrvgnd_1
XFILLER_62_581 VGND VGND VPWR VPWR sky130_fd_sc_hd__decap_6
X_2968_ _0640_ _0655_ VGND VGND VPWR VPWR _0656_ sky130_fd_sc_hd__or2_1
XFILLER_22_489 VPWR VGND VPWR VGND sky130_ef_sc_hd__decap_12
X_1919_ _1171_ _1183_ VGND VGND VPWR VPWR _1184_ sky130_fd_sc_hd__nand2_1
XTAP_TAPCELL_ROW_20_646 VGND VPWR sky130_fd_sc_hd__tapvpwrvgnd_1
XTAP_TAPCELL_ROW_20_657 VGND VPWR sky130_fd_sc_hd__tapvpwrvgnd_1
XFILLER_136_837 VPWR VGND VPWR VGND sky130_ef_sc_hd__decap_12
XFILLER_108_539 VGND VGND VPWR VPWR sky130_fd_sc_hd__fill_2
X_2899_ _0578_ _0586_ VGND VGND VPWR VPWR _0587_ sky130_fd_sc_hd__nand2_1
XTAP_TAPCELL_ROW_116_2195 VGND VPWR sky130_fd_sc_hd__tapvpwrvgnd_1
XTAP_TAPCELL_ROW_116_2184 VGND VPWR sky130_fd_sc_hd__tapvpwrvgnd_1
XFILLER_144_881 VPWR VGND VPWR VGND sky130_ef_sc_hd__decap_12
XFILLER_104_701 VPWR VGND VPWR VGND sky130_ef_sc_hd__decap_12
XFILLER_1_305 VPWR VGND VPWR VGND sky130_ef_sc_hd__decap_12
XFILLER_143_391 VGND VGND VPWR VPWR sky130_fd_sc_hd__fill_1
XFILLER_1_349 VPWR VGND VPWR VGND sky130_ef_sc_hd__decap_12
XFILLER_131_553 VGND VGND VPWR VPWR sky130_fd_sc_hd__decap_6
XFILLER_77_629 VPWR VGND VPWR VGND sky130_ef_sc_hd__decap_12
XFILLER_131_597 VPWR VGND VPWR VGND sky130_ef_sc_hd__decap_12
XFILLER_76_117 VPWR VGND VPWR VGND sky130_ef_sc_hd__decap_12
XFILLER_58_821 VGND VGND VPWR VPWR sky130_fd_sc_hd__fill_2
XFILLER_85_673 VPWR VGND VPWR VGND sky130_ef_sc_hd__decap_12
XFILLER_17_217 VGND VGND VPWR VPWR sky130_fd_sc_hd__decap_6
XFILLER_45_526 VGND VGND VPWR VPWR sky130_fd_sc_hd__decap_8
XFILLER_72_345 VPWR VGND VPWR VGND sky130_ef_sc_hd__decap_12
XFILLER_57_397 VGND VGND VPWR VPWR sky130_fd_sc_hd__fill_1
XFILLER_150_77 VGND VGND VPWR VPWR sky130_fd_sc_hd__decap_6
XTAP_TAPCELL_ROW_28_779 VGND VPWR sky130_fd_sc_hd__tapvpwrvgnd_1
XFILLER_32_209 VGND VGND VPWR VPWR sky130_fd_sc_hd__decap_6
XFILLER_25_261 VPWR VGND VPWR VGND sky130_ef_sc_hd__decap_12
XFILLER_41_721 VGND VGND VPWR VPWR sky130_fd_sc_hd__fill_2
XFILLER_9_405 VPWR VGND VPWR VGND sky130_ef_sc_hd__decap_12
XFILLER_40_253 VPWR VGND VPWR VGND sky130_ef_sc_hd__decap_12
XTAP_TAPCELL_ROW_136_2505 VGND VPWR sky130_fd_sc_hd__tapvpwrvgnd_1
XFILLER_9_449 VGND VGND VPWR VPWR sky130_fd_sc_hd__decap_4
XFILLER_139_653 VPWR VGND VPWR VGND sky130_ef_sc_hd__decap_12
XFILLER_138_141 VPWR VGND VPWR VGND sky130_ef_sc_hd__decap_12
XFILLER_139_697 VPWR VGND VPWR VGND sky130_ef_sc_hd__decap_12
XFILLER_4_121 VPWR VGND VPWR VGND sky130_ef_sc_hd__decap_12
XFILLER_141_317 VPWR VGND VPWR VGND sky130_ef_sc_hd__decap_12
XFILLER_107_561 VPWR VGND VPWR VGND sky130_ef_sc_hd__decap_12
XTAP_TAPCELL_ROW_56_1231 VGND VPWR sky130_fd_sc_hd__tapvpwrvgnd_1
XTAP_TAPCELL_ROW_56_1220 VGND VPWR sky130_fd_sc_hd__tapvpwrvgnd_1
XFILLER_4_165 VPWR VGND VPWR VGND sky130_ef_sc_hd__decap_12
XFILLER_122_531 VGND VGND VPWR VPWR sky130_fd_sc_hd__fill_1
XFILLER_96_905 VGND VGND VPWR VPWR sky130_fd_sc_hd__decap_4
XTAP_TAPCELL_ROW_8_460 VGND VPWR sky130_fd_sc_hd__tapvpwrvgnd_1
XFILLER_110_737 VPWR VGND VPWR VGND sky130_ef_sc_hd__decap_12
XFILLER_68_94 VPWR VGND VPWR VGND sky130_ef_sc_hd__decap_12
XFILLER_68_83 VGND VGND VPWR VPWR sky130_fd_sc_hd__fill_1
XANTENNA__2838__A0 net11 VGND VGND VPWR VPWR sky130_fd_sc_hd__diode_2
XTAP_TAPCELL_ROW_147_2689 VGND VPWR sky130_fd_sc_hd__tapvpwrvgnd_1
XTAP_TAPCELL_ROW_147_2678 VGND VPWR sky130_fd_sc_hd__tapvpwrvgnd_1
XFILLER_0_393 VPWR VGND VPWR VGND sky130_ef_sc_hd__decap_12
XFILLER_76_695 VGND VGND VPWR VPWR sky130_fd_sc_hd__decap_4
XFILLER_64_813 VPWR VGND VPWR VGND sky130_ef_sc_hd__decap_12
XFILLER_91_665 VGND VGND VPWR VPWR sky130_fd_sc_hd__decap_6
XFILLER_63_389 VGND VGND VPWR VPWR sky130_fd_sc_hd__fill_1
XFILLER_51_529 VPWR VGND VPWR VGND sky130_ef_sc_hd__decap_12
XFILLER_90_197 VGND VGND VPWR VPWR sky130_fd_sc_hd__decap_8
XFILLER_90_186 VGND VGND VPWR VPWR sky130_fd_sc_hd__decap_8
XFILLER_44_581 VGND VGND VPWR VPWR sky130_fd_sc_hd__decap_6
XFILLER_149_417 VPWR VGND VPWR VGND sky130_ef_sc_hd__decap_12
XFILLER_20_905 VGND VGND VPWR VPWR sky130_fd_sc_hd__decap_4
XFILLER_83_3 VPWR VGND VPWR VGND sky130_ef_sc_hd__decap_12
X_2822_ net48 X_crt\[4\] _0553_ VGND VGND VPWR VPWR _0045_ sky130_fd_sc_hd__mux2_1
XPHY_EDGE_ROW_140_Right_140 VGND VGND VPWR VPWR sky130_fd_sc_hd__decap_3
X_2753_ _0408_ _0492_ VGND VGND VPWR VPWR _0493_ sky130_fd_sc_hd__nor2_1
XFILLER_118_837 VPWR VGND VPWR VGND sky130_ef_sc_hd__decap_12
X_1704_ _0972_ _0979_ VGND VGND VPWR VPWR _0980_ sky130_fd_sc_hd__and2b_1
XFILLER_144_133 VGND VGND VPWR VPWR sky130_fd_sc_hd__decap_6
X_2684_ a_r3\[2\] b_r3\[2\] VGND VGND VPWR VPWR _0424_ sky130_fd_sc_hd__nor2_1
XFILLER_144_177 VPWR VGND VPWR VGND sky130_ef_sc_hd__decap_12
XFILLER_126_881 VPWR VGND VPWR VGND sky130_ef_sc_hd__decap_12
XFILLER_99_721 VGND VGND VPWR VPWR sky130_fd_sc_hd__decap_6
XANTENNA__3218__CLK clknet_3_3__leaf_clk VGND VGND VPWR VPWR sky130_fd_sc_hd__diode_2
X_1635_ _0912_ VGND VGND VPWR VPWR CRT_Start sky130_fd_sc_hd__inv_2
XFILLER_125_391 VGND VGND VPWR VPWR sky130_fd_sc_hd__fill_1
XFILLER_113_553 VGND VGND VPWR VPWR sky130_fd_sc_hd__decap_6
XFILLER_99_765 VPWR VGND VPWR VGND sky130_ef_sc_hd__decap_12
X_3305_ clknet_3_0__leaf_clk _0088_ net36 VGND VGND VPWR VPWR B_reg\[15\] sky130_fd_sc_hd__dfrtp_4
XFILLER_141_895 VGND VGND VPWR VPWR sky130_fd_sc_hd__fill_1
XFILLER_113_597 VPWR VGND VPWR VGND sky130_ef_sc_hd__decap_12
XFILLER_58_117 VGND VGND VPWR VPWR sky130_fd_sc_hd__decap_3
XFILLER_104_15 VPWR VGND VPWR VGND sky130_ef_sc_hd__decap_12
X_3236_ clknet_3_3__leaf_clk _0023_ net36 VGND VGND VPWR VPWR b_r3\[0\] sky130_fd_sc_hd__dfrtp_4
XTAP_TAPCELL_ROW_87_1725 VGND VPWR sky130_fd_sc_hd__tapvpwrvgnd_1
X_3167_ _0847_ _0848_ _0850_ _0852_ _0853_ VGND VGND VPWR VPWR _0855_ sky130_fd_sc_hd__o2111a_1
XFILLER_82_643 VGND VGND VPWR VPWR sky130_fd_sc_hd__fill_1
X_2118_ B_reg\[8\] _1374_ _1375_ VGND VGND VPWR VPWR _1377_ sky130_fd_sc_hd__o21ai_1
X_3098_ _0762_ _0785_ VGND VGND VPWR VPWR _0786_ sky130_fd_sc_hd__nor2_1
X_2049_ B_reg\[6\] _1306_ VGND VGND VPWR VPWR _1311_ sky130_fd_sc_hd__xnor2_1
XFILLER_14_209 VPWR VGND VPWR VGND sky130_ef_sc_hd__decap_12
XFILLER_70_849 VPWR VGND VPWR VGND sky130_ef_sc_hd__decap_12
XFILLER_23_721 VGND VGND VPWR VPWR sky130_fd_sc_hd__decap_6
XTAP_TAPCELL_ROW_25_727 VGND VPWR sky130_fd_sc_hd__tapvpwrvgnd_1
XTAP_TAPCELL_ROW_25_738 VGND VPWR sky130_fd_sc_hd__tapvpwrvgnd_1
XFILLER_80_29 VPWR VGND VPWR VGND sky130_ef_sc_hd__decap_12
XFILLER_22_242 VGND VGND VPWR VPWR sky130_fd_sc_hd__fill_1
XFILLER_23_765 VPWR VGND VPWR VGND sky130_ef_sc_hd__decap_12
XANTENNA__1804__A1 A_reg\[4\] VGND VGND VPWR VPWR sky130_fd_sc_hd__diode_2
XTAP_TAPCELL_ROW_118_2213 VGND VPWR sky130_fd_sc_hd__tapvpwrvgnd_1
XFILLER_136_601 VPWR VGND VPWR VGND sky130_ef_sc_hd__decap_12
XTAP_TAPCELL_ROW_118_2224 VGND VPWR sky130_fd_sc_hd__tapvpwrvgnd_1
XFILLER_7_909 VGND VGND VPWR VPWR sky130_fd_sc_hd__fill_1
XFILLER_135_111 VGND VGND VPWR VPWR sky130_fd_sc_hd__fill_1
XANTENNA__1827__A A_reg\[1\] VGND VGND VPWR VPWR sky130_fd_sc_hd__diode_2
XFILLER_136_645 VPWR VGND VPWR VGND sky130_ef_sc_hd__decap_12
XTAP_TAPCELL_ROW_131_2424 VGND VPWR sky130_fd_sc_hd__tapvpwrvgnd_1
XTAP_TAPCELL_ROW_98_1898 VGND VPWR sky130_fd_sc_hd__tapvpwrvgnd_1
XFILLER_151_615 VGND VGND VPWR VPWR sky130_fd_sc_hd__fill_1
XTAP_TAPCELL_ROW_131_2435 VGND VPWR sky130_fd_sc_hd__tapvpwrvgnd_1
XFILLER_123_317 VPWR VGND VPWR VGND sky130_ef_sc_hd__decap_12
XFILLER_2_636 VGND VGND VPWR VPWR sky130_fd_sc_hd__decap_3
XFILLER_1_113 VPWR VGND VPWR VGND sky130_ef_sc_hd__decap_12
XFILLER_145_55 VGND VGND VPWR VPWR sky130_fd_sc_hd__fill_1
XFILLER_78_905 VGND VGND VPWR VPWR sky130_fd_sc_hd__decap_4
XFILLER_2_669 VPWR VGND VPWR VGND sky130_ef_sc_hd__decap_12
XFILLER_131_361 VPWR VGND VPWR VGND sky130_ef_sc_hd__decap_12
XTAP_TAPCELL_ROW_51_1150 VGND VPWR sky130_fd_sc_hd__tapvpwrvgnd_1
XFILLER_38_53 VPWR VGND VPWR VGND sky130_ef_sc_hd__decap_12
XTAP_TAPCELL_ROW_129_2397 VGND VPWR sky130_fd_sc_hd__tapvpwrvgnd_1
XFILLER_100_781 VPWR VGND VPWR VGND sky130_ef_sc_hd__decap_12
XFILLER_64_109 VPWR VGND VPWR VGND sky130_ef_sc_hd__decap_12
XFILLER_57_161 VGND VGND VPWR VPWR sky130_fd_sc_hd__decap_6
XFILLER_38_97 VPWR VGND VPWR VGND sky130_ef_sc_hd__decap_12
XFILLER_72_120 VGND VGND VPWR VPWR sky130_fd_sc_hd__decap_8
XFILLER_73_665 VGND VGND VPWR VPWR sky130_fd_sc_hd__decap_6
XFILLER_54_41 VPWR VGND VPWR VGND sky130_ef_sc_hd__decap_12
XTAP_TAPCELL_ROW_142_2597 VGND VPWR sky130_fd_sc_hd__tapvpwrvgnd_1
XFILLER_72_197 VPWR VGND VPWR VGND sky130_ef_sc_hd__decap_12
XFILLER_54_85 VPWR VGND VPWR VGND sky130_ef_sc_hd__decap_12
XFILLER_41_573 VPWR VGND VPWR VGND sky130_ef_sc_hd__decap_12
XFILLER_139_461 VPWR VGND VPWR VGND sky130_ef_sc_hd__decap_12
XFILLER_9_279 VGND VGND VPWR VPWR sky130_fd_sc_hd__fill_1
XFILLER_126_133 VGND VGND VPWR VPWR sky130_fd_sc_hd__decap_6
XFILLER_126_177 VPWR VGND VPWR VGND sky130_ef_sc_hd__decap_12
XFILLER_108_881 VPWR VGND VPWR VGND sky130_ef_sc_hd__decap_12
XFILLER_5_441 VGND VGND VPWR VPWR sky130_fd_sc_hd__decap_6
XTAP_TAPCELL_ROW_149_2718 VGND VPWR sky130_fd_sc_hd__tapvpwrvgnd_1
XFILLER_142_637 VGND VGND VPWR VPWR sky130_fd_sc_hd__decap_6
XFILLER_141_125 VPWR VGND VPWR VGND sky130_ef_sc_hd__decap_12
XFILLER_5_485 VPWR VGND VPWR VGND sky130_ef_sc_hd__decap_12
XFILLER_141_169 VPWR VGND VPWR VGND sky130_ef_sc_hd__decap_12
XFILLER_96_713 VPWR VGND VPWR VGND sky130_ef_sc_hd__decap_12
XFILLER_79_93 VPWR VGND VPWR VGND sky130_ef_sc_hd__decap_12
XFILLER_150_681 VPWR VGND VPWR VGND sky130_ef_sc_hd__decap_12
XFILLER_123_895 VGND VGND VPWR VPWR sky130_fd_sc_hd__fill_1
XANTENNA__3303__RESET_B net36 VGND VGND VPWR VPWR sky130_fd_sc_hd__diode_2
XFILLER_110_545 VPWR VGND VPWR VGND sky130_ef_sc_hd__decap_12
XFILLER_96_757 VPWR VGND VPWR VGND sky130_ef_sc_hd__decap_12
XFILLER_110_589 VPWR VGND VPWR VGND sky130_ef_sc_hd__decap_12
XFILLER_83_429 VPWR VGND VPWR VGND sky130_ef_sc_hd__decap_12
X_3021_ _0683_ _0684_ VGND VGND VPWR VPWR _0709_ sky130_fd_sc_hd__xor2_1
XANTENNA__2287__A1 Encode_EN VGND VGND VPWR VPWR sky130_fd_sc_hd__diode_2
XFILLER_49_673 VPWR VGND VPWR VGND sky130_ef_sc_hd__decap_12
XTAP_TAPCELL_ROW_69_1433 VGND VPWR sky130_fd_sc_hd__tapvpwrvgnd_1
XFILLER_64_643 VGND VGND VPWR VPWR sky130_fd_sc_hd__fill_1
XFILLER_36_345 VGND VGND VPWR VPWR sky130_fd_sc_hd__decap_4
XANTENNA__2039__A1 B_reg\[7\] VGND VGND VPWR VPWR sky130_fd_sc_hd__diode_2
XFILLER_51_337 VGND VGND VPWR VPWR sky130_fd_sc_hd__decap_6
XFILLER_36_389 VPWR VGND VPWR VGND sky130_ef_sc_hd__decap_12
XTAP_TAPCELL_ROW_82_1644 VGND VPWR sky130_fd_sc_hd__tapvpwrvgnd_1
XFILLER_149_225 VPWR VGND VPWR VGND sky130_ef_sc_hd__decap_12
XFILLER_20_713 VPWR VGND VPWR VGND sky130_ef_sc_hd__decap_12
XFILLER_32_562 VPWR VGND VPWR VGND sky130_ef_sc_hd__decap_12
X_2805_ _0184_ _0543_ _0544_ _0910_ u_crt.r3\[0\] VGND VGND VPWR VPWR _0037_ sky130_fd_sc_hd__a32o_1
XFILLER_20_757 VPWR VGND VPWR VGND sky130_ef_sc_hd__decap_12
XFILLER_118_601 VPWR VGND VPWR VGND sky130_ef_sc_hd__decap_12
XFILLER_118_645 VPWR VGND VPWR VGND sky130_ef_sc_hd__decap_12
XFILLER_117_111 VGND VGND VPWR VPWR sky130_fd_sc_hd__fill_1
X_2736_ _0443_ _0446_ _0475_ VGND VGND VPWR VPWR _0476_ sky130_fd_sc_hd__a21o_1
XFILLER_133_615 VGND VGND VPWR VPWR sky130_fd_sc_hd__fill_1
XTAP_TAPCELL_ROW_113_2143 VGND VPWR sky130_fd_sc_hd__tapvpwrvgnd_1
XTAP_TAPCELL_ROW_113_2132 VGND VPWR sky130_fd_sc_hd__tapvpwrvgnd_1
XFILLER_105_317 VPWR VGND VPWR VGND sky130_ef_sc_hd__decap_12
X_2667_ OpSel_reg\[0\] _0406_ VGND VGND VPWR VPWR _0407_ sky130_fd_sc_hd__nand2_1
XFILLER_145_497 VGND VGND VPWR VPWR sky130_fd_sc_hd__decap_6
X_1618_ B_reg\[12\] VGND VGND VPWR VPWR _0898_ sky130_fd_sc_hd__inv_2
XFILLER_120_309 VPWR VGND VPWR VGND sky130_ef_sc_hd__decap_12
XFILLER_99_551 VGND VGND VPWR VPWR sky130_fd_sc_hd__decap_8
X_2598_ _0186_ _0342_ VGND VGND VPWR VPWR _0343_ sky130_fd_sc_hd__nor2_1
XFILLER_113_361 VPWR VGND VPWR VGND sky130_ef_sc_hd__decap_12
XFILLER_99_595 VPWR VGND VPWR VGND sky130_ef_sc_hd__decap_12
XFILLER_87_724 VGND VGND VPWR VPWR sky130_fd_sc_hd__decap_4
XANTENNA__2478__A _0188_ VGND VGND VPWR VPWR sky130_fd_sc_hd__diode_2
XFILLER_115_69 VPWR VGND VPWR VGND sky130_ef_sc_hd__decap_12
XFILLER_86_245 VGND VGND VPWR VPWR sky130_fd_sc_hd__decap_6
X_3219_ clknet_3_3__leaf_clk _0007_ net36 VGND VGND VPWR VPWR a_r0\[1\] sky130_fd_sc_hd__dfrtp_2
XFILLER_74_418 VGND VGND VPWR VPWR sky130_fd_sc_hd__fill_2
XANTENNA__2278__A1 A_reg\[0\] VGND VGND VPWR VPWR sky130_fd_sc_hd__diode_2
XFILLER_28_813 VPWR VGND VPWR VGND sky130_ef_sc_hd__decap_12
XFILLER_39_161 VGND VGND VPWR VPWR sky130_fd_sc_hd__decap_6
XFILLER_46_109 VPWR VGND VPWR VGND sky130_ef_sc_hd__decap_12
XFILLER_131_57 VPWR VGND VPWR VGND sky130_ef_sc_hd__decap_12
XPHY_EDGE_ROW_19_Left_173 VGND VGND VPWR VPWR sky130_fd_sc_hd__decap_3
XFILLER_70_613 VGND VGND VPWR VPWR sky130_fd_sc_hd__fill_1
XFILLER_54_197 VPWR VGND VPWR VGND sky130_ef_sc_hd__decap_12
XFILLER_15_529 VPWR VGND VPWR VGND sky130_ef_sc_hd__decap_12
XFILLER_70_657 VPWR VGND VPWR VGND sky130_ef_sc_hd__decap_12
XFILLER_23_573 VPWR VGND VPWR VGND sky130_ef_sc_hd__decap_12
XFILLER_24_77 VGND VGND VPWR VPWR sky130_fd_sc_hd__decap_6
XFILLER_10_245 VGND VGND VPWR VPWR sky130_fd_sc_hd__decap_6
XFILLER_108_133 VGND VGND VPWR VPWR sky130_fd_sc_hd__decap_6
XANTENNA__2202__A1 A_reg\[7\] VGND VGND VPWR VPWR sky130_fd_sc_hd__diode_2
XPHY_EDGE_ROW_28_Left_182 VGND VGND VPWR VPWR sky130_fd_sc_hd__decap_3
XFILLER_136_475 VGND VGND VPWR VPWR sky130_fd_sc_hd__fill_1
XFILLER_108_177 VPWR VGND VPWR VGND sky130_ef_sc_hd__decap_12
XFILLER_40_65 VPWR VGND VPWR VGND sky130_ef_sc_hd__decap_12
XFILLER_124_637 VGND VGND VPWR VPWR sky130_fd_sc_hd__decap_6
XFILLER_123_125 VPWR VGND VPWR VGND sky130_ef_sc_hd__decap_12
XFILLER_123_169 VPWR VGND VPWR VGND sky130_ef_sc_hd__decap_12
XFILLER_78_713 VPWR VGND VPWR VGND sky130_ef_sc_hd__decap_12
XFILLER_2_433 VGND VGND VPWR VPWR sky130_fd_sc_hd__fill_2
XFILLER_132_681 VPWR VGND VPWR VGND sky130_ef_sc_hd__decap_12
XFILLER_105_895 VGND VGND VPWR VPWR sky130_fd_sc_hd__fill_1
XFILLER_104_361 VGND VGND VPWR VPWR sky130_fd_sc_hd__fill_1
XFILLER_77_223 VGND VGND VPWR VPWR sky130_fd_sc_hd__fill_1
XFILLER_2_477 VGND VGND VPWR VPWR sky130_fd_sc_hd__fill_2
XFILLER_78_757 VPWR VGND VPWR VGND sky130_ef_sc_hd__decap_12
XTAP_TAPCELL_ROW_144_2637 VGND VPWR sky130_fd_sc_hd__tapvpwrvgnd_1
XFILLER_93_727 VGND VGND VPWR VPWR sky130_fd_sc_hd__fill_1
XFILLER_65_429 VPWR VGND VPWR VGND sky130_ef_sc_hd__decap_12
XFILLER_58_470 VGND VGND VPWR VPWR sky130_fd_sc_hd__decap_6
XFILLER_1_15 VPWR VGND VPWR VGND sky130_ef_sc_hd__decap_12
XFILLER_18_301 VGND VGND VPWR VPWR sky130_fd_sc_hd__decap_6
XANTENNA__3280__Q A_reg\[6\] VGND VGND VPWR VPWR sky130_fd_sc_hd__diode_2
XFILLER_65_40 VPWR VGND VPWR VGND sky130_ef_sc_hd__decap_12
XFILLER_46_643 VGND VGND VPWR VPWR sky130_fd_sc_hd__fill_1
XPHY_EDGE_ROW_37_Left_191 VGND VGND VPWR VPWR sky130_fd_sc_hd__decap_3
XFILLER_46_676 VPWR VGND VPWR VGND sky130_ef_sc_hd__decap_12
XFILLER_18_345 VGND VGND VPWR VPWR sky130_fd_sc_hd__decap_8
XFILLER_73_473 VGND VGND VPWR VPWR sky130_fd_sc_hd__fill_2
XFILLER_33_337 VGND VGND VPWR VPWR sky130_fd_sc_hd__decap_8
XFILLER_34_849 VPWR VGND VPWR VGND sky130_ef_sc_hd__decap_12
XTAP_TAPCELL_ROW_64_1352 VGND VPWR sky130_fd_sc_hd__tapvpwrvgnd_1
XTAP_TAPCELL_ROW_64_1363 VGND VPWR sky130_fd_sc_hd__tapvpwrvgnd_1
XFILLER_42_893 VPWR VGND VPWR VGND sky130_ef_sc_hd__decap_12
XFILLER_147_729 VPWR VGND VPWR VGND sky130_ef_sc_hd__decap_12
XFILLER_142_401 VPWR VGND VPWR VGND sky130_ef_sc_hd__decap_12
XFILLER_115_615 VGND VGND VPWR VPWR sky130_fd_sc_hd__fill_1
X_2521_ _0232_ _0247_ _0246_ VGND VGND VPWR VPWR _0269_ sky130_fd_sc_hd__o21ba_1
XFILLER_142_445 VPWR VGND VPWR VGND sky130_ef_sc_hd__decap_12
XFILLER_127_497 VGND VGND VPWR VPWR sky130_fd_sc_hd__decap_6
XFILLER_102_309 VPWR VGND VPWR VGND sky130_ef_sc_hd__decap_12
X_2452_ b_r0\[0\] a_r0\[1\] b_r0\[1\] a_r0\[0\] VGND VGND VPWR VPWR _0202_ sky130_fd_sc_hd__a22o_1
XFILLER_142_489 VPWR VGND VPWR VGND sky130_ef_sc_hd__decap_12
XFILLER_111_821 VPWR VGND VPWR VGND sky130_ef_sc_hd__decap_12
X_2383_ _0906_ _0129_ _0132_ VGND VGND VPWR VPWR _0137_ sky130_fd_sc_hd__and3_1
XPHY_EDGE_ROW_18_Right_18 VGND VGND VPWR VPWR sky130_fd_sc_hd__decap_3
XFILLER_111_865 VPWR VGND VPWR VGND sky130_ef_sc_hd__decap_12
XFILLER_68_289 VGND VGND VPWR VPWR sky130_fd_sc_hd__decap_6
XFILLER_28_109 VPWR VGND VPWR VGND sky130_ef_sc_hd__decap_12
XFILLER_83_237 VPWR VGND VPWR VGND sky130_ef_sc_hd__decap_12
X_3004_ _0687_ _0689_ _0690_ VGND VGND VPWR VPWR _0692_ sky130_fd_sc_hd__and3_1
Xinput3 A_in[11] VGND VGND VPWR VPWR net3 sky130_fd_sc_hd__clkbuf_1
XFILLER_36_153 VPWR VGND VPWR VGND sky130_ef_sc_hd__decap_12
XFILLER_37_665 VGND VGND VPWR VPWR sky130_fd_sc_hd__decap_6
XFILLER_92_793 VPWR VGND VPWR VGND sky130_ef_sc_hd__decap_12
XFILLER_91_281 VPWR VGND VPWR VGND sky130_ef_sc_hd__decap_12
XFILLER_52_613 VPWR VGND VPWR VGND sky130_ef_sc_hd__decap_12
XFILLER_101_27 VPWR VGND VPWR VGND sky130_ef_sc_hd__decap_12
XPHY_EDGE_ROW_27_Right_27 VGND VGND VPWR VPWR sky130_fd_sc_hd__decap_3
XFILLER_36_197 VGND VGND VPWR VPWR sky130_fd_sc_hd__decap_3
XTAP_TAPCELL_ROW_35_888 VGND VPWR sky130_fd_sc_hd__tapvpwrvgnd_1
XTAP_TAPCELL_ROW_35_899 VGND VPWR sky130_fd_sc_hd__tapvpwrvgnd_1
XFILLER_137_217 VGND VGND VPWR VPWR sky130_fd_sc_hd__decap_6
XFILLER_20_587 VGND VGND VPWR VPWR sky130_fd_sc_hd__fill_1
XFILLER_152_209 VPWR VGND VPWR VGND sky130_ef_sc_hd__decap_12
XFILLER_145_261 VPWR VGND VPWR VGND sky130_ef_sc_hd__decap_12
XFILLER_118_475 VGND VGND VPWR VPWR sky130_fd_sc_hd__fill_1
X_2719_ _0407_ _0452_ _0457_ _0458_ VGND VGND VPWR VPWR _0459_ sky130_fd_sc_hd__o22a_1
XTAP_TAPCELL_ROW_95_1846 VGND VPWR sky130_fd_sc_hd__tapvpwrvgnd_1
XANTENNA__3296__RESET_B net36 VGND VGND VPWR VPWR sky130_fd_sc_hd__diode_2
XFILLER_106_637 VGND VGND VPWR VPWR sky130_fd_sc_hd__decap_6
XFILLER_105_125 VPWR VGND VPWR VGND sky130_ef_sc_hd__decap_12
XTAP_TAPCELL_ROW_95_1857 VGND VPWR sky130_fd_sc_hd__tapvpwrvgnd_1
XANTENNA__3225__RESET_B net36 VGND VGND VPWR VPWR sky130_fd_sc_hd__diode_2
XFILLER_105_169 VPWR VGND VPWR VGND sky130_ef_sc_hd__decap_12
XPHY_EDGE_ROW_36_Right_36 VGND VGND VPWR VPWR sky130_fd_sc_hd__decap_3
XFILLER_121_629 VPWR VGND VPWR VGND sky130_ef_sc_hd__decap_12
XFILLER_114_681 VPWR VGND VPWR VGND sky130_ef_sc_hd__decap_12
XFILLER_59_212 VPWR VGND VPWR VGND sky130_ef_sc_hd__decap_12
XFILLER_120_139 VGND VGND VPWR VPWR sky130_fd_sc_hd__fill_1
XFILLER_19_55 VGND VGND VPWR VPWR sky130_fd_sc_hd__fill_1
XTAP_TAPCELL_ROW_126_2345 VGND VPWR sky130_fd_sc_hd__tapvpwrvgnd_1
XFILLER_101_386 VGND VGND VPWR VPWR sky130_fd_sc_hd__decap_6
XFILLER_28_643 VGND VGND VPWR VPWR sky130_fd_sc_hd__fill_1
XANTENNA__1840__A _0911_ VGND VGND VPWR VPWR sky130_fd_sc_hd__diode_2
XFILLER_16_805 VGND VGND VPWR VPWR sky130_fd_sc_hd__decap_6
XFILLER_70_421 VGND VGND VPWR VPWR sky130_fd_sc_hd__decap_8
XFILLER_55_473 VGND VGND VPWR VPWR sky130_fd_sc_hd__decap_6
XFILLER_16_849 VPWR VGND VPWR VGND sky130_ef_sc_hd__decap_12
XPHY_EDGE_ROW_45_Right_45 VGND VGND VPWR VPWR sky130_fd_sc_hd__decap_3
XFILLER_150_3 VPWR VGND VPWR VGND sky130_ef_sc_hd__decap_12
XFILLER_70_432 VPWR VGND VPWR VGND sky130_ef_sc_hd__decap_12
XFILLER_15_337 VPWR VGND VPWR VGND sky130_ef_sc_hd__decap_12
XANTENNA__2671__A a_r3\[1\] VGND VGND VPWR VPWR sky130_fd_sc_hd__diode_2
XTAP_TAPCELL_ROW_46_1071 VGND VPWR sky130_fd_sc_hd__tapvpwrvgnd_1
XTAP_TAPCELL_ROW_46_1060 VGND VPWR sky130_fd_sc_hd__tapvpwrvgnd_1
XTAP_TAPCELL_ROW_104_1997 VGND VPWR sky130_fd_sc_hd__tapvpwrvgnd_1
XFILLER_51_690 VPWR VGND VPWR VGND sky130_ef_sc_hd__decap_12
XTAP_TAPCELL_ROW_13_538 VGND VPWR sky130_fd_sc_hd__tapvpwrvgnd_1
XFILLER_24_893 VPWR VGND VPWR VGND sky130_ef_sc_hd__decap_12
XFILLER_129_729 VPWR VGND VPWR VGND sky130_ef_sc_hd__decap_12
XFILLER_51_86 VGND VGND VPWR VPWR sky130_fd_sc_hd__decap_8
XFILLER_124_401 VPWR VGND VPWR VGND sky130_ef_sc_hd__decap_12
XANTENNA__3275__Q A_reg\[1\] VGND VGND VPWR VPWR sky130_fd_sc_hd__diode_2
XFILLER_7_569 VGND VGND VPWR VPWR sky130_fd_sc_hd__fill_2
XPHY_EDGE_ROW_54_Right_54 VGND VGND VPWR VPWR sky130_fd_sc_hd__decap_3
XFILLER_140_905 VGND VGND VPWR VPWR sky130_fd_sc_hd__decap_4
XFILLER_124_445 VPWR VGND VPWR VGND sky130_ef_sc_hd__decap_12
XFILLER_3_753 VPWR VGND VPWR VGND sky130_ef_sc_hd__decap_12
XFILLER_124_489 VPWR VGND VPWR VGND sky130_ef_sc_hd__decap_12
XFILLER_3_797 VPWR VGND VPWR VGND sky130_ef_sc_hd__decap_12
XFILLER_93_502 VGND VGND VPWR VPWR sky130_fd_sc_hd__fill_2
XFILLER_78_587 VGND VGND VPWR VPWR sky130_fd_sc_hd__fill_1
XFILLER_76_83 VGND VGND VPWR VPWR sky130_fd_sc_hd__fill_1
XANTENNA__1750__A A_reg\[10\] VGND VGND VPWR VPWR sky130_fd_sc_hd__diode_2
XPHY_EDGE_ROW_63_Right_63 VGND VGND VPWR VPWR sky130_fd_sc_hd__decap_3
XFILLER_19_665 VGND VGND VPWR VPWR sky130_fd_sc_hd__decap_6
XFILLER_18_153 VPWR VGND VPWR VGND sky130_ef_sc_hd__decap_12
XFILLER_34_613 VPWR VGND VPWR VGND sky130_ef_sc_hd__decap_12
XFILLER_46_473 VGND VGND VPWR VPWR sky130_fd_sc_hd__decap_3
XFILLER_73_281 VPWR VGND VPWR VGND sky130_ef_sc_hd__decap_12
XFILLER_18_197 VPWR VGND VPWR VGND sky130_ef_sc_hd__decap_12
XFILLER_34_657 VPWR VGND VPWR VGND sky130_ef_sc_hd__decap_12
XFILLER_33_167 VGND VGND VPWR VPWR sky130_fd_sc_hd__fill_1
X_1952_ _1208_ _1212_ VGND VGND VPWR VPWR _1217_ sky130_fd_sc_hd__nor2_1
XFILLER_21_329 VGND VGND VPWR VPWR sky130_fd_sc_hd__decap_6
XTAP_TAPCELL_ROW_32_836 VGND VPWR sky130_fd_sc_hd__tapvpwrvgnd_1
XTAP_TAPCELL_ROW_32_847 VGND VPWR sky130_fd_sc_hd__tapvpwrvgnd_1
XFILLER_119_217 VGND VGND VPWR VPWR sky130_fd_sc_hd__decap_6
X_1883_ _1149_ _0895_ _1150_ VGND VGND VPWR VPWR _1153_ sky130_fd_sc_hd__mux2_1
XFILLER_147_559 VGND VGND VPWR VPWR sky130_fd_sc_hd__fill_1
XFILLER_134_209 VPWR VGND VPWR VGND sky130_ef_sc_hd__decap_12
XPHY_EDGE_ROW_72_Right_72 VGND VGND VPWR VPWR sky130_fd_sc_hd__decap_3
XFILLER_143_721 VGND VGND VPWR VPWR sky130_fd_sc_hd__decap_6
XFILLER_127_261 VPWR VGND VPWR VGND sky130_ef_sc_hd__decap_12
XTAP_TAPCELL_ROW_77_1565 VGND VPWR sky130_fd_sc_hd__tapvpwrvgnd_1
XFILLER_143_765 VPWR VGND VPWR VGND sky130_ef_sc_hd__decap_12
XFILLER_142_253 VPWR VGND VPWR VGND sky130_ef_sc_hd__decap_12
X_2504_ a_r1\[0\] b_r1\[2\] _0250_ _0251_ VGND VGND VPWR VPWR _0252_ sky130_fd_sc_hd__and4_1
XFILLER_103_629 VPWR VGND VPWR VGND sky130_ef_sc_hd__decap_12
X_2435_ OpSel_reg\[0\] OpSel_reg\[1\] VGND VGND VPWR VPWR _0185_ sky130_fd_sc_hd__nor2_4
XFILLER_102_139 VGND VGND VPWR VPWR sky130_fd_sc_hd__fill_1
XFILLER_97_841 VPWR VGND VPWR VGND sky130_ef_sc_hd__decap_12
XTAP_TAPCELL_ROW_90_1776 VGND VPWR sky130_fd_sc_hd__tapvpwrvgnd_1
XTAP_TAPCELL_ROW_90_1765 VGND VPWR sky130_fd_sc_hd__tapvpwrvgnd_1
XFILLER_69_543 VPWR VGND VPWR VGND sky130_ef_sc_hd__decap_12
XANTENNA__1689__C1 A_reg\[6\] VGND VGND VPWR VPWR sky130_fd_sc_hd__diode_2
XFILLER_111_673 VPWR VGND VPWR VGND sky130_ef_sc_hd__decap_12
XFILLER_96_362 VGND VGND VPWR VPWR sky130_fd_sc_hd__fill_2
X_2366_ _0115_ _0118_ _0113_ VGND VGND VPWR VPWR _0120_ sky130_fd_sc_hd__a21o_1
XFILLER_57_727 VGND VGND VPWR VPWR sky130_fd_sc_hd__fill_1
XFILLER_84_524 VGND VGND VPWR VPWR sky130_fd_sc_hd__decap_6
XPHY_EDGE_ROW_81_Right_81 VGND VGND VPWR VPWR sky130_fd_sc_hd__decap_3
X_2297_ B_reg\[13\] _1549_ _1175_ VGND VGND VPWR VPWR _1550_ sky130_fd_sc_hd__o21bai_2
XFILLER_29_429 VPWR VGND VPWR VGND sky130_ef_sc_hd__decap_12
XFILLER_112_15 VPWR VGND VPWR VGND sky130_ef_sc_hd__decap_12
XTAP_TAPCELL_ROW_108_2064 VGND VPWR sky130_fd_sc_hd__tapvpwrvgnd_1
XTAP_TAPCELL_ROW_108_2053 VGND VPWR sky130_fd_sc_hd__tapvpwrvgnd_1
XFILLER_65_782 VGND VGND VPWR VPWR sky130_fd_sc_hd__fill_2
XFILLER_37_473 VGND VGND VPWR VPWR sky130_fd_sc_hd__fill_2
XFILLER_80_730 VPWR VGND VPWR VGND sky130_ef_sc_hd__decap_12
XFILLER_52_421 VPWR VGND VPWR VGND sky130_ef_sc_hd__decap_12
XTAP_TAPCELL_ROW_121_2275 VGND VPWR sky130_fd_sc_hd__tapvpwrvgnd_1
XTAP_TAPCELL_ROW_121_2264 VGND VPWR sky130_fd_sc_hd__tapvpwrvgnd_1
XFILLER_12_307 VGND VGND VPWR VPWR sky130_fd_sc_hd__fill_1
XFILLER_21_841 VPWR VGND VPWR VGND sky130_ef_sc_hd__decap_12
XFILLER_24_189 VGND VGND VPWR VPWR sky130_fd_sc_hd__decap_6
XPHY_EDGE_ROW_90_Right_90 VGND VGND VPWR VPWR sky130_fd_sc_hd__decap_3
XFILLER_153_529 VGND VGND VPWR VPWR sky130_fd_sc_hd__decap_3
XFILLER_4_506 VGND VGND VPWR VPWR sky130_fd_sc_hd__decap_3
XFILLER_146_581 VGND VGND VPWR VPWR sky130_fd_sc_hd__decap_6
XFILLER_4_539 VPWR VGND VPWR VGND sky130_ef_sc_hd__decap_12
XFILLER_122_905 VGND VGND VPWR VPWR sky130_fd_sc_hd__decap_4
XANTENNA__2430__S Encode_EN VGND VGND VPWR VPWR sky130_fd_sc_hd__diode_2
XFILLER_106_489 VPWR VGND VPWR VGND sky130_ef_sc_hd__decap_12
XFILLER_79_318 VPWR VGND VPWR VGND sky130_ef_sc_hd__decap_12
XFILLER_0_701 VPWR VGND VPWR VGND sky130_ef_sc_hd__decap_12
XFILLER_87_373 VPWR VGND VPWR VGND sky130_ef_sc_hd__decap_12
XFILLER_101_161 VGND VGND VPWR VPWR sky130_fd_sc_hd__decap_6
XFILLER_46_20 VGND VGND VPWR VPWR sky130_fd_sc_hd__decap_8
XTAP_TAPCELL_ROW_48_1100 VGND VPWR sky130_fd_sc_hd__tapvpwrvgnd_1
XFILLER_16_613 VPWR VGND VPWR VGND sky130_ef_sc_hd__decap_12
XTAP_TAPCELL_ROW_18_619 VGND VPWR sky130_fd_sc_hd__tapvpwrvgnd_1
XFILLER_46_53 VPWR VGND VPWR VGND sky130_ef_sc_hd__decap_12
XFILLER_71_741 VPWR VGND VPWR VGND sky130_ef_sc_hd__decap_12
XFILLER_55_281 VPWR VGND VPWR VGND sky130_ef_sc_hd__decap_12
XFILLER_16_657 VPWR VGND VPWR VGND sky130_ef_sc_hd__decap_12
XFILLER_46_97 VPWR VGND VPWR VGND sky130_ef_sc_hd__decap_12
XFILLER_71_785 VPWR VGND VPWR VGND sky130_ef_sc_hd__decap_12
XFILLER_70_251 VGND VGND VPWR VPWR sky130_fd_sc_hd__fill_1
XTAP_TAPCELL_ROW_61_1300 VGND VPWR sky130_fd_sc_hd__tapvpwrvgnd_1
XFILLER_15_167 VGND VGND VPWR VPWR sky130_fd_sc_hd__fill_1
XFILLER_62_41 VPWR VGND VPWR VGND sky130_ef_sc_hd__decap_12
XTAP_TAPCELL_ROW_61_1311 VGND VPWR sky130_fd_sc_hd__tapvpwrvgnd_1
XTAP_TAPCELL_ROW_139_2558 VGND VPWR sky130_fd_sc_hd__tapvpwrvgnd_1
XFILLER_129_559 VGND VGND VPWR VPWR sky130_fd_sc_hd__fill_1
XFILLER_11_373 VPWR VGND VPWR VGND sky130_ef_sc_hd__decap_12
XTAP_TAPCELL_ROW_152_2758 VGND VPWR sky130_fd_sc_hd__tapvpwrvgnd_1
XFILLER_116_209 VPWR VGND VPWR VGND sky130_ef_sc_hd__decap_12
XFILLER_8_867 VGND VGND VPWR VPWR sky130_fd_sc_hd__fill_1
XFILLER_7_69 VPWR VGND VPWR VGND sky130_ef_sc_hd__decap_12
XTAP_TAPCELL_ROW_152_2769 VGND VPWR sky130_fd_sc_hd__tapvpwrvgnd_1
XFILLER_125_721 VGND VGND VPWR VPWR sky130_fd_sc_hd__decap_6
XFILLER_109_261 VPWR VGND VPWR VGND sky130_ef_sc_hd__decap_12
XFILLER_125_765 VPWR VGND VPWR VGND sky130_ef_sc_hd__decap_12
XTAP_TAPCELL_ROW_59_1273 VGND VPWR sky130_fd_sc_hd__tapvpwrvgnd_1
XFILLER_152_573 VPWR VGND VPWR VGND sky130_ef_sc_hd__decap_12
XFILLER_140_713 VPWR VGND VPWR VGND sky130_ef_sc_hd__decap_12
XFILLER_124_253 VPWR VGND VPWR VGND sky130_ef_sc_hd__decap_12
XFILLER_3_561 VGND VGND VPWR VPWR sky130_fd_sc_hd__decap_8
XFILLER_140_757 VPWR VGND VPWR VGND sky130_ef_sc_hd__decap_12
XFILLER_97_137 VPWR VGND VPWR VGND sky130_ef_sc_hd__decap_12
XFILLER_79_841 VPWR VGND VPWR VGND sky130_ef_sc_hd__decap_12
XANTENNA__3251__CLK clknet_3_4__leaf_clk VGND VGND VPWR VPWR sky130_fd_sc_hd__diode_2
X_2220_ _1475_ _1476_ VGND VGND VPWR VPWR _1477_ sky130_fd_sc_hd__or2_1
XFILLER_94_811 VGND VGND VPWR VPWR sky130_fd_sc_hd__fill_1
XTAP_TAPCELL_ROW_72_1484 VGND VPWR sky130_fd_sc_hd__tapvpwrvgnd_1
XFILLER_66_513 VPWR VGND VPWR VGND sky130_ef_sc_hd__decap_12
X_2151_ A_reg\[15\] A_reg\[14\] A_reg\[12\] VGND VGND VPWR VPWR _1408_ sky130_fd_sc_hd__a21o_1
XFILLER_93_343 VGND VGND VPWR VPWR sky130_fd_sc_hd__decap_8
X_2082_ _1341_ _1343_ B_reg\[1\] VGND VGND VPWR VPWR _1344_ sky130_fd_sc_hd__a21oi_1
XFILLER_66_557 VPWR VGND VPWR VGND sky130_ef_sc_hd__decap_12
XFILLER_19_473 VPWR VGND VPWR VGND sky130_ef_sc_hd__decap_12
XTAP_TAPCELL_ROW_37_917 VGND VPWR sky130_fd_sc_hd__tapvpwrvgnd_1
XTAP_TAPCELL_ROW_37_928 VGND VPWR sky130_fd_sc_hd__tapvpwrvgnd_1
XFILLER_34_421 VPWR VGND VPWR VGND sky130_ef_sc_hd__decap_12
X_2984_ _0670_ _0671_ VGND VGND VPWR VPWR _0672_ sky130_fd_sc_hd__or2_1
XFILLER_61_295 VGND VGND VPWR VPWR sky130_fd_sc_hd__decap_8
XFILLER_61_273 VGND VGND VPWR VPWR sky130_fd_sc_hd__decap_6
XFILLER_148_813 VPWR VGND VPWR VGND sky130_ef_sc_hd__decap_12
X_1935_ B_reg\[9\] _1194_ _1190_ VGND VGND VPWR VPWR _1200_ sky130_fd_sc_hd__a21oi_1
XANTENNA__1639__B A_reg\[13\] VGND VGND VPWR VPWR sky130_fd_sc_hd__diode_2
XFILLER_21_137 VPWR VGND VPWR VGND sky130_ef_sc_hd__decap_12
XFILLER_30_693 VGND VGND VPWR VPWR sky130_fd_sc_hd__decap_6
X_1866_ _1134_ _1135_ VGND VGND VPWR VPWR _1136_ sky130_fd_sc_hd__nor2_1
XFILLER_135_529 VPWR VGND VPWR VGND sky130_ef_sc_hd__decap_12
XFILLER_128_581 VGND VGND VPWR VPWR sky130_fd_sc_hd__decap_6
X_1797_ _1063_ _1069_ _0894_ VGND VGND VPWR VPWR _1070_ sky130_fd_sc_hd__o21ai_1
XFILLER_104_905 VGND VGND VPWR VPWR sky130_fd_sc_hd__decap_4
XTAP_TAPCELL_ROW_92_1805 VGND VPWR sky130_fd_sc_hd__tapvpwrvgnd_1
XFILLER_143_573 VPWR VGND VPWR VGND sky130_ef_sc_hd__decap_12
XFILLER_107_15 VPWR VGND VPWR VGND sky130_ef_sc_hd__decap_12
XFILLER_130_245 VGND VGND VPWR VPWR sky130_fd_sc_hd__decap_6
XFILLER_97_671 VGND VGND VPWR VPWR sky130_fd_sc_hd__fill_1
X_2418_ _0143_ _0144_ _0162_ _0163_ VGND VGND VPWR VPWR _0172_ sky130_fd_sc_hd__o31a_1
XFILLER_130_289 VPWR VGND VPWR VGND sky130_ef_sc_hd__decap_12
XFILLER_85_833 VGND VGND VPWR VPWR sky130_fd_sc_hd__decap_6
XFILLER_84_321 VGND VGND VPWR VPWR sky130_fd_sc_hd__decap_4
X_2349_ _1592_ _1601_ VGND VGND VPWR VPWR _1602_ sky130_fd_sc_hd__xnor2_1
XFILLER_69_373 VPWR VGND VPWR VGND sky130_ef_sc_hd__decap_12
XANTENNA__2486__A OpSel_reg\[0\] VGND VGND VPWR VPWR sky130_fd_sc_hd__diode_2
XTAP_TAPCELL_ROW_123_2304 VGND VPWR sky130_fd_sc_hd__tapvpwrvgnd_1
XFILLER_85_877 VPWR VGND VPWR VGND sky130_ef_sc_hd__decap_12
XFILLER_84_332 VPWR VGND VPWR VGND sky130_ef_sc_hd__decap_12
XFILLER_72_505 VGND VGND VPWR VPWR sky130_fd_sc_hd__fill_2
XFILLER_123_69 VPWR VGND VPWR VGND sky130_ef_sc_hd__decap_12
XFILLER_84_365 VPWR VGND VPWR VGND sky130_ef_sc_hd__decap_12
XFILLER_72_516 VPWR VGND VPWR VGND sky130_ef_sc_hd__decap_12
XFILLER_38_793 VPWR VGND VPWR VGND sky130_ef_sc_hd__decap_12
XFILLER_53_741 VPWR VGND VPWR VGND sky130_ef_sc_hd__decap_12
XFILLER_37_281 VPWR VGND VPWR VGND sky130_ef_sc_hd__decap_12
XFILLER_53_785 VPWR VGND VPWR VGND sky130_ef_sc_hd__decap_12
XPHY_EDGE_ROW_0_Right_0 VGND VGND VPWR VPWR sky130_fd_sc_hd__decap_3
XFILLER_138_301 VGND VGND VPWR VPWR sky130_fd_sc_hd__decap_6
XTAP_TAPCELL_ROW_101_1945 VGND VPWR sky130_fd_sc_hd__tapvpwrvgnd_1
XFILLER_9_609 VGND VGND VPWR VPWR sky130_fd_sc_hd__decap_6
XFILLER_40_457 VPWR VGND VPWR VGND sky130_ef_sc_hd__decap_12
XFILLER_21_671 VGND VGND VPWR VPWR sky130_fd_sc_hd__fill_1
XTAP_TAPCELL_ROW_23_699 VGND VPWR sky130_fd_sc_hd__tapvpwrvgnd_1
XANTENNA__3240__RESET_B net36 VGND VGND VPWR VPWR sky130_fd_sc_hd__diode_2
XFILLER_138_345 VPWR VGND VPWR VGND sky130_ef_sc_hd__decap_12
XANTENNA_clkbuf_3_2__f_clk_X clknet_3_2__leaf_clk VGND VGND VPWR VPWR sky130_fd_sc_hd__diode_2
XFILLER_32_77 VGND VGND VPWR VPWR sky130_fd_sc_hd__decap_6
XFILLER_153_337 VPWR VGND VPWR VGND sky130_ef_sc_hd__decap_12
XFILLER_148_77 VGND VGND VPWR VPWR sky130_fd_sc_hd__decap_6
XFILLER_138_389 VPWR VGND VPWR VGND sky130_ef_sc_hd__decap_12
XTAP_TAPCELL_ROW_134_2477 VGND VPWR sky130_fd_sc_hd__tapvpwrvgnd_1
XFILLER_113_3 VPWR VGND VPWR VGND sky130_ef_sc_hd__decap_12
XFILLER_107_721 VGND VGND VPWR VPWR sky130_fd_sc_hd__decap_6
XANTENNA__3274__CLK clknet_3_4__leaf_clk VGND VGND VPWR VPWR sky130_fd_sc_hd__diode_2
XFILLER_107_765 VPWR VGND VPWR VGND sky130_ef_sc_hd__decap_12
XFILLER_122_713 VPWR VGND VPWR VGND sky130_ef_sc_hd__decap_12
XFILLER_106_253 VPWR VGND VPWR VGND sky130_ef_sc_hd__decap_12
XFILLER_122_757 VPWR VGND VPWR VGND sky130_ef_sc_hd__decap_12
XFILLER_121_223 VGND VGND VPWR VPWR sky130_fd_sc_hd__fill_1
XANTENNA_input33_A Op_Sel[0] VGND VGND VPWR VPWR sky130_fd_sc_hd__diode_2
XFILLER_102_470 VGND VGND VPWR VPWR sky130_fd_sc_hd__decap_3
XTAP_TAPCELL_ROW_54_1192 VGND VPWR sky130_fd_sc_hd__tapvpwrvgnd_1
XFILLER_48_513 VPWR VGND VPWR VGND sky130_ef_sc_hd__decap_12
XFILLER_0_597 VGND VGND VPWR VPWR sky130_fd_sc_hd__fill_1
XFILLER_48_557 VGND VGND VPWR VPWR sky130_fd_sc_hd__decap_3
XFILLER_63_505 VGND VGND VPWR VPWR sky130_fd_sc_hd__decap_4
XTAP_TAPCELL_ROW_3_380 VGND VPWR sky130_fd_sc_hd__tapvpwrvgnd_1
XPHY_EDGE_ROW_121_Right_121 VGND VGND VPWR VPWR sky130_fd_sc_hd__decap_3
XFILLER_16_421 VPWR VGND VPWR VGND sky130_ef_sc_hd__decap_12
XFILLER_90_379 VGND VGND VPWR VPWR sky130_fd_sc_hd__decap_4
XFILLER_73_51 VGND VGND VPWR VPWR sky130_fd_sc_hd__decap_4
XFILLER_16_443 VPWR VGND VPWR VGND sky130_ef_sc_hd__decap_12
XFILLER_44_752 VGND VGND VPWR VPWR sky130_fd_sc_hd__decap_4
XFILLER_44_763 VGND VGND VPWR VPWR sky130_fd_sc_hd__fill_1
XFILLER_92_8 VPWR VGND VPWR VGND sky130_ef_sc_hd__decap_12
XFILLER_148_109 VPWR VGND VPWR VGND sky130_ef_sc_hd__decap_12
XTAP_TAPCELL_ROW_42_997 VGND VPWR sky130_fd_sc_hd__tapvpwrvgnd_1
X_1720_ A_reg\[1\] _0992_ VGND VGND VPWR VPWR _0996_ sky130_fd_sc_hd__xor2_1
XFILLER_11_181 VPWR VGND VPWR VGND sky130_ef_sc_hd__decap_12
XFILLER_12_693 VGND VGND VPWR VPWR sky130_fd_sc_hd__decap_6
XFILLER_117_529 VPWR VGND VPWR VGND sky130_ef_sc_hd__decap_12
X_1651_ A_reg\[15\] A_reg\[13\] A_reg\[12\] VGND VGND VPWR VPWR _0927_ sky130_fd_sc_hd__nand3_1
XTAP_TAPCELL_ROW_74_1513 VGND VPWR sky130_fd_sc_hd__tapvpwrvgnd_1
XFILLER_153_893 VGND VGND VPWR VPWR sky130_fd_sc_hd__decap_3
XFILLER_125_573 VPWR VGND VPWR VGND sky130_ef_sc_hd__decap_12
X_3321_ clknet_3_5__leaf_clk _0104_ net36 VGND VGND VPWR VPWR X_crt\[15\] sky130_fd_sc_hd__dfrtp_1
XFILLER_4_881 VPWR VGND VPWR VGND sky130_ef_sc_hd__decap_12
XFILLER_112_245 VGND VGND VPWR VPWR sky130_fd_sc_hd__decap_6
XFILLER_100_407 VGND VGND VPWR VPWR sky130_fd_sc_hd__fill_1
X_3252_ clknet_3_6__leaf_clk _0035_ net36 VGND VGND VPWR VPWR OpSel_reg\[0\] sky130_fd_sc_hd__dfrtp_4
XFILLER_140_587 VGND VGND VPWR VPWR sky130_fd_sc_hd__fill_1
XFILLER_112_289 VPWR VGND VPWR VGND sky130_ef_sc_hd__decap_12
XANTENNA__2856__A1 B_reg\[6\] VGND VGND VPWR VPWR sky130_fd_sc_hd__diode_2
XFILLER_67_833 VGND VGND VPWR VPWR sky130_fd_sc_hd__decap_6
XFILLER_66_321 VPWR VGND VPWR VGND sky130_ef_sc_hd__decap_12
X_2203_ A_reg\[8\] _1431_ _1441_ VGND VGND VPWR VPWR _1460_ sky130_fd_sc_hd__nand3_1
X_3183_ X_crt\[3\] CRT_Start VGND VGND VPWR VPWR _0868_ sky130_fd_sc_hd__nor2_1
X_2134_ _1390_ _1392_ _0907_ VGND VGND VPWR VPWR _1393_ sky130_fd_sc_hd__a21o_1
XFILLER_67_877 VPWR VGND VPWR VGND sky130_ef_sc_hd__decap_12
XTAP_TAPCELL_ROW_105_2012 VGND VPWR sky130_fd_sc_hd__tapvpwrvgnd_1
XFILLER_82_825 VPWR VGND VPWR VGND sky130_ef_sc_hd__decap_12
XFILLER_66_365 VGND VGND VPWR VPWR sky130_fd_sc_hd__fill_1
XFILLER_54_527 VGND VGND VPWR VPWR sky130_fd_sc_hd__decap_4
X_2065_ B_reg\[3\] _1326_ VGND VGND VPWR VPWR _1327_ sky130_fd_sc_hd__or2_1
XFILLER_82_869 VPWR VGND VPWR VGND sky130_ef_sc_hd__decap_12
XFILLER_19_281 VGND VGND VPWR VPWR sky130_fd_sc_hd__fill_2
XFILLER_19_292 VGND VGND VPWR VPWR sky130_fd_sc_hd__fill_1
XFILLER_35_741 VPWR VGND VPWR VGND sky130_ef_sc_hd__decap_12
XFILLER_34_240 VGND VGND VPWR VPWR sky130_fd_sc_hd__decap_8
XTAP_TAPCELL_ROW_85_1697 VGND VPWR sky130_fd_sc_hd__tapvpwrvgnd_1
XTAP_TAPCELL_ROW_85_1686 VGND VPWR sky130_fd_sc_hd__tapvpwrvgnd_1
XFILLER_22_413 VGND VGND VPWR VPWR sky130_fd_sc_hd__decap_3
XFILLER_22_424 VPWR VGND VPWR VGND sky130_ef_sc_hd__decap_12
XFILLER_35_785 VPWR VGND VPWR VGND sky130_ef_sc_hd__decap_12
XFILLER_148_643 VGND VGND VPWR VPWR sky130_fd_sc_hd__fill_1
XANTENNA__3297__CLK clknet_3_2__leaf_clk VGND VGND VPWR VPWR sky130_fd_sc_hd__diode_2
X_2967_ _0652_ _0653_ VGND VGND VPWR VPWR _0655_ sky130_fd_sc_hd__xnor2_1
XFILLER_136_805 VGND VGND VPWR VPWR sky130_fd_sc_hd__decap_6
X_2898_ _0576_ _0584_ VGND VGND VPWR VPWR _0586_ sky130_fd_sc_hd__xor2_1
X_1918_ _1180_ _1181_ _1172_ VGND VGND VPWR VPWR _1183_ sky130_fd_sc_hd__o21ai_1
XTAP_TAPCELL_ROW_20_647 VGND VPWR sky130_fd_sc_hd__tapvpwrvgnd_1
XTAP_TAPCELL_ROW_20_658 VGND VPWR sky130_fd_sc_hd__tapvpwrvgnd_1
XFILLER_136_849 VPWR VGND VPWR VGND sky130_ef_sc_hd__decap_12
X_1849_ _0888_ _1113_ _1115_ _1117_ VGND VGND VPWR VPWR _1119_ sky130_fd_sc_hd__a31o_1
XFILLER_135_337 VPWR VGND VPWR VGND sky130_ef_sc_hd__decap_12
XTAP_TAPCELL_ROW_116_2185 VGND VPWR sky130_fd_sc_hd__tapvpwrvgnd_1
XFILLER_150_307 VGND VGND VPWR VPWR sky130_fd_sc_hd__fill_1
XFILLER_104_713 VPWR VGND VPWR VGND sky130_ef_sc_hd__decap_12
XFILLER_78_29 VGND VGND VPWR VPWR sky130_fd_sc_hd__decap_8
XFILLER_144_893 VPWR VGND VPWR VGND sky130_ef_sc_hd__decap_12
XFILLER_104_757 VPWR VGND VPWR VGND sky130_ef_sc_hd__decap_12
XFILLER_103_223 VGND VGND VPWR VPWR sky130_fd_sc_hd__fill_1
XFILLER_89_446 VGND VGND VPWR VPWR sky130_fd_sc_hd__fill_2
XFILLER_1_317 VPWR VGND VPWR VGND sky130_ef_sc_hd__decap_12
XFILLER_76_129 VGND VGND VPWR VPWR sky130_fd_sc_hd__decap_8
XFILLER_58_811 VGND VGND VPWR VPWR sky130_fd_sc_hd__fill_1
XANTENNA__2847__A1 A_reg\[13\] VGND VGND VPWR VPWR sky130_fd_sc_hd__diode_2
XFILLER_85_641 VGND VGND VPWR VPWR sky130_fd_sc_hd__decap_6
XFILLER_69_181 VGND VGND VPWR VPWR sky130_fd_sc_hd__decap_4
XFILLER_85_685 VGND VGND VPWR VPWR sky130_fd_sc_hd__decap_8
XFILLER_45_505 VGND VGND VPWR VPWR sky130_fd_sc_hd__decap_6
XFILLER_84_184 VPWR VGND VPWR VGND sky130_ef_sc_hd__decap_12
XFILLER_27_55 VGND VGND VPWR VPWR sky130_fd_sc_hd__fill_1
XFILLER_72_357 VGND VGND VPWR VPWR sky130_fd_sc_hd__decap_6
XFILLER_41_700 VPWR VGND VPWR VGND sky130_ef_sc_hd__decap_12
XFILLER_25_273 VGND VGND VPWR VPWR sky130_fd_sc_hd__decap_6
XFILLER_9_417 VPWR VGND VPWR VGND sky130_ef_sc_hd__decap_12
XFILLER_41_744 VPWR VGND VPWR VGND sky130_ef_sc_hd__decap_12
XTAP_TAPCELL_ROW_136_2506 VGND VPWR sky130_fd_sc_hd__tapvpwrvgnd_1
XFILLER_40_265 VGND VGND VPWR VPWR sky130_fd_sc_hd__fill_1
XFILLER_41_799 VGND VGND VPWR VPWR sky130_fd_sc_hd__fill_2
XFILLER_139_665 VGND VGND VPWR VPWR sky130_fd_sc_hd__decap_6
XFILLER_138_153 VPWR VGND VPWR VGND sky130_ef_sc_hd__decap_12
XFILLER_138_197 VPWR VGND VPWR VGND sky130_ef_sc_hd__decap_12
XFILLER_4_133 VGND VGND VPWR VPWR sky130_fd_sc_hd__decap_6
XFILLER_141_329 VGND VGND VPWR VPWR sky130_fd_sc_hd__decap_6
XFILLER_107_573 VPWR VGND VPWR VGND sky130_ef_sc_hd__decap_12
XTAP_TAPCELL_ROW_56_1232 VGND VPWR sky130_fd_sc_hd__tapvpwrvgnd_1
XTAP_TAPCELL_ROW_56_1221 VGND VPWR sky130_fd_sc_hd__tapvpwrvgnd_1
XFILLER_4_15 VPWR VGND VPWR VGND sky130_ef_sc_hd__decap_12
XANTENNA__3283__Q A_reg\[9\] VGND VGND VPWR VPWR sky130_fd_sc_hd__diode_2
XFILLER_4_177 VPWR VGND VPWR VGND sky130_ef_sc_hd__decap_12
XFILLER_95_405 VGND VGND VPWR VPWR sky130_fd_sc_hd__decap_8
XTAP_TAPCELL_ROW_8_461 VGND VPWR sky130_fd_sc_hd__tapvpwrvgnd_1
XFILLER_122_587 VGND VGND VPWR VPWR sky130_fd_sc_hd__fill_1
XFILLER_110_749 VGND VGND VPWR VPWR sky130_fd_sc_hd__decap_6
XFILLER_95_449 VPWR VGND VPWR VGND sky130_ef_sc_hd__decap_12
XFILLER_0_361 VGND VGND VPWR VPWR sky130_fd_sc_hd__decap_3
XFILLER_1_895 VGND VGND VPWR VPWR sky130_fd_sc_hd__fill_1
XANTENNA_input36_X net36 VGND VGND VPWR VPWR sky130_fd_sc_hd__diode_2
XTAP_TAPCELL_ROW_147_2679 VGND VPWR sky130_fd_sc_hd__tapvpwrvgnd_1
XANTENNA__3015__A _0604_ VGND VGND VPWR VPWR sky130_fd_sc_hd__diode_2
XFILLER_76_630 VPWR VGND VPWR VGND sky130_ef_sc_hd__decap_12
XANTENNA__2838__A1 A_reg\[4\] VGND VGND VPWR VPWR sky130_fd_sc_hd__diode_2
XFILLER_48_321 VPWR VGND VPWR VGND sky130_ef_sc_hd__decap_12
XFILLER_64_825 VPWR VGND VPWR VGND sky130_ef_sc_hd__decap_12
XFILLER_48_365 VPWR VGND VPWR VGND sky130_ef_sc_hd__decap_12
XFILLER_48_354 VGND VGND VPWR VPWR sky130_fd_sc_hd__decap_8
XFILLER_84_83 VGND VGND VPWR VPWR sky130_fd_sc_hd__fill_1
XFILLER_64_869 VPWR VGND VPWR VGND sky130_ef_sc_hd__decap_12
XFILLER_63_335 VGND VGND VPWR VPWR sky130_fd_sc_hd__fill_1
XFILLER_17_741 VPWR VGND VPWR VGND sky130_ef_sc_hd__decap_12
XFILLER_17_785 VPWR VGND VPWR VGND sky130_ef_sc_hd__decap_12
XFILLER_149_429 VPWR VGND VPWR VGND sky130_ef_sc_hd__decap_12
XFILLER_32_755 VGND VGND VPWR VPWR sky130_fd_sc_hd__fill_1
X_2821_ net47 X_crt\[3\] _0553_ VGND VGND VPWR VPWR _0044_ sky130_fd_sc_hd__mux2_1
XFILLER_118_805 VGND VGND VPWR VPWR sky130_fd_sc_hd__decap_6
X_2752_ _0187_ _0489_ _0491_ VGND VGND VPWR VPWR _0492_ sky130_fd_sc_hd__a21o_1
XFILLER_118_849 VPWR VGND VPWR VGND sky130_ef_sc_hd__decap_12
X_1703_ _0974_ _0978_ VGND VGND VPWR VPWR _0979_ sky130_fd_sc_hd__nor2_1
XFILLER_117_337 VPWR VGND VPWR VGND sky130_ef_sc_hd__decap_12
X_2683_ a_r3\[2\] b_r3\[2\] VGND VGND VPWR VPWR _0423_ sky130_fd_sc_hd__nand2_1
XFILLER_132_307 VGND VGND VPWR VPWR sky130_fd_sc_hd__fill_1
X_1634_ CU_state_dbg\[0\] CU_state_dbg\[1\] CU_state_dbg\[2\] VGND VGND VPWR VPWR
+ _0912_ sky130_fd_sc_hd__or3b_4
XFILLER_144_189 VGND VGND VPWR VPWR sky130_fd_sc_hd__decap_6
XFILLER_141_841 VPWR VGND VPWR VGND sky130_ef_sc_hd__decap_12
XFILLER_126_893 VPWR VGND VPWR VGND sky130_ef_sc_hd__decap_12
XFILLER_99_777 VGND VGND VPWR VPWR sky130_fd_sc_hd__decap_6
X_3304_ clknet_3_0__leaf_clk _0087_ net36 VGND VGND VPWR VPWR B_reg\[14\] sky130_fd_sc_hd__dfrtp_4
XFILLER_101_727 VGND VGND VPWR VPWR sky130_fd_sc_hd__fill_1
X_3235_ clknet_3_1__leaf_clk _0022_ net36 VGND VGND VPWR VPWR a_r3\[3\] sky130_fd_sc_hd__dfrtp_4
XFILLER_104_27 VGND VGND VPWR VPWR sky130_fd_sc_hd__fill_1
XTAP_TAPCELL_ROW_87_1726 VGND VPWR sky130_fd_sc_hd__tapvpwrvgnd_1
XFILLER_82_611 VPWR VGND VPWR VGND sky130_ef_sc_hd__decap_12
X_3166_ _0852_ _0853_ VGND VGND VPWR VPWR _0854_ sky130_fd_sc_hd__nand2_1
XFILLER_27_505 VPWR VGND VPWR VGND sky130_ef_sc_hd__decap_12
X_2117_ _1372_ _1374_ B_reg\[8\] VGND VGND VPWR VPWR _1376_ sky130_fd_sc_hd__mux2_1
X_3097_ _0721_ _0730_ _0761_ VGND VGND VPWR VPWR _0785_ sky130_fd_sc_hd__nor3_1
X_2048_ _1308_ _1309_ VGND VGND VPWR VPWR _1310_ sky130_fd_sc_hd__and2_1
XFILLER_120_15 VPWR VGND VPWR VGND sky130_ef_sc_hd__decap_12
XFILLER_82_699 VGND VGND VPWR VPWR sky130_fd_sc_hd__fill_1
XTAP_TAPCELL_ROW_25_728 VGND VPWR sky130_fd_sc_hd__tapvpwrvgnd_1
XTAP_TAPCELL_ROW_25_739 VGND VPWR sky130_fd_sc_hd__tapvpwrvgnd_1
XFILLER_22_221 VGND VGND VPWR VPWR sky130_fd_sc_hd__fill_1
XFILLER_22_232 VGND VGND VPWR VPWR sky130_fd_sc_hd__fill_1
XFILLER_23_777 VGND VGND VPWR VPWR sky130_fd_sc_hd__decap_6
XTAP_TAPCELL_ROW_118_2225 VGND VPWR sky130_fd_sc_hd__tapvpwrvgnd_1
XTAP_TAPCELL_ROW_118_2214 VGND VPWR sky130_fd_sc_hd__tapvpwrvgnd_1
XFILLER_13_57 VPWR VGND VPWR VGND sky130_ef_sc_hd__decap_12
XFILLER_136_613 VPWR VGND VPWR VGND sky130_ef_sc_hd__decap_12
XFILLER_129_57 VPWR VGND VPWR VGND sky130_ef_sc_hd__decap_12
XFILLER_136_657 VPWR VGND VPWR VGND sky130_ef_sc_hd__decap_12
XTAP_TAPCELL_ROW_131_2425 VGND VPWR sky130_fd_sc_hd__tapvpwrvgnd_1
XTAP_TAPCELL_ROW_98_1899 VGND VPWR sky130_fd_sc_hd__tapvpwrvgnd_1
XFILLER_135_167 VGND VGND VPWR VPWR sky130_fd_sc_hd__fill_1
XFILLER_2_604 VPWR VGND VPWR VGND sky130_ef_sc_hd__decap_12
XFILLER_123_329 VGND VGND VPWR VPWR sky130_fd_sc_hd__decap_6
XFILLER_89_221 VGND VGND VPWR VPWR sky130_fd_sc_hd__decap_3
XFILLER_1_125 VPWR VGND VPWR VGND sky130_ef_sc_hd__decap_12
XFILLER_89_254 VPWR VGND VPWR VGND sky130_ef_sc_hd__decap_12
XFILLER_89_232 VGND VGND VPWR VPWR sky130_fd_sc_hd__decap_8
XFILLER_77_405 VPWR VGND VPWR VGND sky130_ef_sc_hd__decap_12
XANTENNA__3190__B1 _0912_ VGND VGND VPWR VPWR sky130_fd_sc_hd__diode_2
XFILLER_131_373 VPWR VGND VPWR VGND sky130_ef_sc_hd__decap_12
XFILLER_104_587 VGND VGND VPWR VPWR sky130_fd_sc_hd__fill_1
XANTENNA__3312__CLK clknet_3_7__leaf_clk VGND VGND VPWR VPWR sky130_fd_sc_hd__diode_2
XFILLER_1_169 VPWR VGND VPWR VGND sky130_ef_sc_hd__decap_12
XFILLER_93_909 VGND VGND VPWR VPWR sky130_fd_sc_hd__fill_1
XFILLER_77_449 VPWR VGND VPWR VGND sky130_ef_sc_hd__decap_12
XTAP_TAPCELL_ROW_51_1151 VGND VPWR sky130_fd_sc_hd__tapvpwrvgnd_1
XTAP_TAPCELL_ROW_51_1140 VGND VPWR sky130_fd_sc_hd__tapvpwrvgnd_1
XTAP_TAPCELL_ROW_129_2398 VGND VPWR sky130_fd_sc_hd__tapvpwrvgnd_1
XFILLER_92_419 VGND VGND VPWR VPWR sky130_fd_sc_hd__fill_1
XANTENNA__1989__S Encode_EN VGND VGND VPWR VPWR sky130_fd_sc_hd__diode_2
XFILLER_38_65 VPWR VGND VPWR VGND sky130_ef_sc_hd__decap_12
XFILLER_100_793 VPWR VGND VPWR VGND sky130_ef_sc_hd__decap_12
XFILLER_45_335 VGND VGND VPWR VPWR sky130_fd_sc_hd__fill_1
XTAP_TAPCELL_ROW_142_2598 VGND VPWR sky130_fd_sc_hd__tapvpwrvgnd_1
XFILLER_61_839 VGND VGND VPWR VPWR sky130_fd_sc_hd__fill_1
XFILLER_60_305 VGND VGND VPWR VPWR sky130_fd_sc_hd__decap_3
XFILLER_54_53 VPWR VGND VPWR VGND sky130_ef_sc_hd__decap_12
XFILLER_26_571 VPWR VGND VPWR VGND sky130_ef_sc_hd__decap_12
XFILLER_54_97 VPWR VGND VPWR VGND sky130_ef_sc_hd__decap_12
XFILLER_13_243 VGND VGND VPWR VPWR sky130_fd_sc_hd__fill_1
XFILLER_14_755 VGND VGND VPWR VPWR sky130_fd_sc_hd__fill_1
XFILLER_41_541 VPWR VGND VPWR VGND sky130_ef_sc_hd__decap_12
XANTENNA__3278__Q A_reg\[4\] VGND VGND VPWR VPWR sky130_fd_sc_hd__diode_2
XFILLER_9_225 VPWR VGND VPWR VGND sky130_ef_sc_hd__decap_12
XFILLER_41_585 VPWR VGND VPWR VGND sky130_ef_sc_hd__decap_12
XFILLER_70_41 VPWR VGND VPWR VGND sky130_ef_sc_hd__decap_12
XFILLER_139_473 VPWR VGND VPWR VGND sky130_ef_sc_hd__decap_12
XANTENNA__2756__B1 _0188_ VGND VGND VPWR VPWR sky130_fd_sc_hd__diode_2
XFILLER_114_307 VGND VGND VPWR VPWR sky130_fd_sc_hd__fill_1
XFILLER_55_8 VPWR VGND VPWR VGND sky130_ef_sc_hd__decap_12
XTAP_TAPCELL_ROW_149_2708 VGND VPWR sky130_fd_sc_hd__tapvpwrvgnd_1
XFILLER_141_137 VPWR VGND VPWR VGND sky130_ef_sc_hd__decap_12
XFILLER_126_189 VGND VGND VPWR VPWR sky130_fd_sc_hd__decap_6
XFILLER_123_841 VPWR VGND VPWR VGND sky130_ef_sc_hd__decap_12
XFILLER_108_893 VPWR VGND VPWR VGND sky130_ef_sc_hd__decap_12
XFILLER_5_497 VGND VGND VPWR VPWR sky130_fd_sc_hd__decap_6
XTAP_TAPCELL_ROW_149_2719 VGND VPWR sky130_fd_sc_hd__tapvpwrvgnd_1
XFILLER_150_693 VGND VGND VPWR VPWR sky130_fd_sc_hd__decap_6
XFILLER_96_725 VPWR VGND VPWR VGND sky130_ef_sc_hd__decap_12
XFILLER_68_427 VPWR VGND VPWR VGND sky130_ef_sc_hd__decap_12
XANTENNA__1731__A1 A_reg\[1\] VGND VGND VPWR VPWR sky130_fd_sc_hd__diode_2
XFILLER_110_557 VPWR VGND VPWR VGND sky130_ef_sc_hd__decap_12
XFILLER_96_769 VPWR VGND VPWR VGND sky130_ef_sc_hd__decap_12
XFILLER_84_909 VGND VGND VPWR VPWR sky130_fd_sc_hd__fill_1
XFILLER_95_279 VGND VGND VPWR VPWR sky130_fd_sc_hd__fill_1
X_3020_ _0706_ _0707_ VGND VGND VPWR VPWR _0708_ sky130_fd_sc_hd__or2_1
XFILLER_49_685 VGND VGND VPWR VPWR sky130_fd_sc_hd__decap_8
XTAP_TAPCELL_ROW_69_1434 VGND VPWR sky130_fd_sc_hd__tapvpwrvgnd_1
XFILLER_48_195 VGND VGND VPWR VPWR sky130_fd_sc_hd__fill_1
XFILLER_52_817 VGND VGND VPWR VPWR sky130_fd_sc_hd__fill_1
XFILLER_64_699 VGND VGND VPWR VPWR sky130_fd_sc_hd__fill_1
XTAP_TAPCELL_ROW_82_1645 VGND VPWR sky130_fd_sc_hd__tapvpwrvgnd_1
XFILLER_32_541 VPWR VGND VPWR VGND sky130_ef_sc_hd__decap_12
XFILLER_149_237 VPWR VGND VPWR VGND sky130_ef_sc_hd__decap_12
XFILLER_20_725 VPWR VGND VPWR VGND sky130_ef_sc_hd__decap_12
XFILLER_32_574 VPWR VGND VPWR VGND sky130_ef_sc_hd__decap_12
X_2804_ _0390_ _0542_ VGND VGND VPWR VPWR _0544_ sky130_fd_sc_hd__or2_1
XFILLER_118_613 VPWR VGND VPWR VGND sky130_ef_sc_hd__decap_12
XANTENNA__1647__B A_reg\[15\] VGND VGND VPWR VPWR sky130_fd_sc_hd__diode_2
XFILLER_20_769 VPWR VGND VPWR VGND sky130_ef_sc_hd__decap_12
XFILLER_118_657 VPWR VGND VPWR VGND sky130_ef_sc_hd__decap_12
X_2735_ _0468_ _0474_ VGND VGND VPWR VPWR _0475_ sky130_fd_sc_hd__or2_1
XFILLER_117_167 VGND VGND VPWR VPWR sky130_fd_sc_hd__fill_1
XTAP_TAPCELL_ROW_113_2144 VGND VPWR sky130_fd_sc_hd__tapvpwrvgnd_1
XTAP_TAPCELL_ROW_113_2133 VGND VPWR sky130_fd_sc_hd__tapvpwrvgnd_1
X_2666_ _0399_ _0405_ _0396_ VGND VGND VPWR VPWR _0406_ sky130_fd_sc_hd__a21o_1
XFILLER_105_329 VGND VGND VPWR VPWR sky130_fd_sc_hd__decap_6
X_1617_ B_reg\[0\] VGND VGND VPWR VPWR _0897_ sky130_fd_sc_hd__inv_2
X_2597_ _0306_ _0341_ _0340_ VGND VGND VPWR VPWR _0342_ sky130_fd_sc_hd__o21a_1
XFILLER_141_671 VGND VGND VPWR VPWR sky130_fd_sc_hd__fill_1
XFILLER_115_15 VPWR VGND VPWR VGND sky130_ef_sc_hd__decap_12
XFILLER_113_373 VPWR VGND VPWR VGND sky130_ef_sc_hd__decap_12
XFILLER_101_502 VGND VGND VPWR VPWR sky130_fd_sc_hd__fill_2
XFILLER_59_405 VPWR VGND VPWR VGND sky130_ef_sc_hd__decap_12
XFILLER_75_909 VGND VGND VPWR VPWR sky130_fd_sc_hd__fill_1
XFILLER_59_449 VPWR VGND VPWR VGND sky130_ef_sc_hd__decap_12
X_3218_ clknet_3_3__leaf_clk _0006_ net36 VGND VGND VPWR VPWR a_r0\[0\] sky130_fd_sc_hd__dfrtp_4
XFILLER_28_825 VPWR VGND VPWR VGND sky130_ef_sc_hd__decap_12
XFILLER_54_121 VGND VGND VPWR VPWR sky130_fd_sc_hd__decap_8
XFILLER_27_313 VGND VGND VPWR VPWR sky130_fd_sc_hd__fill_2
XFILLER_27_335 VGND VGND VPWR VPWR sky130_fd_sc_hd__fill_1
X_3149_ _0810_ _0827_ VGND VGND VPWR VPWR _0837_ sky130_fd_sc_hd__nand2_1
XFILLER_82_441 VGND VGND VPWR VPWR sky130_fd_sc_hd__fill_2
XFILLER_28_869 VPWR VGND VPWR VGND sky130_ef_sc_hd__decap_12
XFILLER_131_69 VPWR VGND VPWR VGND sky130_ef_sc_hd__decap_12
XFILLER_70_636 VGND VGND VPWR VPWR sky130_fd_sc_hd__decap_8
XFILLER_54_176 VGND VGND VPWR VPWR sky130_fd_sc_hd__fill_1
XFILLER_54_165 VGND VGND VPWR VPWR sky130_fd_sc_hd__decap_3
XFILLER_43_828 VPWR VGND VPWR VGND sky130_ef_sc_hd__decap_12
XFILLER_70_669 VPWR VGND VPWR VGND sky130_ef_sc_hd__decap_12
XFILLER_23_541 VPWR VGND VPWR VGND sky130_ef_sc_hd__decap_12
XFILLER_50_393 VGND VGND VPWR VPWR sky130_fd_sc_hd__fill_1
XFILLER_23_585 VPWR VGND VPWR VGND sky130_ef_sc_hd__decap_12
XFILLER_7_729 VPWR VGND VPWR VGND sky130_ef_sc_hd__decap_12
XFILLER_136_421 VPWR VGND VPWR VGND sky130_ef_sc_hd__decap_12
XFILLER_40_77 VGND VGND VPWR VPWR sky130_fd_sc_hd__decap_6
XFILLER_108_189 VGND VGND VPWR VPWR sky130_fd_sc_hd__decap_6
XFILLER_123_137 VPWR VGND VPWR VGND sky130_ef_sc_hd__decap_12
XFILLER_105_841 VPWR VGND VPWR VGND sky130_ef_sc_hd__decap_12
XFILLER_6_3 VPWR VGND VPWR VGND sky130_ef_sc_hd__decap_12
XFILLER_120_811 VGND VGND VPWR VPWR sky130_fd_sc_hd__fill_1
XFILLER_78_725 VPWR VGND VPWR VGND sky130_ef_sc_hd__decap_12
XANTENNA__1713__A1 A_reg\[2\] VGND VGND VPWR VPWR sky130_fd_sc_hd__diode_2
XFILLER_132_693 VGND VGND VPWR VPWR sky130_fd_sc_hd__decap_6
XFILLER_131_181 VPWR VGND VPWR VGND sky130_ef_sc_hd__decap_12
XFILLER_78_769 VPWR VGND VPWR VGND sky130_ef_sc_hd__decap_12
XFILLER_66_909 VGND VGND VPWR VPWR sky130_fd_sc_hd__fill_1
XTAP_TAPCELL_ROW_144_2638 VGND VPWR sky130_fd_sc_hd__tapvpwrvgnd_1
XFILLER_77_279 VGND VGND VPWR VPWR sky130_fd_sc_hd__fill_1
XFILLER_1_27 VPWR VGND VPWR VGND sky130_ef_sc_hd__decap_12
XFILLER_105_81 VPWR VGND VPWR VGND sky130_ef_sc_hd__decap_12
XFILLER_65_52 VGND VGND VPWR VPWR sky130_fd_sc_hd__decap_4
XFILLER_46_688 VPWR VGND VPWR VGND sky130_ef_sc_hd__decap_12
XFILLER_60_135 VGND VGND VPWR VPWR sky130_fd_sc_hd__decap_4
XFILLER_42_850 VPWR VGND VPWR VGND sky130_ef_sc_hd__decap_12
XFILLER_81_51 VGND VGND VPWR VPWR sky130_fd_sc_hd__decap_4
XTAP_TAPCELL_ROW_64_1353 VGND VPWR sky130_fd_sc_hd__tapvpwrvgnd_1
XFILLER_41_371 VPWR VGND VPWR VGND sky130_ef_sc_hd__decap_12
XFILLER_41_393 VGND VGND VPWR VPWR sky130_fd_sc_hd__fill_2
XFILLER_139_281 VPWR VGND VPWR VGND sky130_ef_sc_hd__decap_12
X_2520_ _0187_ _0266_ _0267_ VGND VGND VPWR VPWR _0268_ sky130_fd_sc_hd__and3_1
XFILLER_142_413 VGND VGND VPWR VPWR sky130_fd_sc_hd__decap_6
X_2451_ _0187_ _0200_ VGND VGND VPWR VPWR _0201_ sky130_fd_sc_hd__nand2_1
XFILLER_142_457 VPWR VGND VPWR VGND sky130_ef_sc_hd__decap_12
XFILLER_123_671 VGND VGND VPWR VPWR sky130_fd_sc_hd__fill_1
X_2382_ _0129_ _0132_ _0906_ VGND VGND VPWR VPWR _0136_ sky130_fd_sc_hd__a21oi_1
XFILLER_96_500 VPWR VGND VPWR VGND sky130_ef_sc_hd__decap_12
XFILLER_39_3 VPWR VGND VPWR VGND sky130_ef_sc_hd__decap_12
XFILLER_111_833 VGND VGND VPWR VPWR sky130_fd_sc_hd__decap_6
XFILLER_110_321 VPWR VGND VPWR VGND sky130_ef_sc_hd__decap_12
XFILLER_96_533 VPWR VGND VPWR VGND sky130_ef_sc_hd__decap_12
XFILLER_57_909 VGND VGND VPWR VPWR sky130_fd_sc_hd__fill_1
XFILLER_111_877 VPWR VGND VPWR VGND sky130_ef_sc_hd__decap_12
XFILLER_110_365 VPWR VGND VPWR VGND sky130_ef_sc_hd__decap_12
XFILLER_96_566 VPWR VGND VPWR VGND sky130_ef_sc_hd__decap_12
XFILLER_83_205 VPWR VGND VPWR VGND sky130_ef_sc_hd__decap_12
XFILLER_56_419 VGND VGND VPWR VPWR sky130_fd_sc_hd__fill_1
XFILLER_83_249 VPWR VGND VPWR VGND sky130_ef_sc_hd__decap_12
XFILLER_77_780 VGND VGND VPWR VPWR sky130_fd_sc_hd__decap_4
X_3003_ _0689_ _0690_ VGND VGND VPWR VPWR _0691_ sky130_fd_sc_hd__nand2_1
Xinput4 A_in[12] VGND VGND VPWR VPWR net4 sky130_fd_sc_hd__clkbuf_1
XFILLER_37_611 VGND VGND VPWR VPWR sky130_fd_sc_hd__decap_4
XFILLER_36_121 VPWR VGND VPWR VGND sky130_ef_sc_hd__decap_12
XFILLER_64_474 VGND VGND VPWR VPWR sky130_fd_sc_hd__fill_2
XFILLER_52_625 VPWR VGND VPWR VGND sky130_ef_sc_hd__decap_12
XFILLER_25_839 VGND VGND VPWR VPWR sky130_fd_sc_hd__fill_1
XFILLER_36_165 VPWR VGND VPWR VGND sky130_ef_sc_hd__decap_12
XFILLER_101_39 VPWR VGND VPWR VGND sky130_ef_sc_hd__decap_12
XFILLER_91_293 VPWR VGND VPWR VGND sky130_ef_sc_hd__decap_12
XTAP_TAPCELL_ROW_35_889 VGND VPWR sky130_fd_sc_hd__tapvpwrvgnd_1
XFILLER_60_691 VGND VGND VPWR VPWR sky130_fd_sc_hd__decap_8
XFILLER_20_533 VPWR VGND VPWR VGND sky130_ef_sc_hd__decap_12
XFILLER_118_421 VPWR VGND VPWR VGND sky130_ef_sc_hd__decap_12
X_2718_ _0455_ _0456_ _0186_ VGND VGND VPWR VPWR _0458_ sky130_fd_sc_hd__a21o_1
XTAP_TAPCELL_ROW_95_1847 VGND VPWR sky130_fd_sc_hd__tapvpwrvgnd_1
XFILLER_145_273 VGND VGND VPWR VPWR sky130_fd_sc_hd__decap_6
XTAP_TAPCELL_ROW_95_1858 VGND VPWR sky130_fd_sc_hd__tapvpwrvgnd_1
XFILLER_105_137 VPWR VGND VPWR VGND sky130_ef_sc_hd__decap_12
X_2649_ OpSel_reg\[1\] a_r3\[0\] OpSel_reg\[0\] VGND VGND VPWR VPWR _0389_ sky130_fd_sc_hd__a21o_1
XFILLER_102_811 VGND VGND VPWR VPWR sky130_fd_sc_hd__fill_1
XFILLER_86_29 VPWR VGND VPWR VGND sky130_ef_sc_hd__decap_12
XFILLER_114_693 VGND VGND VPWR VPWR sky130_fd_sc_hd__decap_6
XFILLER_113_181 VPWR VGND VPWR VGND sky130_ef_sc_hd__decap_12
XFILLER_99_393 VPWR VGND VPWR VGND sky130_ef_sc_hd__decap_12
XANTENNA__3265__RESET_B net36 VGND VGND VPWR VPWR sky130_fd_sc_hd__diode_2
XFILLER_59_279 VGND VGND VPWR VPWR sky130_fd_sc_hd__fill_1
XTAP_TAPCELL_ROW_126_2346 VGND VPWR sky130_fd_sc_hd__tapvpwrvgnd_1
XFILLER_55_441 VGND VGND VPWR VPWR sky130_fd_sc_hd__decap_6
XFILLER_83_783 VGND VGND VPWR VPWR sky130_fd_sc_hd__fill_1
XFILLER_15_305 VPWR VGND VPWR VGND sky130_ef_sc_hd__decap_12
XFILLER_28_699 VGND VGND VPWR VPWR sky130_fd_sc_hd__fill_1
XANTENNA__2952__A _0604_ VGND VGND VPWR VPWR sky130_fd_sc_hd__diode_2
XFILLER_70_444 VPWR VGND VPWR VGND sky130_ef_sc_hd__decap_12
XFILLER_15_349 VPWR VGND VPWR VGND sky130_ef_sc_hd__decap_12
XFILLER_35_55 VGND VGND VPWR VPWR sky130_fd_sc_hd__fill_1
XFILLER_43_669 VGND VGND VPWR VPWR sky130_fd_sc_hd__decap_3
XFILLER_24_861 VGND VGND VPWR VPWR sky130_fd_sc_hd__decap_6
XTAP_TAPCELL_ROW_46_1061 VGND VPWR sky130_fd_sc_hd__tapvpwrvgnd_1
XFILLER_143_3 VPWR VGND VPWR VGND sky130_ef_sc_hd__decap_12
XTAP_TAPCELL_ROW_104_1998 VGND VPWR sky130_fd_sc_hd__tapvpwrvgnd_1
XTAP_TAPCELL_ROW_46_1072 VGND VPWR sky130_fd_sc_hd__tapvpwrvgnd_1
XTAP_TAPCELL_ROW_13_539 VGND VPWR sky130_fd_sc_hd__tapvpwrvgnd_1
XFILLER_23_393 VPWR VGND VPWR VGND sky130_ef_sc_hd__decap_12
XFILLER_51_54 VGND VGND VPWR VPWR sky130_fd_sc_hd__fill_2
XFILLER_137_741 VPWR VGND VPWR VGND sky130_ef_sc_hd__decap_12
XFILLER_11_577 VPWR VGND VPWR VGND sky130_ef_sc_hd__decap_12
XFILLER_136_251 VGND VGND VPWR VPWR sky130_fd_sc_hd__fill_1
XFILLER_51_98 VGND VGND VPWR VPWR sky130_fd_sc_hd__decap_4
XFILLER_7_559 VGND VGND VPWR VPWR sky130_fd_sc_hd__fill_1
XANTENNA__2187__A1 A_reg\[9\] VGND VGND VPWR VPWR sky130_fd_sc_hd__diode_2
XFILLER_137_785 VPWR VGND VPWR VGND sky130_ef_sc_hd__decap_12
XFILLER_124_413 VGND VGND VPWR VPWR sky130_fd_sc_hd__decap_6
XFILLER_109_476 VGND VGND VPWR VPWR sky130_fd_sc_hd__fill_1
XFILLER_3_721 VGND VGND VPWR VPWR sky130_fd_sc_hd__decap_6
XFILLER_152_755 VGND VGND VPWR VPWR sky130_fd_sc_hd__fill_1
XFILLER_124_457 VPWR VGND VPWR VGND sky130_ef_sc_hd__decap_12
XFILLER_105_671 VGND VGND VPWR VPWR sky130_fd_sc_hd__fill_1
XFILLER_3_765 VPWR VGND VPWR VGND sky130_ef_sc_hd__decap_12
XANTENNA__3291__Q B_reg\[1\] VGND VGND VPWR VPWR sky130_fd_sc_hd__diode_2
XFILLER_78_533 VPWR VGND VPWR VGND sky130_ef_sc_hd__decap_12
XANTENNA__1698__B1 A_reg\[4\] VGND VGND VPWR VPWR sky130_fd_sc_hd__diode_2
XFILLER_76_51 VPWR VGND VPWR VGND sky130_ef_sc_hd__decap_12
XFILLER_38_419 VGND VGND VPWR VPWR sky130_fd_sc_hd__fill_1
XFILLER_81_709 VPWR VGND VPWR VGND sky130_ef_sc_hd__decap_12
XFILLER_18_121 VPWR VGND VPWR VGND sky130_ef_sc_hd__decap_12
XFILLER_18_165 VPWR VGND VPWR VGND sky130_ef_sc_hd__decap_12
XFILLER_34_625 VPWR VGND VPWR VGND sky130_ef_sc_hd__decap_12
XFILLER_46_463 VGND VGND VPWR VPWR sky130_fd_sc_hd__decap_3
XFILLER_73_293 VPWR VGND VPWR VGND sky130_ef_sc_hd__decap_12
XFILLER_33_113 VPWR VGND VPWR VGND sky130_ef_sc_hd__decap_12
XFILLER_34_669 VPWR VGND VPWR VGND sky130_ef_sc_hd__decap_12
XFILLER_92_83 VGND VGND VPWR VPWR sky130_fd_sc_hd__fill_1
X_1951_ _1204_ _1206_ VGND VGND VPWR VPWR _1216_ sky130_fd_sc_hd__xnor2_1
XANTENNA__2581__B _0187_ VGND VGND VPWR VPWR sky130_fd_sc_hd__diode_2
XPHY_EDGE_ROW_1_Left_155 VGND VGND VPWR VPWR sky130_fd_sc_hd__decap_3
XTAP_TAPCELL_ROW_32_837 VGND VPWR sky130_fd_sc_hd__tapvpwrvgnd_1
XTAP_TAPCELL_ROW_32_848 VGND VPWR sky130_fd_sc_hd__tapvpwrvgnd_1
XFILLER_147_505 VPWR VGND VPWR VGND sky130_ef_sc_hd__decap_12
X_1882_ _1149_ _1151_ VGND VGND VPWR VPWR _1152_ sky130_fd_sc_hd__nor2_1
XFILLER_127_273 VGND VGND VPWR VPWR sky130_fd_sc_hd__decap_6
XTAP_TAPCELL_ROW_77_1566 VGND VPWR sky130_fd_sc_hd__tapvpwrvgnd_1
XFILLER_6_581 VGND VGND VPWR VPWR sky130_fd_sc_hd__decap_6
X_2503_ b_r1\[0\] a_r1\[2\] _0222_ VGND VGND VPWR VPWR _0251_ sky130_fd_sc_hd__nand3_1
XFILLER_143_777 VGND VGND VPWR VPWR sky130_fd_sc_hd__decap_6
XFILLER_142_221 VPWR VGND VPWR VGND sky130_ef_sc_hd__decap_12
XFILLER_89_809 VPWR VGND VPWR VGND sky130_ef_sc_hd__decap_12
XFILLER_142_265 VPWR VGND VPWR VGND sky130_ef_sc_hd__decap_12
X_2434_ OpSel_reg\[0\] OpSel_reg\[1\] _0910_ VGND VGND VPWR VPWR _0184_ sky130_fd_sc_hd__a21oi_4
XPHY_EDGE_ROW_135_Right_135 VGND VGND VPWR VPWR sky130_fd_sc_hd__decap_3
XFILLER_97_853 VPWR VGND VPWR VGND sky130_ef_sc_hd__decap_12
XFILLER_96_330 VPWR VGND VPWR VGND sky130_ef_sc_hd__decap_12
X_2365_ _0115_ _0118_ VGND VGND VPWR VPWR _0119_ sky130_fd_sc_hd__and2_1
XTAP_TAPCELL_ROW_90_1777 VGND VPWR sky130_fd_sc_hd__tapvpwrvgnd_1
XTAP_TAPCELL_ROW_90_1766 VGND VPWR sky130_fd_sc_hd__tapvpwrvgnd_1
XFILLER_111_641 VPWR VGND VPWR VGND sky130_ef_sc_hd__decap_12
XFILLER_97_897 VPWR VGND VPWR VGND sky130_ef_sc_hd__decap_12
XANTENNA__1941__A B_reg\[7\] VGND VGND VPWR VPWR sky130_fd_sc_hd__diode_2
XFILLER_69_555 VGND VGND VPWR VPWR sky130_fd_sc_hd__decap_4
XFILLER_111_685 VPWR VGND VPWR VGND sky130_ef_sc_hd__decap_12
X_2296_ B_reg\[15\] B_reg\[14\] B_reg\[12\] VGND VGND VPWR VPWR _1549_ sky130_fd_sc_hd__and3_1
XFILLER_110_195 VGND VGND VPWR VPWR sky130_fd_sc_hd__fill_1
XTAP_TAPCELL_ROW_108_2065 VGND VPWR sky130_fd_sc_hd__tapvpwrvgnd_1
XTAP_TAPCELL_ROW_108_2054 VGND VPWR sky130_fd_sc_hd__tapvpwrvgnd_1
XFILLER_112_27 VGND VGND VPWR VPWR sky130_fd_sc_hd__fill_1
XFILLER_80_742 VPWR VGND VPWR VGND sky130_ef_sc_hd__decap_12
XFILLER_52_433 VPWR VGND VPWR VGND sky130_ef_sc_hd__decap_12
XTAP_TAPCELL_ROW_121_2265 VGND VPWR sky130_fd_sc_hd__tapvpwrvgnd_1
XFILLER_52_477 VGND VGND VPWR VPWR sky130_fd_sc_hd__fill_2
XFILLER_13_809 VPWR VGND VPWR VGND sky130_ef_sc_hd__decap_12
XFILLER_21_853 VPWR VGND VPWR VGND sky130_ef_sc_hd__decap_12
XFILLER_119_741 VPWR VGND VPWR VGND sky130_ef_sc_hd__decap_12
XFILLER_20_363 VGND VGND VPWR VPWR sky130_fd_sc_hd__fill_1
XFILLER_21_897 VPWR VGND VPWR VGND sky130_ef_sc_hd__decap_12
XFILLER_118_251 VGND VGND VPWR VPWR sky130_fd_sc_hd__fill_1
XFILLER_119_785 VPWR VGND VPWR VGND sky130_ef_sc_hd__decap_12
XFILLER_21_57 VPWR VGND VPWR VGND sky130_ef_sc_hd__decap_12
XFILLER_137_57 VPWR VGND VPWR VGND sky130_ef_sc_hd__decap_12
XFILLER_134_755 VGND VGND VPWR VPWR sky130_fd_sc_hd__fill_1
XFILLER_121_405 VPWR VGND VPWR VGND sky130_ef_sc_hd__decap_12
XFILLER_0_713 VPWR VGND VPWR VGND sky130_ef_sc_hd__decap_12
XFILLER_121_449 VPWR VGND VPWR VGND sky130_ef_sc_hd__decap_12
XPHY_EDGE_ROW_102_Right_102 VGND VGND VPWR VPWR sky130_fd_sc_hd__decap_3
XFILLER_75_503 VGND VGND VPWR VPWR sky130_fd_sc_hd__fill_1
XFILLER_0_757 VPWR VGND VPWR VGND sky130_ef_sc_hd__decap_12
XFILLER_87_385 VGND VGND VPWR VPWR sky130_fd_sc_hd__decap_6
XFILLER_47_205 VPWR VGND VPWR VGND sky130_ef_sc_hd__decap_12
XFILLER_63_709 VPWR VGND VPWR VGND sky130_ef_sc_hd__decap_12
XFILLER_47_249 VPWR VGND VPWR VGND sky130_ef_sc_hd__decap_12
XTAP_TAPCELL_ROW_48_1101 VGND VPWR sky130_fd_sc_hd__tapvpwrvgnd_1
XFILLER_16_625 VPWR VGND VPWR VGND sky130_ef_sc_hd__decap_12
XFILLER_46_65 VPWR VGND VPWR VGND sky130_ef_sc_hd__decap_12
XFILLER_71_753 VPWR VGND VPWR VGND sky130_ef_sc_hd__decap_12
XFILLER_55_293 VPWR VGND VPWR VGND sky130_ef_sc_hd__decap_12
XFILLER_15_113 VPWR VGND VPWR VGND sky130_ef_sc_hd__decap_12
XANTENNA__1852__B1 A_reg\[10\] VGND VGND VPWR VPWR sky130_fd_sc_hd__diode_2
XFILLER_16_669 VPWR VGND VPWR VGND sky130_ef_sc_hd__decap_12
XFILLER_71_797 VPWR VGND VPWR VGND sky130_ef_sc_hd__decap_12
XFILLER_62_53 VPWR VGND VPWR VGND sky130_ef_sc_hd__decap_12
XTAP_TAPCELL_ROW_61_1312 VGND VPWR sky130_fd_sc_hd__tapvpwrvgnd_1
XTAP_TAPCELL_ROW_61_1301 VGND VPWR sky130_fd_sc_hd__tapvpwrvgnd_1
XTAP_TAPCELL_ROW_139_2559 VGND VPWR sky130_fd_sc_hd__tapvpwrvgnd_1
XTAP_TAPCELL_ROW_139_2548 VGND VPWR sky130_fd_sc_hd__tapvpwrvgnd_1
XFILLER_129_505 VPWR VGND VPWR VGND sky130_ef_sc_hd__decap_12
XFILLER_8_813 VPWR VGND VPWR VGND sky130_ef_sc_hd__decap_12
XFILLER_7_15 VPWR VGND VPWR VGND sky130_ef_sc_hd__decap_12
XFILLER_11_385 VGND VGND VPWR VPWR sky130_fd_sc_hd__fill_1
XTAP_TAPCELL_ROW_152_2759 VGND VPWR sky130_fd_sc_hd__tapvpwrvgnd_1
XFILLER_109_273 VGND VGND VPWR VPWR sky130_fd_sc_hd__decap_6
XFILLER_124_221 VPWR VGND VPWR VGND sky130_ef_sc_hd__decap_12
XTAP_TAPCELL_ROW_59_1274 VGND VPWR sky130_fd_sc_hd__tapvpwrvgnd_1
XFILLER_152_585 VGND VGND VPWR VPWR sky130_fd_sc_hd__decap_3
XFILLER_140_725 VPWR VGND VPWR VGND sky130_ef_sc_hd__decap_12
XFILLER_125_777 VGND VGND VPWR VPWR sky130_fd_sc_hd__decap_6
XFILLER_124_265 VPWR VGND VPWR VGND sky130_ef_sc_hd__decap_12
XFILLER_97_105 VGND VGND VPWR VPWR sky130_fd_sc_hd__decap_6
XFILLER_97_149 VPWR VGND VPWR VGND sky130_ef_sc_hd__decap_12
XFILLER_79_853 VPWR VGND VPWR VGND sky130_ef_sc_hd__decap_12
XFILLER_140_769 VPWR VGND VPWR VGND sky130_ef_sc_hd__decap_12
XFILLER_78_363 VGND VGND VPWR VPWR sky130_fd_sc_hd__fill_1
XTAP_TAPCELL_ROW_72_1485 VGND VPWR sky130_fd_sc_hd__tapvpwrvgnd_1
XFILLER_39_706 VGND VGND VPWR VPWR sky130_fd_sc_hd__fill_1
X_2150_ b_r0\[1\] _0911_ _1404_ _1407_ VGND VGND VPWR VPWR _0018_ sky130_fd_sc_hd__a22o_1
XFILLER_79_897 VPWR VGND VPWR VGND sky130_ef_sc_hd__decap_12
XFILLER_66_525 VGND VGND VPWR VPWR sky130_fd_sc_hd__decap_6
XFILLER_94_867 VGND VGND VPWR VPWR sky130_fd_sc_hd__fill_1
X_2081_ _1334_ _1336_ _1342_ VGND VGND VPWR VPWR _1343_ sky130_fd_sc_hd__a21oi_1
XFILLER_66_569 VPWR VGND VPWR VGND sky130_ef_sc_hd__decap_12
XFILLER_19_441 VGND VGND VPWR VPWR sky130_fd_sc_hd__decap_6
XFILLER_93_366 VPWR VGND VPWR VGND sky130_ef_sc_hd__decap_12
XTAP_TAPCELL_ROW_37_918 VGND VPWR sky130_fd_sc_hd__tapvpwrvgnd_1
XTAP_TAPCELL_ROW_37_929 VGND VPWR sky130_fd_sc_hd__tapvpwrvgnd_1
XFILLER_19_485 VPWR VGND VPWR VGND sky130_ef_sc_hd__decap_12
XFILLER_34_433 VPWR VGND VPWR VGND sky130_ef_sc_hd__decap_12
XFILLER_34_477 VPWR VGND VPWR VGND sky130_ef_sc_hd__decap_12
X_2983_ _0554_ _0602_ VGND VGND VPWR VPWR _0671_ sky130_fd_sc_hd__xnor2_1
XFILLER_21_105 VGND VGND VPWR VPWR sky130_fd_sc_hd__decap_6
XFILLER_148_825 VPWR VGND VPWR VGND sky130_ef_sc_hd__decap_12
X_1934_ _0901_ _1195_ VGND VGND VPWR VPWR _1199_ sky130_fd_sc_hd__xnor2_2
XFILLER_21_149 VPWR VGND VPWR VGND sky130_ef_sc_hd__decap_12
XFILLER_148_869 VPWR VGND VPWR VGND sky130_ef_sc_hd__decap_12
XFILLER_147_335 VGND VGND VPWR VPWR sky130_fd_sc_hd__fill_1
X_1865_ _1133_ _1134_ A_reg\[6\] VGND VGND VPWR VPWR _1135_ sky130_fd_sc_hd__o21ai_1
X_1796_ _1064_ _1065_ _1067_ A_reg\[5\] VGND VGND VPWR VPWR _1069_ sky130_fd_sc_hd__o2bb2a_1
XFILLER_143_541 VPWR VGND VPWR VGND sky130_ef_sc_hd__decap_12
XFILLER_116_755 VGND VGND VPWR VPWR sky130_fd_sc_hd__fill_1
XTAP_TAPCELL_ROW_92_1806 VGND VPWR sky130_fd_sc_hd__tapvpwrvgnd_1
XPHY_EDGE_ROW_55_Left_209 VGND VGND VPWR VPWR sky130_fd_sc_hd__decap_3
XFILLER_143_585 VPWR VGND VPWR VGND sky130_ef_sc_hd__decap_12
XFILLER_107_27 VPWR VGND VPWR VGND sky130_ef_sc_hd__decap_12
XFILLER_103_405 VPWR VGND VPWR VGND sky130_ef_sc_hd__decap_12
XFILLER_89_617 VPWR VGND VPWR VGND sky130_ef_sc_hd__decap_12
XFILLER_103_449 VPWR VGND VPWR VGND sky130_ef_sc_hd__decap_12
X_2417_ _0169_ _0170_ VGND VGND VPWR VPWR _0171_ sky130_fd_sc_hd__and2_1
XFILLER_57_503 VGND VGND VPWR VPWR sky130_fd_sc_hd__fill_1
XFILLER_123_15 VPWR VGND VPWR VGND sky130_ef_sc_hd__decap_12
XFILLER_96_171 VGND VGND VPWR VPWR sky130_fd_sc_hd__fill_1
X_2348_ _1595_ _1600_ _0903_ VGND VGND VPWR VPWR _1601_ sky130_fd_sc_hd__a21oi_1
XFILLER_69_385 VGND VGND VPWR VPWR sky130_fd_sc_hd__decap_6
XFILLER_29_205 VGND VGND VPWR VPWR sky130_fd_sc_hd__decap_8
XTAP_TAPCELL_ROW_123_2305 VGND VPWR sky130_fd_sc_hd__tapvpwrvgnd_1
XFILLER_84_344 VPWR VGND VPWR VGND sky130_ef_sc_hd__decap_12
X_2279_ _1528_ _1530_ _1526_ VGND VGND VPWR VPWR _1536_ sky130_fd_sc_hd__a21oi_1
XFILLER_85_889 VGND VGND VPWR VPWR sky130_fd_sc_hd__decap_6
XFILLER_84_377 VPWR VGND VPWR VGND sky130_ef_sc_hd__decap_12
XFILLER_72_528 VGND VGND VPWR VPWR sky130_fd_sc_hd__decap_4
XFILLER_37_260 VPWR VGND VPWR VGND sky130_ef_sc_hd__decap_12
XFILLER_65_591 VGND VGND VPWR VPWR sky130_fd_sc_hd__fill_1
XPHY_EDGE_ROW_64_Left_218 VGND VGND VPWR VPWR sky130_fd_sc_hd__decap_3
XFILLER_53_720 VGND VGND VPWR VPWR sky130_fd_sc_hd__decap_8
XFILLER_25_411 VPWR VGND VPWR VGND sky130_ef_sc_hd__decap_12
XFILLER_37_293 VGND VGND VPWR VPWR sky130_fd_sc_hd__decap_4
XFILLER_53_753 VPWR VGND VPWR VGND sky130_ef_sc_hd__decap_12
XFILLER_13_617 VPWR VGND VPWR VGND sky130_ef_sc_hd__decap_12
XFILLER_53_797 VPWR VGND VPWR VGND sky130_ef_sc_hd__decap_12
XTAP_TAPCELL_ROW_101_1946 VGND VPWR sky130_fd_sc_hd__tapvpwrvgnd_1
XFILLER_8_109 VPWR VGND VPWR VGND sky130_ef_sc_hd__decap_12
XFILLER_40_469 VGND VGND VPWR VPWR sky130_fd_sc_hd__decap_6
XTAP_TAPCELL_ROW_43_1020 VGND VPWR sky130_fd_sc_hd__tapvpwrvgnd_1
XFILLER_138_357 VGND VGND VPWR VPWR sky130_fd_sc_hd__decap_6
XFILLER_153_305 VGND VGND VPWR VPWR sky130_fd_sc_hd__decap_3
XPHY_EDGE_ROW_73_Left_227 VGND VGND VPWR VPWR sky130_fd_sc_hd__decap_3
XFILLER_153_349 VPWR VGND VPWR VGND sky130_ef_sc_hd__decap_12
XTAP_TAPCELL_ROW_134_2478 VGND VPWR sky130_fd_sc_hd__tapvpwrvgnd_1
XFILLER_106_221 VPWR VGND VPWR VGND sky130_ef_sc_hd__decap_12
XANTENNA__3280__RESET_B net36 VGND VGND VPWR VPWR sky130_fd_sc_hd__diode_2
XFILLER_122_725 VPWR VGND VPWR VGND sky130_ef_sc_hd__decap_12
XFILLER_107_777 VGND VGND VPWR VPWR sky130_fd_sc_hd__decap_6
XFILLER_106_265 VPWR VGND VPWR VGND sky130_ef_sc_hd__decap_12
XFILLER_79_105 VGND VGND VPWR VPWR sky130_fd_sc_hd__decap_6
XFILLER_0_510 VGND VGND VPWR VPWR sky130_fd_sc_hd__fill_2
XFILLER_122_769 VPWR VGND VPWR VGND sky130_ef_sc_hd__decap_12
XFILLER_110_909 VGND VGND VPWR VPWR sky130_fd_sc_hd__fill_1
XFILLER_121_279 VGND VGND VPWR VPWR sky130_fd_sc_hd__fill_1
XFILLER_102_482 VPWR VGND VPWR VGND sky130_ef_sc_hd__decap_12
XTAP_TAPCELL_ROW_54_1193 VGND VPWR sky130_fd_sc_hd__tapvpwrvgnd_1
XFILLER_48_525 VGND VGND VPWR VPWR sky130_fd_sc_hd__decap_6
XFILLER_0_587 VGND VGND VPWR VPWR sky130_fd_sc_hd__fill_1
XANTENNA_input26_A B_in[3] VGND VGND VPWR VPWR sky130_fd_sc_hd__diode_2
XFILLER_76_867 VGND VGND VPWR VPWR sky130_fd_sc_hd__fill_1
XFILLER_57_75 VPWR VGND VPWR VGND sky130_ef_sc_hd__decap_12
XPHY_EDGE_ROW_82_Left_236 VGND VGND VPWR VPWR sky130_fd_sc_hd__decap_3
XTAP_TAPCELL_ROW_3_381 VGND VPWR sky130_fd_sc_hd__tapvpwrvgnd_1
XFILLER_29_783 VGND VGND VPWR VPWR sky130_fd_sc_hd__fill_1
XFILLER_113_81 VPWR VGND VPWR VGND sky130_ef_sc_hd__decap_12
XFILLER_16_433 VGND VGND VPWR VPWR sky130_fd_sc_hd__decap_6
XFILLER_16_455 VPWR VGND VPWR VGND sky130_ef_sc_hd__decap_12
XFILLER_32_904 VGND VGND VPWR VPWR sky130_fd_sc_hd__decap_6
XFILLER_16_477 VPWR VGND VPWR VGND sky130_ef_sc_hd__decap_12
XFILLER_31_447 VGND VGND VPWR VPWR sky130_fd_sc_hd__fill_1
XFILLER_129_335 VGND VGND VPWR VPWR sky130_fd_sc_hd__fill_1
XTAP_TAPCELL_ROW_42_998 VGND VPWR sky130_fd_sc_hd__tapvpwrvgnd_1
XPHY_EDGE_ROW_91_Left_245 VGND VGND VPWR VPWR sky130_fd_sc_hd__decap_3
XFILLER_8_643 VGND VGND VPWR VPWR sky130_fd_sc_hd__fill_1
XFILLER_145_839 VGND VGND VPWR VPWR sky130_fd_sc_hd__fill_1
XFILLER_11_193 VPWR VGND VPWR VGND sky130_ef_sc_hd__decap_12
X_1650_ A_reg\[15\] A_reg\[13\] A_reg\[12\] VGND VGND VPWR VPWR _0926_ sky130_fd_sc_hd__and3_1
XFILLER_125_541 VPWR VGND VPWR VGND sky130_ef_sc_hd__decap_12
XTAP_TAPCELL_ROW_74_1514 VGND VPWR sky130_fd_sc_hd__tapvpwrvgnd_1
X_3320_ clknet_3_5__leaf_clk _0103_ net36 VGND VGND VPWR VPWR X_crt\[14\] sky130_fd_sc_hd__dfrtp_1
XFILLER_140_533 VPWR VGND VPWR VGND sky130_ef_sc_hd__decap_12
XFILLER_125_585 VPWR VGND VPWR VGND sky130_ef_sc_hd__decap_12
XFILLER_4_893 VPWR VGND VPWR VGND sky130_ef_sc_hd__decap_12
XFILLER_101_909 VGND VGND VPWR VPWR sky130_fd_sc_hd__fill_1
XFILLER_79_650 VPWR VGND VPWR VGND sky130_ef_sc_hd__decap_12
X_3251_ clknet_3_4__leaf_clk u_crt.start_d net36 VGND VGND VPWR VPWR CRT_Done sky130_fd_sc_hd__dfrtp_1
XFILLER_100_419 VGND VGND VPWR VPWR sky130_fd_sc_hd__fill_1
XFILLER_21_3 VPWR VGND VPWR VGND sky130_ef_sc_hd__decap_12
X_2202_ A_reg\[7\] _1455_ _1456_ _1457_ VGND VGND VPWR VPWR _1459_ sky130_fd_sc_hd__a211o_1
XFILLER_39_503 VGND VGND VPWR VPWR sky130_fd_sc_hd__fill_1
X_3182_ _0836_ _0858_ VGND VGND VPWR VPWR _0867_ sky130_fd_sc_hd__or2_1
X_2133_ _0906_ _1387_ _1389_ _1391_ VGND VGND VPWR VPWR _1392_ sky130_fd_sc_hd__o211ai_2
XFILLER_66_333 VPWR VGND VPWR VGND sky130_ef_sc_hd__decap_12
XFILLER_27_709 VPWR VGND VPWR VGND sky130_ef_sc_hd__decap_12
XTAP_TAPCELL_ROW_105_2013 VGND VPWR sky130_fd_sc_hd__tapvpwrvgnd_1
XFILLER_82_837 VPWR VGND VPWR VGND sky130_ef_sc_hd__decap_12
XFILLER_67_889 VGND VGND VPWR VPWR sky130_fd_sc_hd__decap_6
XFILLER_54_506 VGND VGND VPWR VPWR sky130_fd_sc_hd__fill_2
X_2064_ B_reg\[4\] _1322_ VGND VGND VPWR VPWR _1326_ sky130_fd_sc_hd__xnor2_1
XFILLER_50_701 VGND VGND VPWR VPWR sky130_fd_sc_hd__decap_6
XFILLER_35_753 VPWR VGND VPWR VGND sky130_ef_sc_hd__decap_12
XFILLER_90_881 VPWR VGND VPWR VGND sky130_ef_sc_hd__decap_12
XTAP_TAPCELL_ROW_85_1698 VGND VPWR sky130_fd_sc_hd__tapvpwrvgnd_1
XTAP_TAPCELL_ROW_85_1687 VGND VPWR sky130_fd_sc_hd__tapvpwrvgnd_1
XFILLER_35_797 VPWR VGND VPWR VGND sky130_ef_sc_hd__decap_12
XFILLER_22_436 VPWR VGND VPWR VGND sky130_ef_sc_hd__decap_12
X_2966_ _0652_ _0653_ VGND VGND VPWR VPWR _0654_ sky130_fd_sc_hd__nand2_1
X_2897_ _0576_ _0584_ VGND VGND VPWR VPWR _0585_ sky130_fd_sc_hd__and2_1
X_1917_ _1172_ _1181_ _1180_ VGND VGND VPWR VPWR _1182_ sky130_fd_sc_hd__a21oi_1
XTAP_TAPCELL_ROW_20_648 VGND VPWR sky130_fd_sc_hd__tapvpwrvgnd_1
XFILLER_148_699 VGND VGND VPWR VPWR sky130_fd_sc_hd__fill_1
XFILLER_135_305 VPWR VGND VPWR VGND sky130_ef_sc_hd__decap_12
XFILLER_118_15 VPWR VGND VPWR VGND sky130_ef_sc_hd__decap_12
X_1848_ A_reg\[11\] _1113_ _1115_ _1117_ VGND VGND VPWR VPWR _1118_ sky130_fd_sc_hd__a31o_1
XTAP_TAPCELL_ROW_20_659 VGND VPWR sky130_fd_sc_hd__tapvpwrvgnd_1
XFILLER_151_809 VPWR VGND VPWR VGND sky130_ef_sc_hd__decap_12
XFILLER_135_349 VPWR VGND VPWR VGND sky130_ef_sc_hd__decap_12
XTAP_TAPCELL_ROW_116_2186 VGND VPWR sky130_fd_sc_hd__tapvpwrvgnd_1
XFILLER_144_861 VGND VGND VPWR VPWR sky130_fd_sc_hd__decap_6
X_1779_ _0892_ _1051_ VGND VGND VPWR VPWR _1052_ sky130_fd_sc_hd__nand2_1
XFILLER_143_393 VPWR VGND VPWR VGND sky130_ef_sc_hd__decap_12
XFILLER_104_725 VPWR VGND VPWR VGND sky130_ef_sc_hd__decap_12
XFILLER_89_425 VGND VGND VPWR VPWR sky130_fd_sc_hd__fill_1
XFILLER_1_329 VGND VGND VPWR VPWR sky130_fd_sc_hd__decap_6
XPHY_EDGE_ROW_139_Left_293 VGND VGND VPWR VPWR sky130_fd_sc_hd__decap_3
XFILLER_104_769 VPWR VGND VPWR VGND sky130_ef_sc_hd__decap_12
XFILLER_77_609 VGND VGND VPWR VPWR sky130_fd_sc_hd__decap_6
XANTENNA__2497__A a_r1\[0\] VGND VGND VPWR VPWR sky130_fd_sc_hd__diode_2
XFILLER_103_279 VGND VGND VPWR VPWR sky130_fd_sc_hd__fill_1
XFILLER_84_141 VPWR VGND VPWR VGND sky130_ef_sc_hd__decap_12
XFILLER_41_712 VGND VGND VPWR VPWR sky130_fd_sc_hd__decap_6
XFILLER_13_447 VGND VGND VPWR VPWR sky130_fd_sc_hd__fill_1
XANTENNA__3241__CLK clknet_3_4__leaf_clk VGND VGND VPWR VPWR sky130_fd_sc_hd__diode_2
XFILLER_41_756 VPWR VGND VPWR VGND sky130_ef_sc_hd__decap_12
XFILLER_43_55 VGND VGND VPWR VPWR sky130_fd_sc_hd__fill_1
XTAP_TAPCELL_ROW_136_2507 VGND VPWR sky130_fd_sc_hd__tapvpwrvgnd_1
XFILLER_9_429 VPWR VGND VPWR VGND sky130_ef_sc_hd__decap_12
XFILLER_138_121 VPWR VGND VPWR VGND sky130_ef_sc_hd__decap_12
XFILLER_138_165 VPWR VGND VPWR VGND sky130_ef_sc_hd__decap_12
XFILLER_127_839 VGND VGND VPWR VPWR sky130_fd_sc_hd__fill_1
XFILLER_153_113 VPWR VGND VPWR VGND sky130_ef_sc_hd__decap_12
XFILLER_5_635 VGND VGND VPWR VPWR sky130_fd_sc_hd__decap_6
XTAP_TAPCELL_ROW_56_1222 VGND VPWR sky130_fd_sc_hd__tapvpwrvgnd_1
XFILLER_122_533 VPWR VGND VPWR VGND sky130_ef_sc_hd__decap_12
XFILLER_107_585 VPWR VGND VPWR VGND sky130_ef_sc_hd__decap_12
XTAP_TAPCELL_ROW_56_1233 VGND VPWR sky130_fd_sc_hd__tapvpwrvgnd_1
XFILLER_4_189 VGND VGND VPWR VPWR sky130_fd_sc_hd__decap_6
XFILLER_4_27 VGND VGND VPWR VPWR sky130_fd_sc_hd__fill_1
XTAP_TAPCELL_ROW_8_462 VGND VPWR sky130_fd_sc_hd__tapvpwrvgnd_1
XFILLER_1_841 VPWR VGND VPWR VGND sky130_ef_sc_hd__decap_12
XFILLER_76_642 VGND VGND VPWR VPWR sky130_fd_sc_hd__fill_2
XFILLER_48_333 VGND VGND VPWR VPWR sky130_fd_sc_hd__decap_8
XFILLER_76_675 VGND VGND VPWR VPWR sky130_fd_sc_hd__fill_2
XFILLER_48_377 VPWR VGND VPWR VGND sky130_ef_sc_hd__decap_12
XFILLER_64_837 VPWR VGND VPWR VGND sky130_ef_sc_hd__decap_12
XFILLER_29_591 VPWR VGND VPWR VGND sky130_ef_sc_hd__decap_12
XFILLER_17_753 VPWR VGND VPWR VGND sky130_ef_sc_hd__decap_12
XFILLER_72_881 VPWR VGND VPWR VGND sky130_ef_sc_hd__decap_12
XFILLER_17_797 VPWR VGND VPWR VGND sky130_ef_sc_hd__decap_12
XTAP_TAPCELL_ROW_27_770 VGND VPWR sky130_fd_sc_hd__tapvpwrvgnd_1
XFILLER_32_701 VPWR VGND VPWR VGND sky130_ef_sc_hd__decap_12
XFILLER_71_391 VGND VGND VPWR VPWR sky130_fd_sc_hd__fill_1
XANTENNA__2471__B1 _0186_ VGND VGND VPWR VPWR sky130_fd_sc_hd__diode_2
X_2820_ net46 X_crt\[2\] _0553_ VGND VGND VPWR VPWR _0043_ sky130_fd_sc_hd__mux2_1
X_2751_ _0185_ _0453_ _0490_ _0394_ OpSel_reg\[0\] VGND VGND VPWR VPWR _0491_ sky130_fd_sc_hd__a32o_1
XFILLER_117_305 VPWR VGND VPWR VGND sky130_ef_sc_hd__decap_12
X_2682_ a_r3\[2\] b_r3\[2\] VGND VGND VPWR VPWR _0422_ sky130_fd_sc_hd__and2_1
X_1702_ A_reg\[4\] _0971_ VGND VGND VPWR VPWR _0978_ sky130_fd_sc_hd__nor2_1
XFILLER_133_809 VPWR VGND VPWR VGND sky130_ef_sc_hd__decap_12
XFILLER_117_349 VPWR VGND VPWR VGND sky130_ef_sc_hd__decap_12
X_1633_ _0911_ VGND VGND VPWR VPWR Encode_EN sky130_fd_sc_hd__inv_6
XFILLER_126_861 VGND VGND VPWR VPWR sky130_fd_sc_hd__decap_6
XFILLER_141_853 VPWR VGND VPWR VGND sky130_ef_sc_hd__decap_12
XFILLER_125_393 VPWR VGND VPWR VGND sky130_ef_sc_hd__decap_12
X_3303_ clknet_3_0__leaf_clk _0086_ net36 VGND VGND VPWR VPWR B_reg\[13\] sky130_fd_sc_hd__dfrtp_4
XFILLER_4_690 VGND VGND VPWR VPWR sky130_fd_sc_hd__decap_8
XFILLER_141_897 VPWR VGND VPWR VGND sky130_ef_sc_hd__decap_12
XFILLER_140_363 VGND VGND VPWR VPWR sky130_fd_sc_hd__fill_1
XFILLER_98_288 VGND VGND VPWR VPWR sky130_fd_sc_hd__fill_2
XFILLER_98_266 VGND VGND VPWR VPWR sky130_fd_sc_hd__fill_1
X_3234_ clknet_3_3__leaf_clk _0021_ net36 VGND VGND VPWR VPWR a_r3\[2\] sky130_fd_sc_hd__dfrtp_4
XFILLER_94_450 VPWR VGND VPWR VGND sky130_ef_sc_hd__decap_12
XTAP_TAPCELL_ROW_87_1727 VGND VPWR sky130_fd_sc_hd__tapvpwrvgnd_1
XTAP_TAPCELL_ROW_87_1716 VGND VPWR sky130_fd_sc_hd__tapvpwrvgnd_1
XFILLER_82_601 VGND VGND VPWR VPWR sky130_fd_sc_hd__decap_4
XFILLER_66_141 VPWR VGND VPWR VGND sky130_ef_sc_hd__decap_12
X_3165_ _0820_ _0851_ VGND VGND VPWR VPWR _0853_ sky130_fd_sc_hd__nand2_1
XFILLER_27_517 VGND VGND VPWR VPWR sky130_fd_sc_hd__decap_4
XFILLER_82_645 VPWR VGND VPWR VGND sky130_ef_sc_hd__decap_12
XFILLER_82_623 VPWR VGND VPWR VGND sky130_ef_sc_hd__decap_12
XFILLER_81_111 VGND VGND VPWR VPWR sky130_fd_sc_hd__fill_1
X_2116_ _1372_ _1374_ B_reg\[8\] VGND VGND VPWR VPWR _1375_ sky130_fd_sc_hd__o21ai_1
XFILLER_66_185 VGND VGND VPWR VPWR sky130_fd_sc_hd__decap_8
X_3096_ _0763_ _0783_ VGND VGND VPWR VPWR _0784_ sky130_fd_sc_hd__and2_1
X_2047_ B_reg\[6\] _1300_ _1306_ VGND VGND VPWR VPWR _1309_ sky130_fd_sc_hd__or3_1
XANTENNA__3264__CLK clknet_3_7__leaf_clk VGND VGND VPWR VPWR sky130_fd_sc_hd__diode_2
XFILLER_120_27 VGND VGND VPWR VPWR sky130_fd_sc_hd__fill_1
XTAP_TAPCELL_ROW_25_729 VGND VPWR sky130_fd_sc_hd__tapvpwrvgnd_1
XFILLER_35_583 VPWR VGND VPWR VGND sky130_ef_sc_hd__decap_12
XANTENNA__2462__B1 _0184_ VGND VGND VPWR VPWR sky130_fd_sc_hd__diode_2
XANTENNA__3219__RESET_B net36 VGND VGND VPWR VPWR sky130_fd_sc_hd__diode_2
XFILLER_50_531 VGND VGND VPWR VPWR sky130_fd_sc_hd__fill_1
XFILLER_50_586 VGND VGND VPWR VPWR sky130_fd_sc_hd__fill_2
XTAP_TAPCELL_ROW_118_2226 VGND VPWR sky130_fd_sc_hd__tapvpwrvgnd_1
XTAP_TAPCELL_ROW_118_2215 VGND VPWR sky130_fd_sc_hd__tapvpwrvgnd_1
X_2949_ _0596_ _0616_ _0636_ _0615_ VGND VGND VPWR VPWR _0637_ sky130_fd_sc_hd__o211a_1
XFILLER_22_288 VPWR VGND VPWR VGND sky130_ef_sc_hd__decap_12
XANTENNA__2214__B1 A_reg\[6\] VGND VGND VPWR VPWR sky130_fd_sc_hd__diode_2
XFILLER_136_625 VPWR VGND VPWR VGND sky130_ef_sc_hd__decap_12
XFILLER_109_839 VGND VGND VPWR VPWR sky130_fd_sc_hd__fill_1
XFILLER_13_69 VPWR VGND VPWR VGND sky130_ef_sc_hd__decap_12
XFILLER_135_113 VPWR VGND VPWR VGND sky130_ef_sc_hd__decap_12
XFILLER_129_69 VPWR VGND VPWR VGND sky130_ef_sc_hd__decap_12
XFILLER_151_617 VPWR VGND VPWR VGND sky130_ef_sc_hd__decap_12
XFILLER_136_669 VPWR VGND VPWR VGND sky130_ef_sc_hd__decap_12
XTAP_TAPCELL_ROW_131_2426 VGND VPWR sky130_fd_sc_hd__tapvpwrvgnd_1
XPHY_EDGE_ROW_147_Left_301 VGND VGND VPWR VPWR sky130_fd_sc_hd__decap_3
XFILLER_104_500 VPWR VGND VPWR VGND sky130_ef_sc_hd__decap_12
XFILLER_2_616 VPWR VGND VPWR VGND sky130_ef_sc_hd__decap_12
XFILLER_145_57 VPWR VGND VPWR VGND sky130_ef_sc_hd__decap_12
XFILLER_104_533 VPWR VGND VPWR VGND sky130_ef_sc_hd__decap_12
XFILLER_1_137 VPWR VGND VPWR VGND sky130_ef_sc_hd__decap_12
XFILLER_131_385 VGND VGND VPWR VPWR sky130_fd_sc_hd__decap_6
XFILLER_89_266 VGND VGND VPWR VPWR sky130_fd_sc_hd__decap_6
XFILLER_77_417 VPWR VGND VPWR VGND sky130_ef_sc_hd__decap_12
XTAP_TAPCELL_ROW_5_410 VGND VPWR sky130_fd_sc_hd__tapvpwrvgnd_1
XTAP_TAPCELL_ROW_51_1152 VGND VPWR sky130_fd_sc_hd__tapvpwrvgnd_1
XTAP_TAPCELL_ROW_51_1141 VGND VPWR sky130_fd_sc_hd__tapvpwrvgnd_1
XTAP_TAPCELL_ROW_129_2399 VGND VPWR sky130_fd_sc_hd__tapvpwrvgnd_1
XTAP_TAPCELL_ROW_129_2388 VGND VPWR sky130_fd_sc_hd__tapvpwrvgnd_1
XFILLER_85_461 VPWR VGND VPWR VGND sky130_ef_sc_hd__decap_12
XFILLER_46_815 VGND VGND VPWR VPWR sky130_fd_sc_hd__fill_2
XFILLER_38_77 VGND VGND VPWR VPWR sky130_fd_sc_hd__decap_6
XFILLER_54_10 VPWR VGND VPWR VGND sky130_ef_sc_hd__decap_12
XTAP_TAPCELL_ROW_142_2599 VGND VPWR sky130_fd_sc_hd__tapvpwrvgnd_1
XFILLER_54_65 VGND VGND VPWR VPWR sky130_fd_sc_hd__decap_6
XFILLER_14_701 VPWR VGND VPWR VGND sky130_ef_sc_hd__decap_12
XFILLER_26_583 VGND VGND VPWR VPWR sky130_fd_sc_hd__decap_4
XFILLER_53_391 VGND VGND VPWR VPWR sky130_fd_sc_hd__fill_1
XFILLER_41_553 VGND VGND VPWR VPWR sky130_fd_sc_hd__decap_6
XFILLER_139_441 VGND VGND VPWR VPWR sky130_fd_sc_hd__decap_6
XFILLER_70_53 VPWR VGND VPWR VGND sky130_ef_sc_hd__decap_12
XFILLER_9_237 VPWR VGND VPWR VGND sky130_ef_sc_hd__decap_12
XFILLER_41_597 VPWR VGND VPWR VGND sky130_ef_sc_hd__decap_12
XFILLER_139_485 VPWR VGND VPWR VGND sky130_ef_sc_hd__decap_12
XFILLER_115_809 VPWR VGND VPWR VGND sky130_ef_sc_hd__decap_12
XFILLER_108_861 VGND VGND VPWR VPWR sky130_fd_sc_hd__decap_6
XANTENNA__3294__Q B_reg\[4\] VGND VGND VPWR VPWR sky130_fd_sc_hd__diode_2
XTAP_TAPCELL_ROW_149_2709 VGND VPWR sky130_fd_sc_hd__tapvpwrvgnd_1
XFILLER_141_105 VGND VGND VPWR VPWR sky130_fd_sc_hd__decap_6
XFILLER_141_149 VPWR VGND VPWR VGND sky130_ef_sc_hd__decap_12
XFILLER_123_853 VPWR VGND VPWR VGND sky130_ef_sc_hd__decap_12
XFILLER_123_897 VPWR VGND VPWR VGND sky130_ef_sc_hd__decap_12
XFILLER_122_363 VGND VGND VPWR VPWR sky130_fd_sc_hd__fill_1
XFILLER_110_525 VGND VGND VPWR VPWR sky130_fd_sc_hd__fill_2
XFILLER_96_737 VPWR VGND VPWR VGND sky130_ef_sc_hd__decap_12
XFILLER_1_671 VGND VGND VPWR VPWR sky130_fd_sc_hd__fill_1
XFILLER_95_225 VPWR VGND VPWR VGND sky130_ef_sc_hd__decap_12
XFILLER_68_439 VPWR VGND VPWR VGND sky130_ef_sc_hd__decap_12
XFILLER_0_181 VPWR VGND VPWR VGND sky130_ef_sc_hd__decap_12
XFILLER_110_569 VPWR VGND VPWR VGND sky130_ef_sc_hd__decap_12
XFILLER_95_61 VGND VGND VPWR VPWR sky130_fd_sc_hd__fill_1
XFILLER_64_601 VPWR VGND VPWR VGND sky130_ef_sc_hd__decap_12
XFILLER_48_141 VPWR VGND VPWR VGND sky130_ef_sc_hd__decap_12
XANTENNA__3287__CLK clknet_3_5__leaf_clk VGND VGND VPWR VPWR sky130_fd_sc_hd__diode_2
XTAP_TAPCELL_ROW_69_1435 VGND VPWR sky130_fd_sc_hd__tapvpwrvgnd_1
XFILLER_64_645 VPWR VGND VPWR VGND sky130_ef_sc_hd__decap_12
XFILLER_49_697 VPWR VGND VPWR VGND sky130_ef_sc_hd__decap_12
XFILLER_36_303 VGND VGND VPWR VPWR sky130_fd_sc_hd__decap_4
XFILLER_63_133 VGND VGND VPWR VPWR sky130_fd_sc_hd__decap_3
XFILLER_17_561 VPWR VGND VPWR VGND sky130_ef_sc_hd__decap_12
XFILLER_45_870 VPWR VGND VPWR VGND sky130_ef_sc_hd__decap_12
XTAP_TAPCELL_ROW_82_1646 VGND VPWR sky130_fd_sc_hd__tapvpwrvgnd_1
XFILLER_32_531 VGND VGND VPWR VPWR sky130_fd_sc_hd__fill_1
XFILLER_149_205 VPWR VGND VPWR VGND sky130_ef_sc_hd__decap_12
XANTENNA__3312__RESET_B net36 VGND VGND VPWR VPWR sky130_fd_sc_hd__diode_2
XFILLER_32_553 VGND VGND VPWR VPWR sky130_fd_sc_hd__decap_4
XFILLER_149_249 VPWR VGND VPWR VGND sky130_ef_sc_hd__decap_12
X_2803_ _0390_ _0542_ VGND VGND VPWR VPWR _0543_ sky130_fd_sc_hd__nand2_1
XFILLER_20_737 VPWR VGND VPWR VGND sky130_ef_sc_hd__decap_12
XFILLER_32_586 VGND VGND VPWR VPWR sky130_fd_sc_hd__fill_2
XFILLER_118_625 VPWR VGND VPWR VGND sky130_ef_sc_hd__decap_12
XFILLER_117_113 VPWR VGND VPWR VGND sky130_ef_sc_hd__decap_12
X_2734_ a_r3\[3\] b_r3\[1\] _0467_ VGND VGND VPWR VPWR _0474_ sky130_fd_sc_hd__a21oi_1
XFILLER_133_617 VPWR VGND VPWR VGND sky130_ef_sc_hd__decap_12
XFILLER_118_669 VPWR VGND VPWR VGND sky130_ef_sc_hd__decap_12
XTAP_TAPCELL_ROW_113_2134 VGND VPWR sky130_fd_sc_hd__tapvpwrvgnd_1
X_2665_ _0402_ _0404_ _0400_ VGND VGND VPWR VPWR _0405_ sky130_fd_sc_hd__o21ai_1
XANTENNA__1944__A B_reg\[6\] VGND VGND VPWR VPWR sky130_fd_sc_hd__diode_2
XTAP_TAPCELL_ROW_113_2145 VGND VPWR sky130_fd_sc_hd__tapvpwrvgnd_1
X_2596_ a_r2\[1\] b_r2\[1\] a_r2\[0\] b_r2\[0\] VGND VGND VPWR VPWR _0341_ sky130_fd_sc_hd__o211a_1
X_1616_ A_reg\[3\] VGND VGND VPWR VPWR _0896_ sky130_fd_sc_hd__inv_2
XFILLER_5_81 VPWR VGND VPWR VGND sky130_ef_sc_hd__decap_12
XFILLER_115_27 VPWR VGND VPWR VGND sky130_ef_sc_hd__decap_12
XFILLER_59_417 VPWR VGND VPWR VGND sky130_ef_sc_hd__decap_12
XFILLER_113_385 VGND VGND VPWR VPWR sky130_fd_sc_hd__decap_6
XFILLER_67_461 VPWR VGND VPWR VGND sky130_ef_sc_hd__decap_12
X_3217_ clknet_3_4__leaf_clk _0005_ net36 VGND VGND VPWR VPWR a_r1\[2\] sky130_fd_sc_hd__dfrtp_4
XFILLER_131_15 VPWR VGND VPWR VGND sky130_ef_sc_hd__decap_12
XFILLER_55_634 VPWR VGND VPWR VGND sky130_ef_sc_hd__decap_12
XFILLER_28_837 VPWR VGND VPWR VGND sky130_ef_sc_hd__decap_12
X_3148_ _0832_ _0835_ _0834_ VGND VGND VPWR VPWR _0836_ sky130_fd_sc_hd__or3b_1
X_3079_ _0610_ _0654_ _0766_ VGND VGND VPWR VPWR _0767_ sky130_fd_sc_hd__and3_1
XFILLER_82_475 VGND VGND VPWR VPWR sky130_fd_sc_hd__fill_1
XFILLER_54_188 VGND VGND VPWR VPWR sky130_fd_sc_hd__decap_8
XFILLER_36_881 VPWR VGND VPWR VGND sky130_ef_sc_hd__decap_12
XFILLER_23_553 VGND VGND VPWR VPWR sky130_fd_sc_hd__decap_6
XFILLER_51_895 VGND VGND VPWR VPWR sky130_fd_sc_hd__fill_1
XFILLER_23_597 VPWR VGND VPWR VGND sky130_ef_sc_hd__decap_12
XFILLER_149_783 VGND VGND VPWR VPWR sky130_fd_sc_hd__fill_1
XFILLER_136_433 VPWR VGND VPWR VGND sky130_ef_sc_hd__decap_12
XPHY_EDGE_ROW_149_Right_149 VGND VGND VPWR VPWR sky130_fd_sc_hd__decap_3
XFILLER_136_477 VPWR VGND VPWR VGND sky130_ef_sc_hd__decap_12
XFILLER_123_105 VGND VGND VPWR VPWR sky130_fd_sc_hd__decap_6
XFILLER_151_447 VGND VGND VPWR VPWR sky130_fd_sc_hd__fill_1
XFILLER_123_149 VPWR VGND VPWR VGND sky130_ef_sc_hd__decap_12
XFILLER_105_853 VPWR VGND VPWR VGND sky130_ef_sc_hd__decap_12
XFILLER_105_897 VPWR VGND VPWR VGND sky130_ef_sc_hd__decap_12
XFILLER_131_193 VPWR VGND VPWR VGND sky130_ef_sc_hd__decap_12
XFILLER_77_225 VGND VGND VPWR VPWR sky130_fd_sc_hd__decap_8
XTAP_TAPCELL_ROW_144_2639 VGND VPWR sky130_fd_sc_hd__tapvpwrvgnd_1
XTAP_TAPCELL_ROW_144_2628 VGND VPWR sky130_fd_sc_hd__tapvpwrvgnd_1
XFILLER_120_867 VGND VGND VPWR VPWR sky130_fd_sc_hd__fill_1
XFILLER_93_729 VPWR VGND VPWR VGND sky130_ef_sc_hd__decap_12
XFILLER_46_601 VGND VGND VPWR VPWR sky130_fd_sc_hd__decap_8
XFILLER_105_93 VPWR VGND VPWR VGND sky130_ef_sc_hd__decap_12
XFILLER_86_781 VPWR VGND VPWR VGND sky130_ef_sc_hd__decap_12
XFILLER_1_39 VPWR VGND VPWR VGND sky130_ef_sc_hd__decap_12
XFILLER_45_111 VGND VGND VPWR VPWR sky130_fd_sc_hd__fill_1
XANTENNA__2674__B1 _0187_ VGND VGND VPWR VPWR sky130_fd_sc_hd__diode_2
XFILLER_46_645 VGND VGND VPWR VPWR sky130_fd_sc_hd__decap_8
XFILLER_61_615 VGND VGND VPWR VPWR sky130_fd_sc_hd__fill_1
XANTENNA__3289__Q A_reg\[15\] VGND VGND VPWR VPWR sky130_fd_sc_hd__diode_2
XFILLER_14_531 VGND VGND VPWR VPWR sky130_fd_sc_hd__fill_1
XFILLER_121_81 VPWR VGND VPWR VGND sky130_ef_sc_hd__decap_12
XTAP_TAPCELL_ROW_64_1354 VGND VPWR sky130_fd_sc_hd__tapvpwrvgnd_1
XFILLER_42_862 VGND VGND VPWR VPWR sky130_fd_sc_hd__decap_6
XFILLER_147_709 VPWR VGND VPWR VGND sky130_ef_sc_hd__decap_12
XFILLER_41_383 VGND VGND VPWR VPWR sky130_fd_sc_hd__decap_4
XFILLER_139_293 VPWR VGND VPWR VGND sky130_ef_sc_hd__decap_12
XFILLER_10_781 VPWR VGND VPWR VGND sky130_ef_sc_hd__decap_12
XPHY_EDGE_ROW_116_Right_116 VGND VGND VPWR VPWR sky130_fd_sc_hd__decap_3
XFILLER_115_617 VPWR VGND VPWR VGND sky130_ef_sc_hd__decap_12
X_2450_ a_r0\[0\] b_r0\[0\] a_r0\[1\] b_r0\[1\] VGND VGND VPWR VPWR _0200_ sky130_fd_sc_hd__and4_1
XFILLER_142_469 VGND VGND VPWR VPWR sky130_fd_sc_hd__decap_6
X_2381_ _0127_ _0129_ _0132_ _0134_ VGND VGND VPWR VPWR _0135_ sky130_fd_sc_hd__a31o_1
XFILLER_96_512 VPWR VGND VPWR VGND sky130_ef_sc_hd__decap_12
XFILLER_110_333 VPWR VGND VPWR VGND sky130_ef_sc_hd__decap_12
XFILLER_96_545 VPWR VGND VPWR VGND sky130_ef_sc_hd__decap_12
XANTENNA__2866__Y _0554_ VGND VGND VPWR VPWR sky130_fd_sc_hd__diode_2
XFILLER_111_889 VGND VGND VPWR VPWR sky130_fd_sc_hd__decap_6
XFILLER_96_589 VPWR VGND VPWR VGND sky130_ef_sc_hd__decap_12
XFILLER_96_578 VGND VGND VPWR VPWR sky130_fd_sc_hd__decap_8
XFILLER_110_377 VPWR VGND VPWR VGND sky130_ef_sc_hd__decap_12
XFILLER_83_217 VGND VGND VPWR VPWR sky130_fd_sc_hd__decap_6
X_3002_ _0587_ _0670_ VGND VGND VPWR VPWR _0690_ sky130_fd_sc_hd__and2_1
XFILLER_49_461 VPWR VGND VPWR VGND sky130_ef_sc_hd__decap_12
Xinput5 A_in[13] VGND VGND VPWR VPWR net5 sky130_fd_sc_hd__clkbuf_1
XFILLER_76_280 VGND VGND VPWR VPWR sky130_fd_sc_hd__decap_8
XFILLER_64_431 VGND VGND VPWR VPWR sky130_fd_sc_hd__fill_2
XFILLER_36_133 VGND VGND VPWR VPWR sky130_fd_sc_hd__decap_6
XFILLER_91_261 VPWR VGND VPWR VGND sky130_ef_sc_hd__decap_12
XFILLER_64_486 VPWR VGND VPWR VGND sky130_ef_sc_hd__decap_12
XFILLER_18_881 VPWR VGND VPWR VGND sky130_ef_sc_hd__decap_12
XFILLER_36_177 VPWR VGND VPWR VGND sky130_ef_sc_hd__decap_12
XFILLER_52_637 VGND VGND VPWR VPWR sky130_fd_sc_hd__decap_6
XFILLER_51_169 VPWR VGND VPWR VGND sky130_ef_sc_hd__decap_12
XANTENNA__3302__CLK clknet_3_0__leaf_clk VGND VGND VPWR VPWR sky130_fd_sc_hd__diode_2
XTAP_TAPCELL_ROW_15_570 VGND VPWR sky130_fd_sc_hd__tapvpwrvgnd_1
XFILLER_20_501 VPWR VGND VPWR VGND sky130_ef_sc_hd__decap_12
XFILLER_32_361 VGND VGND VPWR VPWR sky130_fd_sc_hd__fill_1
XFILLER_33_895 VGND VGND VPWR VPWR sky130_fd_sc_hd__fill_1
XFILLER_20_545 VPWR VGND VPWR VGND sky130_ef_sc_hd__decap_12
XFILLER_118_433 VPWR VGND VPWR VGND sky130_ef_sc_hd__decap_12
XFILLER_20_589 VPWR VGND VPWR VGND sky130_ef_sc_hd__decap_12
X_2717_ _0455_ _0456_ VGND VGND VPWR VPWR _0457_ sky130_fd_sc_hd__nor2_1
XFILLER_118_477 VPWR VGND VPWR VGND sky130_ef_sc_hd__decap_12
XFILLER_105_105 VGND VGND VPWR VPWR sky130_fd_sc_hd__decap_6
XTAP_TAPCELL_ROW_95_1859 VGND VPWR sky130_fd_sc_hd__tapvpwrvgnd_1
XTAP_TAPCELL_ROW_95_1848 VGND VPWR sky130_fd_sc_hd__tapvpwrvgnd_1
XFILLER_10_15 VPWR VGND VPWR VGND sky130_ef_sc_hd__decap_12
XFILLER_133_447 VGND VGND VPWR VPWR sky130_fd_sc_hd__fill_1
XFILLER_126_15 VPWR VGND VPWR VGND sky130_ef_sc_hd__decap_12
XFILLER_121_609 VGND VGND VPWR VPWR sky130_fd_sc_hd__decap_6
XFILLER_105_149 VPWR VGND VPWR VGND sky130_ef_sc_hd__decap_12
X_2648_ _0186_ _0387_ VGND VGND VPWR VPWR _0388_ sky130_fd_sc_hd__nor2_1
XFILLER_99_361 VGND VGND VPWR VPWR sky130_fd_sc_hd__decap_8
X_2579_ _0307_ _0313_ _0321_ _0323_ _0317_ VGND VGND VPWR VPWR _0324_ sky130_fd_sc_hd__a221o_1
XFILLER_59_225 VPWR VGND VPWR VGND sky130_ef_sc_hd__decap_12
XFILLER_113_193 VPWR VGND VPWR VGND sky130_ef_sc_hd__decap_12
XFILLER_102_867 VGND VGND VPWR VPWR sky130_fd_sc_hd__fill_1
XFILLER_75_729 VPWR VGND VPWR VGND sky130_ef_sc_hd__decap_12
XTAP_TAPCELL_ROW_126_2347 VGND VPWR sky130_fd_sc_hd__tapvpwrvgnd_1
XFILLER_68_781 VPWR VGND VPWR VGND sky130_ef_sc_hd__decap_12
XFILLER_19_57 VPWR VGND VPWR VGND sky130_ef_sc_hd__decap_12
XFILLER_28_601 VPWR VGND VPWR VGND sky130_ef_sc_hd__decap_12
XANTENNA__3234__RESET_B net36 VGND VGND VPWR VPWR sky130_fd_sc_hd__diode_2
XFILLER_27_111 VGND VGND VPWR VPWR sky130_fd_sc_hd__fill_1
XFILLER_28_645 VPWR VGND VPWR VGND sky130_ef_sc_hd__decap_12
XFILLER_15_317 VPWR VGND VPWR VGND sky130_ef_sc_hd__decap_12
XFILLER_43_615 VGND VGND VPWR VPWR sky130_fd_sc_hd__fill_1
XFILLER_70_456 VPWR VGND VPWR VGND sky130_ef_sc_hd__decap_12
XTAP_TAPCELL_ROW_46_1062 VGND VPWR sky130_fd_sc_hd__tapvpwrvgnd_1
XFILLER_129_709 VPWR VGND VPWR VGND sky130_ef_sc_hd__decap_12
XTAP_TAPCELL_ROW_104_1999 VGND VPWR sky130_fd_sc_hd__tapvpwrvgnd_1
XTAP_TAPCELL_ROW_104_1988 VGND VPWR sky130_fd_sc_hd__tapvpwrvgnd_1
XFILLER_51_11 VGND VGND VPWR VPWR sky130_fd_sc_hd__fill_1
XTAP_TAPCELL_ROW_46_1073 VGND VPWR sky130_fd_sc_hd__tapvpwrvgnd_1
XFILLER_11_501 VGND VGND VPWR VPWR sky130_fd_sc_hd__decap_3
XFILLER_136_3 VPWR VGND VPWR VGND sky130_ef_sc_hd__decap_12
XFILLER_7_505 VPWR VGND VPWR VGND sky130_ef_sc_hd__decap_12
XFILLER_11_589 VPWR VGND VPWR VGND sky130_ef_sc_hd__decap_12
XFILLER_152_701 VPWR VGND VPWR VGND sky130_ef_sc_hd__decap_12
XFILLER_137_753 VPWR VGND VPWR VGND sky130_ef_sc_hd__decap_12
XFILLER_137_797 VPWR VGND VPWR VGND sky130_ef_sc_hd__decap_12
XFILLER_2_221 VPWR VGND VPWR VGND sky130_ef_sc_hd__decap_12
XFILLER_124_469 VGND VGND VPWR VPWR sky130_fd_sc_hd__decap_6
XFILLER_97_309 VPWR VGND VPWR VGND sky130_ef_sc_hd__decap_12
XFILLER_78_501 VPWR VGND VPWR VGND sky130_ef_sc_hd__decap_12
XFILLER_3_777 VGND VGND VPWR VPWR sky130_fd_sc_hd__decap_6
XFILLER_78_545 VPWR VGND VPWR VGND sky130_ef_sc_hd__decap_12
XFILLER_66_718 VPWR VGND VPWR VGND sky130_ef_sc_hd__decap_12
XFILLER_38_409 VGND VGND VPWR VPWR sky130_fd_sc_hd__fill_1
XFILLER_93_515 VPWR VGND VPWR VGND sky130_ef_sc_hd__decap_12
XFILLER_78_589 VGND VGND VPWR VPWR sky130_fd_sc_hd__decap_8
XFILLER_76_63 VPWR VGND VPWR VGND sky130_ef_sc_hd__decap_12
XFILLER_59_770 VPWR VGND VPWR VGND sky130_ef_sc_hd__decap_12
XFILLER_93_559 VGND VGND VPWR VPWR sky130_fd_sc_hd__fill_1
XANTENNA_input11_X net11 VGND VGND VPWR VPWR sky130_fd_sc_hd__diode_2
XFILLER_58_280 VPWR VGND VPWR VGND sky130_ef_sc_hd__decap_12
XFILLER_18_133 VGND VGND VPWR VPWR sky130_fd_sc_hd__decap_6
XFILLER_73_261 VPWR VGND VPWR VGND sky130_ef_sc_hd__decap_12
XFILLER_18_177 VPWR VGND VPWR VGND sky130_ef_sc_hd__decap_12
XFILLER_33_125 VPWR VGND VPWR VGND sky130_ef_sc_hd__decap_12
XFILLER_34_637 VGND VGND VPWR VPWR sky130_fd_sc_hd__decap_6
XFILLER_33_169 VPWR VGND VPWR VGND sky130_ef_sc_hd__decap_12
X_1950_ _1213_ _1214_ VGND VGND VPWR VPWR _1215_ sky130_fd_sc_hd__nor2_1
XFILLER_14_361 VGND VGND VPWR VPWR sky130_fd_sc_hd__decap_3
XFILLER_15_895 VGND VGND VPWR VPWR sky130_fd_sc_hd__fill_1
XTAP_TAPCELL_ROW_32_838 VGND VPWR sky130_fd_sc_hd__tapvpwrvgnd_1
XTAP_TAPCELL_ROW_32_849 VGND VPWR sky130_fd_sc_hd__tapvpwrvgnd_1
XFILLER_147_517 VPWR VGND VPWR VGND sky130_ef_sc_hd__decap_12
X_1881_ _1148_ _1150_ A_reg\[2\] VGND VGND VPWR VPWR _1151_ sky130_fd_sc_hd__mux2_1
XTAP_TAPCELL_ROW_77_1556 VGND VPWR sky130_fd_sc_hd__tapvpwrvgnd_1
X_2502_ b_r1\[0\] a_r1\[2\] _0222_ VGND VGND VPWR VPWR _0250_ sky130_fd_sc_hd__a21o_1
XFILLER_142_233 VPWR VGND VPWR VGND sky130_ef_sc_hd__decap_12
XFILLER_115_447 VGND VGND VPWR VPWR sky130_fd_sc_hd__fill_1
XTAP_TAPCELL_ROW_77_1567 VGND VPWR sky130_fd_sc_hd__tapvpwrvgnd_1
XFILLER_51_3 VGND VGND VPWR VPWR sky130_fd_sc_hd__decap_8
XFILLER_142_277 VPWR VGND VPWR VGND sky130_ef_sc_hd__decap_12
X_2433_ Encode_EN _0174_ _0183_ _0182_ VGND VGND VPWR VPWR _0026_ sky130_fd_sc_hd__a31o_1
XFILLER_88_309 VPWR VGND VPWR VGND sky130_ef_sc_hd__decap_12
XPHY_EDGE_ROW_102_Left_256 VGND VGND VPWR VPWR sky130_fd_sc_hd__decap_3
XFILLER_97_821 VPWR VGND VPWR VGND sky130_ef_sc_hd__decap_12
X_2364_ _0905_ _0114_ _0116_ VGND VGND VPWR VPWR _0118_ sky130_fd_sc_hd__or3_1
XTAP_TAPCELL_ROW_90_1767 VGND VPWR sky130_fd_sc_hd__tapvpwrvgnd_1
XFILLER_111_653 VPWR VGND VPWR VGND sky130_ef_sc_hd__decap_12
XFILLER_110_141 VPWR VGND VPWR VGND sky130_ef_sc_hd__decap_12
XFILLER_97_865 VPWR VGND VPWR VGND sky130_ef_sc_hd__decap_12
XFILLER_96_342 VPWR VGND VPWR VGND sky130_ef_sc_hd__decap_12
XTAP_TAPCELL_ROW_90_1778 VGND VPWR sky130_fd_sc_hd__tapvpwrvgnd_1
XFILLER_111_697 VPWR VGND VPWR VGND sky130_ef_sc_hd__decap_12
X_2295_ a_r3\[3\] _0911_ _1547_ _1548_ VGND VGND VPWR VPWR _0022_ sky130_fd_sc_hd__a22o_1
XFILLER_57_729 VPWR VGND VPWR VGND sky130_ef_sc_hd__decap_12
XTAP_TAPCELL_ROW_108_2066 VGND VPWR sky130_fd_sc_hd__tapvpwrvgnd_1
XTAP_TAPCELL_ROW_108_2055 VGND VPWR sky130_fd_sc_hd__tapvpwrvgnd_1
XANTENNA__2638__B1 _0910_ VGND VGND VPWR VPWR sky130_fd_sc_hd__diode_2
XFILLER_71_209 VGND VGND VPWR VPWR sky130_fd_sc_hd__fill_1
XFILLER_52_401 VPWR VGND VPWR VGND sky130_ef_sc_hd__decap_12
XFILLER_25_615 VGND VGND VPWR VPWR sky130_fd_sc_hd__fill_1
XTAP_TAPCELL_ROW_121_2266 VGND VPWR sky130_fd_sc_hd__tapvpwrvgnd_1
XFILLER_80_754 VGND VGND VPWR VPWR sky130_fd_sc_hd__fill_2
XFILLER_52_456 VPWR VGND VPWR VGND sky130_ef_sc_hd__decap_12
XFILLER_52_445 VGND VGND VPWR VPWR sky130_fd_sc_hd__decap_8
XFILLER_12_309 VPWR VGND VPWR VGND sky130_ef_sc_hd__decap_12
XPHY_EDGE_ROW_111_Left_265 VGND VGND VPWR VPWR sky130_fd_sc_hd__decap_3
XFILLER_21_821 VPWR VGND VPWR VGND sky130_ef_sc_hd__decap_12
XFILLER_21_865 VPWR VGND VPWR VGND sky130_ef_sc_hd__decap_12
XFILLER_119_753 VPWR VGND VPWR VGND sky130_ef_sc_hd__decap_12
XFILLER_134_701 VPWR VGND VPWR VGND sky130_ef_sc_hd__decap_12
XFILLER_119_797 VPWR VGND VPWR VGND sky130_ef_sc_hd__decap_12
XFILLER_21_69 VPWR VGND VPWR VGND sky130_ef_sc_hd__decap_12
XFILLER_137_69 VPWR VGND VPWR VGND sky130_ef_sc_hd__decap_12
XFILLER_106_425 VPWR VGND VPWR VGND sky130_ef_sc_hd__decap_12
XFILLER_121_417 VPWR VGND VPWR VGND sky130_ef_sc_hd__decap_12
XPHY_EDGE_ROW_120_Left_274 VGND VGND VPWR VPWR sky130_fd_sc_hd__decap_3
XFILLER_0_725 VGND VGND VPWR VPWR sky130_fd_sc_hd__decap_3
XFILLER_153_57 VPWR VGND VPWR VGND sky130_ef_sc_hd__decap_12
XFILLER_0_769 VPWR VGND VPWR VGND sky130_ef_sc_hd__decap_12
XFILLER_47_217 VGND VGND VPWR VPWR sky130_fd_sc_hd__decap_6
XFILLER_75_559 VGND VGND VPWR VPWR sky130_fd_sc_hd__fill_1
XFILLER_56_773 VGND VGND VPWR VPWR sky130_fd_sc_hd__decap_4
XTAP_TAPCELL_ROW_48_1102 VGND VPWR sky130_fd_sc_hd__tapvpwrvgnd_1
XFILLER_28_475 VGND VGND VPWR VPWR sky130_fd_sc_hd__fill_1
XTAP_TAPCELL_ROW_39_960 VGND VPWR sky130_fd_sc_hd__tapvpwrvgnd_1
XFILLER_46_77 VGND VGND VPWR VPWR sky130_fd_sc_hd__decap_6
XFILLER_71_721 VGND VGND VPWR VPWR sky130_fd_sc_hd__decap_6
XFILLER_56_795 VGND VGND VPWR VPWR sky130_fd_sc_hd__decap_6
XFILLER_55_272 VGND VGND VPWR VPWR sky130_fd_sc_hd__decap_8
XFILLER_15_125 VPWR VGND VPWR VGND sky130_ef_sc_hd__decap_12
XFILLER_16_637 VGND VGND VPWR VPWR sky130_fd_sc_hd__decap_6
XFILLER_71_765 VPWR VGND VPWR VGND sky130_ef_sc_hd__decap_12
XFILLER_70_253 VPWR VGND VPWR VGND sky130_ef_sc_hd__decap_12
XFILLER_70_231 VGND VGND VPWR VPWR sky130_fd_sc_hd__fill_1
XFILLER_15_169 VPWR VGND VPWR VGND sky130_ef_sc_hd__decap_12
XFILLER_102_83 VGND VGND VPWR VPWR sky130_fd_sc_hd__fill_1
XTAP_TAPCELL_ROW_61_1313 VGND VPWR sky130_fd_sc_hd__tapvpwrvgnd_1
XTAP_TAPCELL_ROW_61_1302 VGND VPWR sky130_fd_sc_hd__tapvpwrvgnd_1
XFILLER_24_681 VPWR VGND VPWR VGND sky130_ef_sc_hd__decap_12
XTAP_TAPCELL_ROW_139_2549 VGND VPWR sky130_fd_sc_hd__tapvpwrvgnd_1
XFILLER_129_517 VPWR VGND VPWR VGND sky130_ef_sc_hd__decap_12
XFILLER_62_65 VGND VGND VPWR VPWR sky130_fd_sc_hd__decap_8
XFILLER_30_139 VGND VGND VPWR VPWR sky130_fd_sc_hd__fill_1
XFILLER_8_825 VPWR VGND VPWR VGND sky130_ef_sc_hd__decap_12
XFILLER_7_27 VPWR VGND VPWR VGND sky130_ef_sc_hd__decap_12
XFILLER_8_869 VPWR VGND VPWR VGND sky130_ef_sc_hd__decap_12
XFILLER_7_335 VGND VGND VPWR VPWR sky130_fd_sc_hd__fill_1
XFILLER_137_561 VPWR VGND VPWR VGND sky130_ef_sc_hd__decap_12
XFILLER_152_531 VGND VGND VPWR VPWR sky130_fd_sc_hd__fill_1
XFILLER_124_233 VPWR VGND VPWR VGND sky130_ef_sc_hd__decap_12
XTAP_TAPCELL_ROW_59_1275 VGND VPWR sky130_fd_sc_hd__tapvpwrvgnd_1
XANTENNA__2203__A A_reg\[8\] VGND VGND VPWR VPWR sky130_fd_sc_hd__diode_2
XFILLER_140_737 VPWR VGND VPWR VGND sky130_ef_sc_hd__decap_12
XFILLER_124_277 VPWR VGND VPWR VGND sky130_ef_sc_hd__decap_12
XFILLER_79_821 VPWR VGND VPWR VGND sky130_ef_sc_hd__decap_12
XFILLER_79_865 VPWR VGND VPWR VGND sky130_ef_sc_hd__decap_12
XTAP_TAPCELL_ROW_72_1486 VGND VPWR sky130_fd_sc_hd__tapvpwrvgnd_1
XFILLER_94_813 VPWR VGND VPWR VGND sky130_ef_sc_hd__decap_12
X_2080_ _1326_ _1333_ _1335_ VGND VGND VPWR VPWR _1342_ sky130_fd_sc_hd__o21a_1
XFILLER_47_740 VPWR VGND VPWR VGND sky130_ef_sc_hd__decap_12
XFILLER_93_378 VPWR VGND VPWR VGND sky130_ef_sc_hd__decap_12
XFILLER_47_773 VGND VGND VPWR VPWR sky130_fd_sc_hd__decap_8
XFILLER_34_401 VPWR VGND VPWR VGND sky130_ef_sc_hd__decap_12
XTAP_TAPCELL_ROW_37_919 VGND VPWR sky130_fd_sc_hd__tapvpwrvgnd_1
XFILLER_74_581 VGND VGND VPWR VPWR sky130_fd_sc_hd__decap_6
XTAP_TAPCELL_ROW_17_610 VGND VPWR sky130_fd_sc_hd__tapvpwrvgnd_1
XFILLER_19_497 VGND VGND VPWR VPWR sky130_fd_sc_hd__decap_6
XFILLER_46_294 VPWR VGND VPWR VGND sky130_ef_sc_hd__decap_12
XFILLER_50_905 VGND VGND VPWR VPWR sky130_fd_sc_hd__fill_2
XFILLER_34_445 VPWR VGND VPWR VGND sky130_ef_sc_hd__decap_12
XFILLER_99_3 VPWR VGND VPWR VGND sky130_ef_sc_hd__decap_12
X_2982_ _0586_ _0669_ VGND VGND VPWR VPWR _0670_ sky130_fd_sc_hd__nand2_1
X_1933_ _1196_ _1197_ VGND VGND VPWR VPWR _1198_ sky130_fd_sc_hd__or2_1
XFILLER_148_837 VPWR VGND VPWR VGND sky130_ef_sc_hd__decap_12
Xinput30 B_in[7] VGND VGND VPWR VPWR net30 sky130_fd_sc_hd__clkbuf_1
X_1864_ A_reg\[7\] _1131_ _1132_ VGND VGND VPWR VPWR _1134_ sky130_fd_sc_hd__o21ba_1
XFILLER_116_701 VPWR VGND VPWR VGND sky130_ef_sc_hd__decap_12
X_1795_ A_reg\[5\] _1067_ VGND VGND VPWR VPWR _1068_ sky130_fd_sc_hd__nor2_1
XTAP_TAPCELL_ROW_92_1807 VGND VPWR sky130_fd_sc_hd__tapvpwrvgnd_1
XFILLER_143_553 VGND VGND VPWR VPWR sky130_fd_sc_hd__decap_6
XFILLER_107_39 VPWR VGND VPWR VGND sky130_ef_sc_hd__decap_12
XFILLER_89_629 VPWR VGND VPWR VGND sky130_ef_sc_hd__decap_12
XFILLER_143_597 VPWR VGND VPWR VGND sky130_ef_sc_hd__decap_12
X_2416_ _0161_ _0166_ VGND VGND VPWR VPWR _0170_ sky130_fd_sc_hd__xnor2_1
XFILLER_88_139 VGND VGND VPWR VPWR sky130_fd_sc_hd__fill_1
XFILLER_111_461 VPWR VGND VPWR VGND sky130_ef_sc_hd__decap_12
XFILLER_97_673 VPWR VGND VPWR VGND sky130_ef_sc_hd__decap_12
XFILLER_84_312 VGND VGND VPWR VPWR sky130_fd_sc_hd__fill_2
X_2347_ _1598_ _1599_ _1597_ VGND VGND VPWR VPWR _1600_ sky130_fd_sc_hd__a21o_1
XFILLER_123_27 VPWR VGND VPWR VGND sky130_ef_sc_hd__decap_12
XFILLER_111_494 VGND VGND VPWR VPWR sky130_fd_sc_hd__decap_4
X_2278_ A_reg\[0\] _1531_ _1532_ _1533_ VGND VGND VPWR VPWR _1535_ sky130_fd_sc_hd__a22o_1
XFILLER_57_559 VGND VGND VPWR VPWR sky130_fd_sc_hd__fill_1
XTAP_TAPCELL_ROW_123_2306 VGND VPWR sky130_fd_sc_hd__tapvpwrvgnd_1
XFILLER_84_389 VPWR VGND VPWR VGND sky130_ef_sc_hd__decap_12
XFILLER_84_356 VGND VGND VPWR VPWR sky130_fd_sc_hd__decap_8
XFILLER_44_209 VPWR VGND VPWR VGND sky130_ef_sc_hd__decap_12
XFILLER_25_423 VPWR VGND VPWR VGND sky130_ef_sc_hd__decap_12
XFILLER_37_272 VGND VGND VPWR VPWR sky130_fd_sc_hd__decap_8
XFILLER_80_562 VGND VGND VPWR VPWR sky130_fd_sc_hd__fill_1
XFILLER_53_765 VGND VGND VPWR VPWR sky130_fd_sc_hd__decap_8
XFILLER_13_629 VPWR VGND VPWR VGND sky130_ef_sc_hd__decap_12
XTAP_TAPCELL_ROW_101_1947 VGND VPWR sky130_fd_sc_hd__tapvpwrvgnd_1
XFILLER_12_139 VGND VGND VPWR VPWR sky130_fd_sc_hd__fill_1
XTAP_TAPCELL_ROW_43_1021 VGND VPWR sky130_fd_sc_hd__tapvpwrvgnd_1
XFILLER_21_673 VPWR VGND VPWR VGND sky130_ef_sc_hd__decap_12
XTAP_TAPCELL_ROW_134_2468 VGND VPWR sky130_fd_sc_hd__tapvpwrvgnd_1
XFILLER_119_561 VPWR VGND VPWR VGND sky130_ef_sc_hd__decap_12
XFILLER_5_839 VGND VGND VPWR VPWR sky130_fd_sc_hd__fill_1
XTAP_TAPCELL_ROW_134_2479 VGND VPWR sky130_fd_sc_hd__tapvpwrvgnd_1
XFILLER_134_531 VGND VGND VPWR VPWR sky130_fd_sc_hd__fill_1
XFILLER_106_233 VPWR VGND VPWR VGND sky130_ef_sc_hd__decap_12
XFILLER_122_737 VPWR VGND VPWR VGND sky130_ef_sc_hd__decap_12
XFILLER_121_225 VPWR VGND VPWR VGND sky130_ef_sc_hd__decap_12
XFILLER_106_277 VPWR VGND VPWR VGND sky130_ef_sc_hd__decap_12
XFILLER_0_533 VGND VGND VPWR VPWR sky130_fd_sc_hd__decap_6
XFILLER_130_781 VPWR VGND VPWR VGND sky130_ef_sc_hd__decap_12
XFILLER_87_161 VGND VGND VPWR VPWR sky130_fd_sc_hd__decap_6
XFILLER_76_813 VPWR VGND VPWR VGND sky130_ef_sc_hd__decap_12
XFILLER_57_43 VGND VGND VPWR VPWR sky130_fd_sc_hd__fill_1
XTAP_TAPCELL_ROW_54_1194 VGND VPWR sky130_fd_sc_hd__tapvpwrvgnd_1
XFILLER_102_494 VPWR VGND VPWR VGND sky130_ef_sc_hd__decap_12
XFILLER_75_334 VGND VGND VPWR VPWR sky130_fd_sc_hd__fill_2
XFILLER_57_87 VPWR VGND VPWR VGND sky130_ef_sc_hd__decap_12
XANTENNA_input19_A B_in[11] VGND VGND VPWR VPWR sky130_fd_sc_hd__diode_2
XFILLER_28_250 VGND VGND VPWR VPWR sky130_fd_sc_hd__fill_2
XFILLER_35_209 VGND VGND VPWR VPWR sky130_fd_sc_hd__fill_1
XTAP_TAPCELL_ROW_3_382 VGND VPWR sky130_fd_sc_hd__tapvpwrvgnd_1
XFILLER_16_401 VPWR VGND VPWR VGND sky130_ef_sc_hd__decap_12
XFILLER_44_710 VGND VGND VPWR VPWR sky130_fd_sc_hd__fill_1
XFILLER_113_93 VPWR VGND VPWR VGND sky130_ef_sc_hd__decap_12
XFILLER_16_467 VGND VGND VPWR VPWR sky130_fd_sc_hd__decap_8
XFILLER_16_489 VPWR VGND VPWR VGND sky130_ef_sc_hd__decap_12
XANTENNA__3297__Q B_reg\[7\] VGND VGND VPWR VPWR sky130_fd_sc_hd__diode_2
XTAP_TAPCELL_ROW_42_999 VGND VPWR sky130_fd_sc_hd__tapvpwrvgnd_1
XFILLER_11_161 VGND VGND VPWR VPWR sky130_fd_sc_hd__decap_6
XFILLER_138_881 VPWR VGND VPWR VGND sky130_ef_sc_hd__decap_12
XTAP_TAPCELL_ROW_22_690 VGND VPWR sky130_fd_sc_hd__tapvpwrvgnd_1
XFILLER_137_391 VGND VGND VPWR VPWR sky130_fd_sc_hd__fill_1
XFILLER_8_699 VGND VGND VPWR VPWR sky130_fd_sc_hd__fill_1
XFILLER_140_501 VPWR VGND VPWR VGND sky130_ef_sc_hd__decap_12
XFILLER_125_553 VGND VGND VPWR VPWR sky130_fd_sc_hd__decap_6
XTAP_TAPCELL_ROW_74_1515 VGND VPWR sky130_fd_sc_hd__tapvpwrvgnd_1
XFILLER_4_861 VGND VGND VPWR VPWR sky130_fd_sc_hd__decap_6
XFILLER_125_597 VPWR VGND VPWR VGND sky130_ef_sc_hd__decap_12
XFILLER_98_83 VGND VGND VPWR VPWR sky130_fd_sc_hd__fill_1
XFILLER_140_545 VPWR VGND VPWR VGND sky130_ef_sc_hd__decap_12
XFILLER_3_393 VGND VGND VPWR VPWR sky130_fd_sc_hd__decap_8
X_3250_ clknet_3_7__leaf_clk CRT_Start net36 VGND VGND VPWR VPWR u_crt.start_d sky130_fd_sc_hd__dfrtp_1
XFILLER_140_589 VPWR VGND VPWR VGND sky130_ef_sc_hd__decap_12
XFILLER_79_673 VPWR VGND VPWR VGND sky130_ef_sc_hd__decap_12
XFILLER_79_662 VGND VGND VPWR VPWR sky130_fd_sc_hd__decap_8
XFILLER_66_301 VGND VGND VPWR VPWR sky130_fd_sc_hd__decap_6
X_2201_ _1456_ _1457_ VGND VGND VPWR VPWR _1458_ sky130_fd_sc_hd__nor2_1
X_3181_ _0834_ _0864_ VGND VGND VPWR VPWR _0866_ sky130_fd_sc_hd__or2_1
XFILLER_94_643 VGND VGND VPWR VPWR sky130_fd_sc_hd__fill_1
X_2132_ _0906_ _1388_ VGND VGND VPWR VPWR _1391_ sky130_fd_sc_hd__nand2_1
XFILLER_66_345 VPWR VGND VPWR VGND sky130_ef_sc_hd__decap_12
XFILLER_14_3 VPWR VGND VPWR VGND sky130_ef_sc_hd__decap_12
XFILLER_39_559 VGND VGND VPWR VPWR sky130_fd_sc_hd__fill_1
XTAP_TAPCELL_ROW_105_2014 VGND VPWR sky130_fd_sc_hd__tapvpwrvgnd_1
XFILLER_82_805 VGND VGND VPWR VPWR sky130_fd_sc_hd__decap_6
XFILLER_26_209 VPWR VGND VPWR VGND sky130_ef_sc_hd__decap_12
X_2063_ B_reg\[4\] _1322_ VGND VGND VPWR VPWR _1325_ sky130_fd_sc_hd__or2_1
XFILLER_82_849 VPWR VGND VPWR VGND sky130_ef_sc_hd__decap_12
XFILLER_81_337 VGND VGND VPWR VPWR sky130_fd_sc_hd__fill_1
XFILLER_35_721 VGND VGND VPWR VPWR sky130_fd_sc_hd__decap_6
XFILLER_35_765 VPWR VGND VPWR VGND sky130_ef_sc_hd__decap_12
XFILLER_90_893 VPWR VGND VPWR VGND sky130_ef_sc_hd__decap_12
XTAP_TAPCELL_ROW_85_1699 VGND VPWR sky130_fd_sc_hd__tapvpwrvgnd_1
XTAP_TAPCELL_ROW_85_1688 VGND VPWR sky130_fd_sc_hd__tapvpwrvgnd_1
XANTENNA__3211__B _0912_ VGND VGND VPWR VPWR sky130_fd_sc_hd__diode_2
XFILLER_148_601 VPWR VGND VPWR VGND sky130_ef_sc_hd__decap_12
XFILLER_50_757 VPWR VGND VPWR VGND sky130_ef_sc_hd__decap_12
XFILLER_22_448 VPWR VGND VPWR VGND sky130_ef_sc_hd__decap_12
XFILLER_147_111 VGND VGND VPWR VPWR sky130_fd_sc_hd__fill_1
X_2965_ _0612_ _0635_ _0638_ VGND VGND VPWR VPWR _0653_ sky130_fd_sc_hd__a21o_1
XFILLER_148_645 VPWR VGND VPWR VGND sky130_ef_sc_hd__decap_12
X_2896_ _0579_ _0582_ VGND VGND VPWR VPWR _0584_ sky130_fd_sc_hd__xor2_1
X_1916_ _0899_ _1168_ VGND VGND VPWR VPWR _1181_ sky130_fd_sc_hd__nor2_1
XTAP_TAPCELL_ROW_20_649 VGND VPWR sky130_fd_sc_hd__tapvpwrvgnd_1
XFILLER_135_317 VPWR VGND VPWR VGND sky130_ef_sc_hd__decap_12
X_1847_ A_reg\[11\] _1113_ _1116_ VGND VGND VPWR VPWR _1117_ sky130_fd_sc_hd__and3_1
XFILLER_118_27 VGND VGND VPWR VPWR sky130_fd_sc_hd__fill_1
XFILLER_116_531 VGND VGND VPWR VPWR sky130_fd_sc_hd__fill_1
XTAP_TAPCELL_ROW_116_2187 VGND VPWR sky130_fd_sc_hd__tapvpwrvgnd_1
XFILLER_150_309 VPWR VGND VPWR VGND sky130_ef_sc_hd__decap_12
X_1778_ A_reg\[8\] _1045_ VGND VGND VPWR VPWR _1051_ sky130_fd_sc_hd__xnor2_1
XFILLER_143_361 VPWR VGND VPWR VGND sky130_ef_sc_hd__decap_12
XFILLER_104_737 VPWR VGND VPWR VGND sky130_ef_sc_hd__decap_12
XFILLER_103_225 VPWR VGND VPWR VGND sky130_ef_sc_hd__decap_12
XANTENNA__1682__A A_reg\[6\] VGND VGND VPWR VPWR sky130_fd_sc_hd__diode_2
XFILLER_134_15 VPWR VGND VPWR VGND sky130_ef_sc_hd__decap_12
XFILLER_112_781 VPWR VGND VPWR VGND sky130_ef_sc_hd__decap_12
XFILLER_58_813 VGND VGND VPWR VPWR sky130_fd_sc_hd__decap_8
XFILLER_84_120 VPWR VGND VPWR VGND sky130_ef_sc_hd__decap_12
XFILLER_69_194 VGND VGND VPWR VPWR sky130_fd_sc_hd__decap_3
XFILLER_84_153 VPWR VGND VPWR VGND sky130_ef_sc_hd__decap_12
XFILLER_84_197 VPWR VGND VPWR VGND sky130_ef_sc_hd__decap_12
XTAP_TAPCELL_ROW_0_330 VGND VPWR sky130_fd_sc_hd__tapvpwrvgnd_1
XFILLER_27_57 VPWR VGND VPWR VGND sky130_ef_sc_hd__decap_12
XFILLER_38_581 VGND VGND VPWR VPWR sky130_fd_sc_hd__decap_6
XFILLER_53_540 VGND VGND VPWR VPWR sky130_fd_sc_hd__decap_8
XFILLER_14_905 VGND VGND VPWR VPWR sky130_fd_sc_hd__decap_4
XFILLER_13_437 VGND VGND VPWR VPWR sky130_fd_sc_hd__fill_2
XFILLER_40_234 VPWR VGND VPWR VGND sky130_ef_sc_hd__decap_12
XFILLER_41_768 VGND VGND VPWR VPWR sky130_fd_sc_hd__decap_8
XTAP_TAPCELL_ROW_136_2508 VGND VPWR sky130_fd_sc_hd__tapvpwrvgnd_1
XFILLER_41_779 VGND VGND VPWR VPWR sky130_fd_sc_hd__decap_4
XTAP_TAPCELL_ROW_153_2800 VGND VPWR sky130_fd_sc_hd__tapvpwrvgnd_1
XFILLER_138_133 VGND VGND VPWR VPWR sky130_fd_sc_hd__decap_6
XFILLER_138_177 VPWR VGND VPWR VGND sky130_ef_sc_hd__decap_12
XFILLER_153_125 VPWR VGND VPWR VGND sky130_ef_sc_hd__decap_12
XFILLER_119_391 VGND VGND VPWR VPWR sky130_fd_sc_hd__fill_1
XFILLER_5_625 VGND VGND VPWR VPWR sky130_fd_sc_hd__decap_3
XFILLER_153_169 VPWR VGND VPWR VGND sky130_ef_sc_hd__decap_12
XTAP_TAPCELL_ROW_56_1223 VGND VPWR sky130_fd_sc_hd__tapvpwrvgnd_1
XFILLER_135_895 VGND VGND VPWR VPWR sky130_fd_sc_hd__fill_1
XFILLER_122_501 VPWR VGND VPWR VGND sky130_ef_sc_hd__decap_12
XFILLER_107_597 VPWR VGND VPWR VGND sky130_ef_sc_hd__decap_12
XTAP_TAPCELL_ROW_56_1234 VGND VPWR sky130_fd_sc_hd__tapvpwrvgnd_1
XFILLER_122_545 VPWR VGND VPWR VGND sky130_ef_sc_hd__decap_12
XTAP_TAPCELL_ROW_8_463 VGND VPWR sky130_fd_sc_hd__tapvpwrvgnd_1
XTAP_TAPCELL_ROW_8_452 VGND VPWR sky130_fd_sc_hd__tapvpwrvgnd_1
XFILLER_1_853 VPWR VGND VPWR VGND sky130_ef_sc_hd__decap_12
XFILLER_122_589 VPWR VGND VPWR VGND sky130_ef_sc_hd__decap_12
XFILLER_76_610 VGND VGND VPWR VPWR sky130_fd_sc_hd__decap_3
XFILLER_48_301 VGND VGND VPWR VPWR sky130_fd_sc_hd__decap_6
XFILLER_1_897 VPWR VGND VPWR VGND sky130_ef_sc_hd__decap_12
XFILLER_76_687 VGND VGND VPWR VPWR sky130_fd_sc_hd__decap_4
XFILLER_64_849 VPWR VGND VPWR VGND sky130_ef_sc_hd__decap_12
XFILLER_48_389 VGND VGND VPWR VPWR sky130_fd_sc_hd__decap_4
XFILLER_17_721 VGND VGND VPWR VPWR sky130_fd_sc_hd__decap_6
XFILLER_84_85 VGND VGND VPWR VPWR sky130_fd_sc_hd__fill_2
XFILLER_17_765 VPWR VGND VPWR VGND sky130_ef_sc_hd__decap_12
XFILLER_72_893 VPWR VGND VPWR VGND sky130_ef_sc_hd__decap_12
XANTENNA__2471__A1 OpSel_reg\[0\] VGND VGND VPWR VPWR sky130_fd_sc_hd__diode_2
XFILLER_16_253 VPWR VGND VPWR VGND sky130_ef_sc_hd__decap_12
XTAP_TAPCELL_ROW_27_760 VGND VPWR sky130_fd_sc_hd__tapvpwrvgnd_1
XTAP_TAPCELL_ROW_27_771 VGND VPWR sky130_fd_sc_hd__tapvpwrvgnd_1
XFILLER_32_713 VPWR VGND VPWR VGND sky130_ef_sc_hd__decap_12
XTAP_TAPCELL_ROW_67_1396 VGND VPWR sky130_fd_sc_hd__tapvpwrvgnd_1
XFILLER_31_223 VGND VGND VPWR VPWR sky130_fd_sc_hd__fill_1
XFILLER_129_111 VGND VGND VPWR VPWR sky130_fd_sc_hd__fill_1
X_2750_ _0454_ _0456_ VGND VGND VPWR VPWR _0490_ sky130_fd_sc_hd__nand2_1
XFILLER_145_615 VGND VGND VPWR VPWR sky130_fd_sc_hd__fill_1
XFILLER_117_317 VPWR VGND VPWR VGND sky130_ef_sc_hd__decap_12
X_2681_ _0391_ _0420_ _0409_ VGND VGND VPWR VPWR _0421_ sky130_fd_sc_hd__o21ai_1
X_1701_ _0963_ _0976_ VGND VGND VPWR VPWR _0977_ sky130_fd_sc_hd__xnor2_1
X_1632_ CU_state_dbg\[2\] CU_state_dbg\[0\] CU_state_dbg\[1\] VGND VGND VPWR VPWR
+ _0911_ sky130_fd_sc_hd__or3b_4
XFILLER_132_309 VPWR VGND VPWR VGND sky130_ef_sc_hd__decap_12
XFILLER_141_821 VPWR VGND VPWR VGND sky130_ef_sc_hd__decap_12
XFILLER_125_361 VPWR VGND VPWR VGND sky130_ef_sc_hd__decap_12
XANTENNA__2598__A _0186_ VGND VGND VPWR VPWR sky130_fd_sc_hd__diode_2
XFILLER_141_865 VPWR VGND VPWR VGND sky130_ef_sc_hd__decap_12
X_3302_ clknet_3_0__leaf_clk _0085_ net36 VGND VGND VPWR VPWR B_reg\[12\] sky130_fd_sc_hd__dfrtp_4
XFILLER_101_729 VPWR VGND VPWR VGND sky130_ef_sc_hd__decap_12
X_3233_ clknet_3_3__leaf_clk _0020_ net36 VGND VGND VPWR VPWR a_r3\[1\] sky130_fd_sc_hd__dfrtp_4
XANTENNA_clkbuf_3_3__f_clk_A clknet_0_clk VGND VGND VPWR VPWR sky130_fd_sc_hd__diode_2
XFILLER_58_109 VGND VGND VPWR VPWR sky130_fd_sc_hd__decap_8
XFILLER_104_29 VPWR VGND VPWR VGND sky130_ef_sc_hd__decap_12
XFILLER_94_462 VPWR VGND VPWR VGND sky130_ef_sc_hd__decap_12
XTAP_TAPCELL_ROW_87_1728 VGND VPWR sky130_fd_sc_hd__tapvpwrvgnd_1
XTAP_TAPCELL_ROW_87_1717 VGND VPWR sky130_fd_sc_hd__tapvpwrvgnd_1
XFILLER_67_676 VPWR VGND VPWR VGND sky130_ef_sc_hd__decap_12
XFILLER_66_153 VPWR VGND VPWR VGND sky130_ef_sc_hd__decap_12
X_3164_ _0820_ _0851_ VGND VGND VPWR VPWR _0852_ sky130_fd_sc_hd__or2_1
XFILLER_82_635 VGND VGND VPWR VPWR sky130_fd_sc_hd__decap_8
X_2115_ B_reg\[9\] _1370_ _1373_ VGND VGND VPWR VPWR _1374_ sky130_fd_sc_hd__a21oi_1
XFILLER_55_849 VGND VGND VPWR VPWR sky130_fd_sc_hd__fill_2
X_3095_ _0698_ _0720_ _0762_ VGND VGND VPWR VPWR _0783_ sky130_fd_sc_hd__or3_1
XFILLER_54_315 VPWR VGND VPWR VGND sky130_ef_sc_hd__decap_12
X_2046_ B_reg\[6\] _1306_ _1300_ VGND VGND VPWR VPWR _1308_ sky130_fd_sc_hd__o21ai_1
XFILLER_82_657 VPWR VGND VPWR VGND sky130_ef_sc_hd__decap_12
XFILLER_35_595 VPWR VGND VPWR VGND sky130_ef_sc_hd__decap_12
XFILLER_13_15 VPWR VGND VPWR VGND sky130_ef_sc_hd__decap_12
XANTENNA__1677__A A_reg\[8\] VGND VGND VPWR VPWR sky130_fd_sc_hd__diode_2
XFILLER_129_15 VPWR VGND VPWR VGND sky130_ef_sc_hd__decap_12
XTAP_TAPCELL_ROW_118_2227 VGND VPWR sky130_fd_sc_hd__tapvpwrvgnd_1
XTAP_TAPCELL_ROW_118_2216 VGND VPWR sky130_fd_sc_hd__tapvpwrvgnd_1
X_2948_ _0612_ _0635_ VGND VGND VPWR VPWR _0636_ sky130_fd_sc_hd__xnor2_1
XFILLER_148_475 VGND VGND VPWR VPWR sky130_fd_sc_hd__fill_1
XANTENNA__3259__RESET_B net36 VGND VGND VPWR VPWR sky130_fd_sc_hd__diode_2
XFILLER_136_637 VGND VGND VPWR VPWR sky130_fd_sc_hd__decap_6
XFILLER_135_125 VPWR VGND VPWR VGND sky130_ef_sc_hd__decap_12
X_2879_ u_crt.r3\[3\] u_crt.r3\[1\] u_crt.r3\[0\] VGND VGND VPWR VPWR _0567_ sky130_fd_sc_hd__and3_1
XANTENNA__1973__B1 B_reg\[2\] VGND VGND VPWR VPWR sky130_fd_sc_hd__diode_2
XFILLER_135_169 VPWR VGND VPWR VGND sky130_ef_sc_hd__decap_12
XTAP_TAPCELL_ROW_131_2427 VGND VPWR sky130_fd_sc_hd__tapvpwrvgnd_1
XFILLER_151_629 VPWR VGND VPWR VGND sky130_ef_sc_hd__decap_12
XFILLER_144_681 VPWR VGND VPWR VGND sky130_ef_sc_hd__decap_12
XFILLER_117_895 VGND VGND VPWR VPWR sky130_fd_sc_hd__fill_1
XFILLER_104_512 VPWR VGND VPWR VGND sky130_ef_sc_hd__decap_12
XFILLER_2_628 VGND VGND VPWR VPWR sky130_fd_sc_hd__decap_8
XFILLER_1_105 VGND VGND VPWR VPWR sky130_fd_sc_hd__decap_6
XFILLER_150_139 VGND VGND VPWR VPWR sky130_fd_sc_hd__fill_1
XFILLER_145_69 VPWR VGND VPWR VGND sky130_ef_sc_hd__decap_12
XFILLER_104_545 VPWR VGND VPWR VGND sky130_ef_sc_hd__decap_12
XFILLER_1_149 VPWR VGND VPWR VGND sky130_ef_sc_hd__decap_12
XFILLER_104_589 VPWR VGND VPWR VGND sky130_ef_sc_hd__decap_12
XFILLER_89_289 VPWR VGND VPWR VGND sky130_ef_sc_hd__decap_12
XFILLER_77_429 VPWR VGND VPWR VGND sky130_ef_sc_hd__decap_12
XTAP_TAPCELL_ROW_5_411 VGND VPWR sky130_fd_sc_hd__tapvpwrvgnd_1
XTAP_TAPCELL_ROW_51_1153 VGND VPWR sky130_fd_sc_hd__tapvpwrvgnd_1
XTAP_TAPCELL_ROW_51_1142 VGND VPWR sky130_fd_sc_hd__tapvpwrvgnd_1
XTAP_TAPCELL_ROW_146_2670 VGND VPWR sky130_fd_sc_hd__tapvpwrvgnd_1
XTAP_TAPCELL_ROW_129_2389 VGND VPWR sky130_fd_sc_hd__tapvpwrvgnd_1
XFILLER_85_473 VPWR VGND VPWR VGND sky130_ef_sc_hd__decap_12
XFILLER_57_186 VPWR VGND VPWR VGND sky130_ef_sc_hd__decap_12
XFILLER_46_827 VPWR VGND VPWR VGND sky130_ef_sc_hd__decap_12
XFILLER_54_22 VGND VGND VPWR VPWR sky130_fd_sc_hd__decap_6
XFILLER_45_337 VPWR VGND VPWR VGND sky130_ef_sc_hd__decap_12
XFILLER_14_713 VPWR VGND VPWR VGND sky130_ef_sc_hd__decap_12
XFILLER_13_223 VGND VGND VPWR VPWR sky130_fd_sc_hd__fill_1
XFILLER_14_757 VPWR VGND VPWR VGND sky130_ef_sc_hd__decap_12
XFILLER_9_205 VPWR VGND VPWR VGND sky130_ef_sc_hd__decap_12
XFILLER_110_83 VGND VGND VPWR VPWR sky130_fd_sc_hd__fill_1
XFILLER_9_249 VPWR VGND VPWR VGND sky130_ef_sc_hd__decap_12
XFILLER_13_278 VGND VGND VPWR VPWR sky130_fd_sc_hd__fill_2
XFILLER_127_615 VGND VGND VPWR VPWR sky130_fd_sc_hd__fill_1
XFILLER_70_65 VPWR VGND VPWR VGND sky130_ef_sc_hd__decap_12
XFILLER_139_497 VGND VGND VPWR VPWR sky130_fd_sc_hd__decap_6
XFILLER_119_81 VPWR VGND VPWR VGND sky130_ef_sc_hd__decap_12
XFILLER_114_309 VPWR VGND VPWR VGND sky130_ef_sc_hd__decap_12
XFILLER_123_821 VPWR VGND VPWR VGND sky130_ef_sc_hd__decap_12
XFILLER_107_361 VPWR VGND VPWR VGND sky130_ef_sc_hd__decap_12
XFILLER_123_865 VPWR VGND VPWR VGND sky130_ef_sc_hd__decap_12
XANTENNA__2211__A A_reg\[7\] VGND VGND VPWR VPWR sky130_fd_sc_hd__diode_2
XFILLER_96_749 VGND VGND VPWR VPWR sky130_fd_sc_hd__decap_6
XFILLER_95_237 VPWR VGND VPWR VGND sky130_ef_sc_hd__decap_12
XFILLER_49_610 VGND VGND VPWR VPWR sky130_fd_sc_hd__decap_6
XFILLER_48_153 VPWR VGND VPWR VGND sky130_ef_sc_hd__decap_12
XFILLER_0_193 VGND VGND VPWR VPWR sky130_fd_sc_hd__decap_3
XTAP_TAPCELL_ROW_69_1436 VGND VPWR sky130_fd_sc_hd__tapvpwrvgnd_1
XFILLER_64_613 VPWR VGND VPWR VGND sky130_ef_sc_hd__decap_12
XFILLER_64_657 VPWR VGND VPWR VGND sky130_ef_sc_hd__decap_12
XFILLER_48_197 VPWR VGND VPWR VGND sky130_ef_sc_hd__decap_12
XFILLER_63_167 VGND VGND VPWR VPWR sky130_fd_sc_hd__fill_1
XFILLER_17_573 VPWR VGND VPWR VGND sky130_ef_sc_hd__decap_12
XFILLER_45_860 VGND VGND VPWR VPWR sky130_fd_sc_hd__fill_1
XFILLER_45_882 VPWR VGND VPWR VGND sky130_ef_sc_hd__decap_12
XFILLER_91_498 VGND VGND VPWR VPWR sky130_fd_sc_hd__decap_6
XTAP_TAPCELL_ROW_82_1647 VGND VPWR sky130_fd_sc_hd__tapvpwrvgnd_1
XTAP_TAPCELL_ROW_82_1636 VGND VPWR sky130_fd_sc_hd__tapvpwrvgnd_1
XFILLER_63_189 VGND VGND VPWR VPWR sky130_fd_sc_hd__fill_2
XFILLER_149_217 VGND VGND VPWR VPWR sky130_fd_sc_hd__decap_6
X_2802_ _0541_ _0540_ VGND VGND VPWR VPWR _0542_ sky130_fd_sc_hd__and2b_1
XFILLER_81_3 VPWR VGND VPWR VGND sky130_ef_sc_hd__decap_12
XANTENNA__2092__S Encode_EN VGND VGND VPWR VPWR sky130_fd_sc_hd__diode_2
XFILLER_20_749 VGND VGND VPWR VPWR sky130_fd_sc_hd__decap_6
X_2733_ _0471_ _0472_ _0465_ _0468_ VGND VGND VPWR VPWR _0473_ sky130_fd_sc_hd__a211oi_1
XFILLER_118_637 VGND VGND VPWR VPWR sky130_fd_sc_hd__decap_6
XFILLER_117_125 VPWR VGND VPWR VGND sky130_ef_sc_hd__decap_12
XFILLER_9_783 VGND VGND VPWR VPWR sky130_fd_sc_hd__fill_1
XANTENNA__2820__S _0553_ VGND VGND VPWR VPWR sky130_fd_sc_hd__diode_2
X_2664_ _0384_ _0402_ _0403_ VGND VGND VPWR VPWR _0404_ sky130_fd_sc_hd__nor3_1
XFILLER_133_629 VPWR VGND VPWR VGND sky130_ef_sc_hd__decap_12
XFILLER_126_681 VPWR VGND VPWR VGND sky130_ef_sc_hd__decap_12
XFILLER_117_169 VPWR VGND VPWR VGND sky130_ef_sc_hd__decap_12
XTAP_TAPCELL_ROW_113_2146 VGND VPWR sky130_fd_sc_hd__tapvpwrvgnd_1
XTAP_TAPCELL_ROW_113_2135 VGND VPWR sky130_fd_sc_hd__tapvpwrvgnd_1
XTAP_TAPCELL_ROW_97_1890 VGND VPWR sky130_fd_sc_hd__tapvpwrvgnd_1
X_2595_ _0313_ _0339_ VGND VGND VPWR VPWR _0340_ sky130_fd_sc_hd__nor2_1
X_1615_ A_reg\[2\] VGND VGND VPWR VPWR _0895_ sky130_fd_sc_hd__inv_2
XTAP_TAPCELL_ROW_10_490 VGND VPWR sky130_fd_sc_hd__tapvpwrvgnd_1
XFILLER_132_139 VGND VGND VPWR VPWR sky130_fd_sc_hd__fill_1
XFILLER_141_673 VPWR VGND VPWR VGND sky130_ef_sc_hd__decap_12
XFILLER_59_429 VPWR VGND VPWR VGND sky130_ef_sc_hd__decap_12
XFILLER_5_93 VPWR VGND VPWR VGND sky130_ef_sc_hd__decap_12
XFILLER_115_39 VPWR VGND VPWR VGND sky130_ef_sc_hd__decap_12
XANTENNA__3231__CLK clknet_3_2__leaf_clk VGND VGND VPWR VPWR sky130_fd_sc_hd__diode_2
XFILLER_86_259 VPWR VGND VPWR VGND sky130_ef_sc_hd__decap_12
XFILLER_28_805 VGND VGND VPWR VPWR sky130_fd_sc_hd__decap_6
X_3216_ clknet_3_4__leaf_clk _0004_ net36 VGND VGND VPWR VPWR a_r1\[1\] sky130_fd_sc_hd__dfrtp_4
XFILLER_67_473 VPWR VGND VPWR VGND sky130_ef_sc_hd__decap_12
X_3147_ _0804_ _0829_ VGND VGND VPWR VPWR _0835_ sky130_fd_sc_hd__xnor2_1
XFILLER_28_849 VPWR VGND VPWR VGND sky130_ef_sc_hd__decap_12
XFILLER_131_27 VPWR VGND VPWR VGND sky130_ef_sc_hd__decap_12
XFILLER_82_421 VPWR VGND VPWR VGND sky130_ef_sc_hd__decap_12
XFILLER_55_646 VPWR VGND VPWR VGND sky130_ef_sc_hd__decap_12
XFILLER_27_337 VPWR VGND VPWR VGND sky130_ef_sc_hd__decap_12
X_3078_ _0633_ _0650_ _0649_ VGND VGND VPWR VPWR _0766_ sky130_fd_sc_hd__a21bo_1
XFILLER_36_860 VGND VGND VPWR VPWR sky130_fd_sc_hd__decap_8
X_2029_ _1286_ _1290_ VGND VGND VPWR VPWR _1291_ sky130_fd_sc_hd__nand2_1
XFILLER_51_841 VPWR VGND VPWR VGND sky130_ef_sc_hd__decap_12
XFILLER_35_381 VGND VGND VPWR VPWR sky130_fd_sc_hd__decap_8
XFILLER_36_893 VPWR VGND VPWR VGND sky130_ef_sc_hd__decap_12
XFILLER_42_329 VGND VGND VPWR VPWR sky130_fd_sc_hd__fill_1
XFILLER_11_727 VGND VGND VPWR VPWR sky130_fd_sc_hd__fill_1
XFILLER_136_401 VPWR VGND VPWR VGND sky130_ef_sc_hd__decap_12
XFILLER_109_615 VGND VGND VPWR VPWR sky130_fd_sc_hd__fill_1
XFILLER_7_709 VPWR VGND VPWR VGND sky130_ef_sc_hd__decap_12
XFILLER_152_905 VGND VGND VPWR VPWR sky130_fd_sc_hd__decap_4
XFILLER_136_445 VPWR VGND VPWR VGND sky130_ef_sc_hd__decap_12
XFILLER_136_489 VPWR VGND VPWR VGND sky130_ef_sc_hd__decap_12
XFILLER_105_821 VPWR VGND VPWR VGND sky130_ef_sc_hd__decap_12
XFILLER_2_403 VPWR VGND VPWR VGND sky130_ef_sc_hd__decap_12
XANTENNA__2031__A B_reg\[8\] VGND VGND VPWR VPWR sky130_fd_sc_hd__diode_2
XFILLER_49_11 VGND VGND VPWR VPWR sky130_fd_sc_hd__fill_1
XFILLER_120_813 VPWR VGND VPWR VGND sky130_ef_sc_hd__decap_12
XFILLER_105_865 VPWR VGND VPWR VGND sky130_ef_sc_hd__decap_12
XFILLER_49_55 VGND VGND VPWR VPWR sky130_fd_sc_hd__fill_1
XFILLER_131_161 VGND VGND VPWR VPWR sky130_fd_sc_hd__decap_6
XFILLER_77_237 VGND VGND VPWR VPWR sky130_fd_sc_hd__decap_6
XTAP_TAPCELL_ROW_144_2629 VGND VPWR sky130_fd_sc_hd__tapvpwrvgnd_1
XANTENNA__2123__B1 B_reg\[6\] VGND VGND VPWR VPWR sky130_fd_sc_hd__diode_2
XFILLER_86_793 VPWR VGND VPWR VGND sky130_ef_sc_hd__decap_12
XTAP_TAPCELL_ROW_29_800 VGND VPWR sky130_fd_sc_hd__tapvpwrvgnd_1
XFILLER_85_281 VGND VGND VPWR VPWR sky130_fd_sc_hd__decap_4
XFILLER_65_87 VPWR VGND VPWR VGND sky130_ef_sc_hd__decap_12
XFILLER_45_167 VGND VGND VPWR VPWR sky130_fd_sc_hd__fill_1
XFILLER_61_649 VGND VGND VPWR VPWR sky130_fd_sc_hd__fill_1
XFILLER_26_392 VPWR VGND VPWR VGND sky130_ef_sc_hd__decap_12
XFILLER_121_93 VPWR VGND VPWR VGND sky130_ef_sc_hd__decap_12
XTAP_TAPCELL_ROW_64_1355 VGND VPWR sky130_fd_sc_hd__tapvpwrvgnd_1
XFILLER_14_587 VGND VGND VPWR VPWR sky130_fd_sc_hd__fill_1
XFILLER_146_209 VPWR VGND VPWR VGND sky130_ef_sc_hd__decap_12
XFILLER_139_261 VPWR VGND VPWR VGND sky130_ef_sc_hd__decap_12
XFILLER_60_8 VPWR VGND VPWR VGND sky130_ef_sc_hd__decap_12
XFILLER_10_793 VPWR VGND VPWR VGND sky130_ef_sc_hd__decap_12
XFILLER_115_629 VPWR VGND VPWR VGND sky130_ef_sc_hd__decap_12
XFILLER_108_681 VPWR VGND VPWR VGND sky130_ef_sc_hd__decap_12
XFILLER_114_139 VGND VGND VPWR VPWR sky130_fd_sc_hd__fill_1
XANTENNA__3254__CLK clknet_3_6__leaf_clk VGND VGND VPWR VPWR sky130_fd_sc_hd__diode_2
XFILLER_5_296 VGND VGND VPWR VPWR sky130_fd_sc_hd__fill_1
XFILLER_5_285 VGND VGND VPWR VPWR sky130_fd_sc_hd__fill_1
XFILLER_123_673 VPWR VGND VPWR VGND sky130_ef_sc_hd__decap_12
X_2380_ _0126_ _0127_ _0133_ VGND VGND VPWR VPWR _0134_ sky130_fd_sc_hd__o21ba_1
XFILLER_69_727 VGND VGND VPWR VPWR sky130_fd_sc_hd__fill_1
XFILLER_110_301 VGND VGND VPWR VPWR sky130_fd_sc_hd__decap_6
XFILLER_96_524 VGND VGND VPWR VPWR sky130_fd_sc_hd__decap_8
XFILLER_110_345 VPWR VGND VPWR VGND sky130_ef_sc_hd__decap_12
XFILLER_96_557 VGND VGND VPWR VPWR sky130_fd_sc_hd__decap_6
XFILLER_110_389 VPWR VGND VPWR VGND sky130_ef_sc_hd__decap_12
X_3001_ _0578_ _0586_ _0669_ VGND VGND VPWR VPWR _0689_ sky130_fd_sc_hd__or3_1
XFILLER_49_473 VPWR VGND VPWR VGND sky130_ef_sc_hd__decap_12
Xinput6 A_in[14] VGND VGND VPWR VPWR net6 sky130_fd_sc_hd__clkbuf_1
XFILLER_64_443 VGND VGND VPWR VPWR sky130_fd_sc_hd__decap_4
XFILLER_64_421 VGND VGND VPWR VPWR sky130_fd_sc_hd__decap_4
XFILLER_64_454 VPWR VGND VPWR VGND sky130_ef_sc_hd__decap_12
XFILLER_24_307 VGND VGND VPWR VPWR sky130_fd_sc_hd__fill_1
XFILLER_91_273 VGND VGND VPWR VPWR sky130_fd_sc_hd__decap_6
XFILLER_64_498 VPWR VGND VPWR VGND sky130_ef_sc_hd__decap_12
XFILLER_51_126 VGND VGND VPWR VPWR sky130_fd_sc_hd__fill_1
XFILLER_18_893 VPWR VGND VPWR VGND sky130_ef_sc_hd__decap_12
XFILLER_33_841 VPWR VGND VPWR VGND sky130_ef_sc_hd__decap_12
XFILLER_36_189 VGND VGND VPWR VPWR sky130_fd_sc_hd__decap_6
XTAP_TAPCELL_ROW_15_571 VGND VPWR sky130_fd_sc_hd__tapvpwrvgnd_1
XFILLER_20_513 VPWR VGND VPWR VGND sky130_ef_sc_hd__decap_12
XANTENNA__1640__A2 A_reg\[13\] VGND VGND VPWR VPWR sky130_fd_sc_hd__diode_2
XFILLER_20_557 VPWR VGND VPWR VGND sky130_ef_sc_hd__decap_12
XFILLER_118_401 VPWR VGND VPWR VGND sky130_ef_sc_hd__decap_12
XANTENNA__1955__A B_reg\[5\] VGND VGND VPWR VPWR sky130_fd_sc_hd__diode_2
XFILLER_134_905 VGND VGND VPWR VPWR sky130_fd_sc_hd__decap_4
XFILLER_118_445 VPWR VGND VPWR VGND sky130_ef_sc_hd__decap_12
X_2716_ _0425_ _0426_ _0422_ VGND VGND VPWR VPWR _0456_ sky130_fd_sc_hd__a21o_1
XFILLER_118_489 VPWR VGND VPWR VGND sky130_ef_sc_hd__decap_12
X_2647_ _0385_ _0386_ VGND VGND VPWR VPWR _0387_ sky130_fd_sc_hd__nand2_1
XTAP_TAPCELL_ROW_95_1849 VGND VPWR sky130_fd_sc_hd__tapvpwrvgnd_1
XFILLER_10_27 VGND VGND VPWR VPWR sky130_fd_sc_hd__fill_1
XFILLER_126_27 VGND VGND VPWR VPWR sky130_fd_sc_hd__fill_1
XFILLER_120_109 VPWR VGND VPWR VGND sky130_ef_sc_hd__decap_12
XFILLER_102_813 VPWR VGND VPWR VGND sky130_ef_sc_hd__decap_12
X_2578_ _0317_ _0322_ VGND VGND VPWR VPWR _0323_ sky130_fd_sc_hd__nor2_1
XFILLER_113_161 VGND VGND VPWR VPWR sky130_fd_sc_hd__decap_6
XFILLER_59_237 VPWR VGND VPWR VGND sky130_ef_sc_hd__decap_12
XFILLER_142_15 VPWR VGND VPWR VGND sky130_ef_sc_hd__decap_12
XFILLER_75_708 VPWR VGND VPWR VGND sky130_ef_sc_hd__decap_12
XTAP_TAPCELL_ROW_126_2348 VGND VPWR sky130_fd_sc_hd__tapvpwrvgnd_1
XFILLER_68_793 VPWR VGND VPWR VGND sky130_ef_sc_hd__decap_12
XFILLER_19_69 VPWR VGND VPWR VGND sky130_ef_sc_hd__decap_12
XFILLER_28_613 VPWR VGND VPWR VGND sky130_ef_sc_hd__decap_12
XFILLER_83_741 VPWR VGND VPWR VGND sky130_ef_sc_hd__decap_12
XFILLER_67_281 VPWR VGND VPWR VGND sky130_ef_sc_hd__decap_12
XFILLER_28_657 VPWR VGND VPWR VGND sky130_ef_sc_hd__decap_12
XFILLER_83_785 VPWR VGND VPWR VGND sky130_ef_sc_hd__decap_12
XFILLER_70_402 VPWR VGND VPWR VGND sky130_ef_sc_hd__decap_12
XFILLER_27_167 VGND VGND VPWR VPWR sky130_fd_sc_hd__fill_1
XFILLER_15_329 VGND VGND VPWR VPWR sky130_fd_sc_hd__decap_6
XFILLER_35_57 VPWR VGND VPWR VGND sky130_ef_sc_hd__decap_12
XFILLER_43_638 VPWR VGND VPWR VGND sky130_ef_sc_hd__decap_12
XFILLER_70_468 VGND VGND VPWR VPWR sky130_fd_sc_hd__decap_8
XANTENNA__3274__RESET_B net36 VGND VGND VPWR VPWR sky130_fd_sc_hd__diode_2
XTAP_TAPCELL_ROW_104_1989 VGND VPWR sky130_fd_sc_hd__tapvpwrvgnd_1
XFILLER_51_671 VGND VGND VPWR VPWR sky130_fd_sc_hd__fill_1
XTAP_TAPCELL_ROW_46_1074 VGND VPWR sky130_fd_sc_hd__tapvpwrvgnd_1
XFILLER_23_351 VPWR VGND VPWR VGND sky130_ef_sc_hd__decap_12
XTAP_TAPCELL_ROW_34_880 VGND VPWR sky130_fd_sc_hd__tapvpwrvgnd_1
XTAP_TAPCELL_ROW_46_1063 VGND VPWR sky130_fd_sc_hd__tapvpwrvgnd_1
XFILLER_128_209 VPWR VGND VPWR VGND sky130_ef_sc_hd__decap_12
Xclkbuf_3_3__f_clk clknet_0_clk VGND VGND VPWR VPWR clknet_3_3__leaf_clk sky130_fd_sc_hd__clkbuf_16
XPHY_EDGE_ROW_14_Right_14 VGND VGND VPWR VPWR sky130_fd_sc_hd__decap_3
XFILLER_137_721 VGND VGND VPWR VPWR sky130_fd_sc_hd__decap_6
XFILLER_129_3 VPWR VGND VPWR VGND sky130_ef_sc_hd__decap_12
XANTENNA__3277__CLK clknet_3_0__leaf_clk VGND VGND VPWR VPWR sky130_fd_sc_hd__diode_2
XFILLER_7_517 VPWR VGND VPWR VGND sky130_ef_sc_hd__decap_12
XFILLER_137_765 VPWR VGND VPWR VGND sky130_ef_sc_hd__decap_12
XFILLER_152_713 VPWR VGND VPWR VGND sky130_ef_sc_hd__decap_12
XFILLER_136_253 VPWR VGND VPWR VGND sky130_ef_sc_hd__decap_12
XFILLER_152_757 VPWR VGND VPWR VGND sky130_ef_sc_hd__decap_12
XFILLER_151_223 VGND VGND VPWR VPWR sky130_fd_sc_hd__fill_1
XFILLER_105_673 VPWR VGND VPWR VGND sky130_ef_sc_hd__decap_12
XFILLER_2_233 VPWR VGND VPWR VGND sky130_ef_sc_hd__decap_12
XFILLER_78_513 VPWR VGND VPWR VGND sky130_ef_sc_hd__decap_12
XFILLER_2_266 VPWR VGND VPWR VGND sky130_ef_sc_hd__decap_12
XPHY_EDGE_ROW_23_Right_23 VGND VGND VPWR VPWR sky130_fd_sc_hd__decap_3
XFILLER_120_643 VGND VGND VPWR VPWR sky130_fd_sc_hd__fill_1
XFILLER_78_557 VGND VGND VPWR VPWR sky130_fd_sc_hd__decap_4
XFILLER_93_527 VPWR VGND VPWR VGND sky130_ef_sc_hd__decap_12
XFILLER_76_75 VGND VGND VPWR VPWR sky130_fd_sc_hd__decap_8
XFILLER_59_782 VGND VGND VPWR VPWR sky130_fd_sc_hd__fill_2
XFILLER_58_292 VPWR VGND VPWR VGND sky130_ef_sc_hd__decap_12
XFILLER_46_421 VPWR VGND VPWR VGND sky130_ef_sc_hd__decap_12
XFILLER_61_402 VPWR VGND VPWR VGND sky130_ef_sc_hd__decap_12
XFILLER_92_41 VPWR VGND VPWR VGND sky130_ef_sc_hd__decap_12
XFILLER_73_273 VGND VGND VPWR VPWR sky130_fd_sc_hd__decap_6
XFILLER_18_189 VGND VGND VPWR VPWR sky130_fd_sc_hd__decap_6
XFILLER_92_85 VPWR VGND VPWR VGND sky130_ef_sc_hd__decap_12
XFILLER_61_446 VGND VGND VPWR VPWR sky130_fd_sc_hd__fill_2
XFILLER_15_841 VPWR VGND VPWR VGND sky130_ef_sc_hd__decap_12
XPHY_EDGE_ROW_32_Right_32 VGND VGND VPWR VPWR sky130_fd_sc_hd__decap_3
XFILLER_33_137 VPWR VGND VPWR VGND sky130_ef_sc_hd__decap_12
XFILLER_30_811 VGND VGND VPWR VPWR sky130_fd_sc_hd__fill_1
XTAP_TAPCELL_ROW_32_839 VGND VPWR sky130_fd_sc_hd__tapvpwrvgnd_1
XFILLER_42_671 VPWR VGND VPWR VGND sky130_ef_sc_hd__decap_12
X_1880_ A_reg\[3\] _1146_ _1147_ VGND VGND VPWR VPWR _1150_ sky130_fd_sc_hd__o21a_1
XTAP_TAPCELL_ROW_12_530 VGND VPWR sky130_fd_sc_hd__tapvpwrvgnd_1
XFILLER_41_181 VPWR VGND VPWR VGND sky130_ef_sc_hd__decap_12
XFILLER_147_529 VPWR VGND VPWR VGND sky130_ef_sc_hd__decap_12
XFILLER_30_877 VGND VGND VPWR VPWR sky130_fd_sc_hd__decap_3
XFILLER_116_905 VGND VGND VPWR VPWR sky130_fd_sc_hd__decap_4
XTAP_TAPCELL_ROW_77_1557 VGND VPWR sky130_fd_sc_hd__tapvpwrvgnd_1
X_2501_ _0232_ _0248_ VGND VGND VPWR VPWR _0249_ sky130_fd_sc_hd__xnor2_1
XTAP_TAPCELL_ROW_77_1568 VGND VPWR sky130_fd_sc_hd__tapvpwrvgnd_1
XFILLER_142_245 VGND VGND VPWR VPWR sky130_fd_sc_hd__decap_6
XFILLER_102_109 VPWR VGND VPWR VGND sky130_ef_sc_hd__decap_12
X_2432_ _0171_ _0175_ _0173_ VGND VGND VPWR VPWR _0183_ sky130_fd_sc_hd__o21ai_1
XPHY_EDGE_ROW_41_Right_41 VGND VGND VPWR VPWR sky130_fd_sc_hd__decap_3
XFILLER_44_3 VPWR VGND VPWR VGND sky130_ef_sc_hd__decap_12
XFILLER_142_289 VPWR VGND VPWR VGND sky130_ef_sc_hd__decap_12
XFILLER_97_833 VGND VGND VPWR VPWR sky130_fd_sc_hd__decap_6
X_2363_ _0114_ _0116_ VGND VGND VPWR VPWR _0117_ sky130_fd_sc_hd__nor2_1
XTAP_TAPCELL_ROW_90_1768 VGND VPWR sky130_fd_sc_hd__tapvpwrvgnd_1
XFILLER_111_665 VGND VGND VPWR VPWR sky130_fd_sc_hd__decap_6
XFILLER_97_877 VPWR VGND VPWR VGND sky130_ef_sc_hd__decap_12
XFILLER_96_354 VGND VGND VPWR VPWR sky130_fd_sc_hd__decap_8
XTAP_TAPCELL_ROW_90_1779 VGND VPWR sky130_fd_sc_hd__tapvpwrvgnd_1
XFILLER_110_153 VPWR VGND VPWR VGND sky130_ef_sc_hd__decap_12
XFILLER_96_365 VPWR VGND VPWR VGND sky130_ef_sc_hd__decap_12
X_2294_ _1535_ _1537_ _0911_ VGND VGND VPWR VPWR _1548_ sky130_fd_sc_hd__a21oi_1
XFILLER_110_197 VPWR VGND VPWR VGND sky130_ef_sc_hd__decap_12
XTAP_TAPCELL_ROW_108_2067 VGND VPWR sky130_fd_sc_hd__tapvpwrvgnd_1
XTAP_TAPCELL_ROW_108_2056 VGND VPWR sky130_fd_sc_hd__tapvpwrvgnd_1
XANTENNA__2638__A1 _0184_ VGND VGND VPWR VPWR sky130_fd_sc_hd__diode_2
XFILLER_65_741 VPWR VGND VPWR VGND sky130_ef_sc_hd__decap_12
XFILLER_49_281 VGND VGND VPWR VPWR sky130_fd_sc_hd__decap_4
XFILLER_2_83 VGND VGND VPWR VPWR sky130_fd_sc_hd__fill_1
XFILLER_37_421 VPWR VGND VPWR VGND sky130_ef_sc_hd__decap_12
XFILLER_112_29 VPWR VGND VPWR VGND sky130_ef_sc_hd__decap_12
XFILLER_65_785 VPWR VGND VPWR VGND sky130_ef_sc_hd__decap_12
XFILLER_65_774 VGND VGND VPWR VPWR sky130_fd_sc_hd__decap_8
XFILLER_92_593 VGND VGND VPWR VPWR sky130_fd_sc_hd__fill_1
XFILLER_92_582 VGND VGND VPWR VPWR sky130_fd_sc_hd__decap_6
XFILLER_52_413 VGND VGND VPWR VPWR sky130_fd_sc_hd__decap_6
XPHY_EDGE_ROW_50_Right_50 VGND VGND VPWR VPWR sky130_fd_sc_hd__decap_3
XTAP_TAPCELL_ROW_121_2267 VGND VPWR sky130_fd_sc_hd__tapvpwrvgnd_1
XFILLER_52_468 VGND VGND VPWR VPWR sky130_fd_sc_hd__decap_3
XFILLER_33_671 VGND VGND VPWR VPWR sky130_fd_sc_hd__fill_1
XFILLER_20_321 VPWR VGND VPWR VGND sky130_ef_sc_hd__decap_12
XFILLER_21_833 VGND VGND VPWR VPWR sky130_fd_sc_hd__decap_6
XFILLER_119_721 VGND VGND VPWR VPWR sky130_fd_sc_hd__decap_6
XFILLER_20_365 VPWR VGND VPWR VGND sky130_ef_sc_hd__decap_12
XFILLER_21_877 VPWR VGND VPWR VGND sky130_ef_sc_hd__decap_12
XFILLER_119_765 VPWR VGND VPWR VGND sky130_ef_sc_hd__decap_12
XFILLER_21_15 VPWR VGND VPWR VGND sky130_ef_sc_hd__decap_12
XFILLER_137_15 VPWR VGND VPWR VGND sky130_ef_sc_hd__decap_12
XFILLER_134_713 VPWR VGND VPWR VGND sky130_ef_sc_hd__decap_12
XFILLER_118_253 VPWR VGND VPWR VGND sky130_ef_sc_hd__decap_12
XFILLER_134_757 VPWR VGND VPWR VGND sky130_ef_sc_hd__decap_12
XFILLER_133_223 VGND VGND VPWR VPWR sky130_fd_sc_hd__fill_1
XFILLER_106_437 VPWR VGND VPWR VGND sky130_ef_sc_hd__decap_12
XFILLER_88_811 VGND VGND VPWR VPWR sky130_fd_sc_hd__fill_1
XFILLER_121_429 VPWR VGND VPWR VGND sky130_ef_sc_hd__decap_12
XFILLER_99_181 VPWR VGND VPWR VGND sky130_ef_sc_hd__decap_12
XFILLER_102_643 VGND VGND VPWR VPWR sky130_fd_sc_hd__fill_1
XFILLER_153_69 VPWR VGND VPWR VGND sky130_ef_sc_hd__decap_12
XFILLER_75_505 VPWR VGND VPWR VGND sky130_ef_sc_hd__decap_12
XFILLER_28_421 VGND VGND VPWR VPWR sky130_fd_sc_hd__decap_6
XFILLER_47_229 VGND VGND VPWR VPWR sky130_fd_sc_hd__fill_1
XTAP_TAPCELL_ROW_48_1103 VGND VPWR sky130_fd_sc_hd__tapvpwrvgnd_1
XTAP_TAPCELL_ROW_39_950 VGND VPWR sky130_fd_sc_hd__tapvpwrvgnd_1
XTAP_TAPCELL_ROW_39_961 VGND VPWR sky130_fd_sc_hd__tapvpwrvgnd_1
XFILLER_71_777 VGND VGND VPWR VPWR sky130_fd_sc_hd__decap_6
XFILLER_15_137 VPWR VGND VPWR VGND sky130_ef_sc_hd__decap_12
XTAP_TAPCELL_ROW_61_1314 VGND VPWR sky130_fd_sc_hd__tapvpwrvgnd_1
XTAP_TAPCELL_ROW_61_1303 VGND VPWR sky130_fd_sc_hd__tapvpwrvgnd_1
XFILLER_12_811 VGND VGND VPWR VPWR sky130_fd_sc_hd__fill_1
XFILLER_31_619 VPWR VGND VPWR VGND sky130_ef_sc_hd__decap_12
XFILLER_23_181 VPWR VGND VPWR VGND sky130_ef_sc_hd__decap_12
XFILLER_24_693 VGND VGND VPWR VPWR sky130_fd_sc_hd__decap_6
XFILLER_129_529 VPWR VGND VPWR VGND sky130_ef_sc_hd__decap_12
XFILLER_8_837 VPWR VGND VPWR VGND sky130_ef_sc_hd__decap_12
XFILLER_7_39 VPWR VGND VPWR VGND sky130_ef_sc_hd__decap_12
XFILLER_137_573 VPWR VGND VPWR VGND sky130_ef_sc_hd__decap_12
XTAP_TAPCELL_ROW_59_1276 VGND VPWR sky130_fd_sc_hd__tapvpwrvgnd_1
XFILLER_124_245 VGND VGND VPWR VPWR sky130_fd_sc_hd__decap_6
XFILLER_11_81 VPWR VGND VPWR VGND sky130_ef_sc_hd__decap_12
XFILLER_140_749 VGND VGND VPWR VPWR sky130_fd_sc_hd__decap_6
XFILLER_127_81 VPWR VGND VPWR VGND sky130_ef_sc_hd__decap_12
XFILLER_124_289 VPWR VGND VPWR VGND sky130_ef_sc_hd__decap_12
XFILLER_79_833 VGND VGND VPWR VPWR sky130_fd_sc_hd__decap_6
XFILLER_79_877 VPWR VGND VPWR VGND sky130_ef_sc_hd__decap_12
XFILLER_78_321 VPWR VGND VPWR VGND sky130_ef_sc_hd__decap_12
XTAP_TAPCELL_ROW_72_1487 VGND VPWR sky130_fd_sc_hd__tapvpwrvgnd_1
XTAP_TAPCELL_ROW_72_1476 VGND VPWR sky130_fd_sc_hd__tapvpwrvgnd_1
XFILLER_94_825 VPWR VGND VPWR VGND sky130_ef_sc_hd__decap_12
XFILLER_78_365 VGND VGND VPWR VPWR sky130_fd_sc_hd__fill_1
XFILLER_94_869 VPWR VGND VPWR VGND sky130_ef_sc_hd__decap_12
XFILLER_93_335 VGND VGND VPWR VPWR sky130_fd_sc_hd__fill_1
XFILLER_47_752 VPWR VGND VPWR VGND sky130_ef_sc_hd__decap_12
XFILLER_46_251 VGND VGND VPWR VPWR sky130_fd_sc_hd__fill_1
XFILLER_47_785 VPWR VGND VPWR VGND sky130_ef_sc_hd__decap_12
XTAP_TAPCELL_ROW_17_600 VGND VPWR sky130_fd_sc_hd__tapvpwrvgnd_1
XTAP_TAPCELL_ROW_17_611 VGND VPWR sky130_fd_sc_hd__tapvpwrvgnd_1
XFILLER_34_413 VGND VGND VPWR VPWR sky130_fd_sc_hd__decap_6
XFILLER_46_273 VGND VGND VPWR VPWR sky130_fd_sc_hd__fill_2
XFILLER_62_755 VGND VGND VPWR VPWR sky130_fd_sc_hd__fill_1
XFILLER_34_457 VPWR VGND VPWR VGND sky130_ef_sc_hd__decap_12
X_2981_ _0577_ _0664_ _0665_ _0572_ VGND VGND VPWR VPWR _0669_ sky130_fd_sc_hd__and4b_1
XFILLER_15_671 VGND VGND VPWR VPWR sky130_fd_sc_hd__fill_1
XFILLER_148_805 VGND VGND VPWR VPWR sky130_fd_sc_hd__decap_6
X_1932_ _1186_ _1189_ _1193_ VGND VGND VPWR VPWR _1197_ sky130_fd_sc_hd__o21ba_1
XFILLER_148_849 VPWR VGND VPWR VGND sky130_ef_sc_hd__decap_12
X_1863_ _1132_ _0892_ _1130_ VGND VGND VPWR VPWR _1133_ sky130_fd_sc_hd__mux2_1
XFILLER_147_337 VPWR VGND VPWR VGND sky130_ef_sc_hd__decap_12
Xinput31 B_in[8] VGND VGND VPWR VPWR net31 sky130_fd_sc_hd__clkbuf_1
Xinput20 B_in[12] VGND VGND VPWR VPWR net20 sky130_fd_sc_hd__clkbuf_1
XFILLER_116_713 VPWR VGND VPWR VGND sky130_ef_sc_hd__decap_12
X_1794_ A_reg\[6\] _1061_ VGND VGND VPWR VPWR _1067_ sky130_fd_sc_hd__xnor2_1
XFILLER_116_757 VPWR VGND VPWR VGND sky130_ef_sc_hd__decap_12
XFILLER_115_223 VGND VGND VPWR VPWR sky130_fd_sc_hd__fill_1
XTAP_TAPCELL_ROW_92_1808 VGND VPWR sky130_fd_sc_hd__tapvpwrvgnd_1
XANTENNA__3209__B _0912_ VGND VGND VPWR VPWR sky130_fd_sc_hd__diode_2
XFILLER_131_727 VGND VGND VPWR VPWR sky130_fd_sc_hd__fill_1
X_2415_ _0897_ _0166_ _0167_ VGND VGND VPWR VPWR _0169_ sky130_fd_sc_hd__or3_1
XFILLER_97_641 VPWR VGND VPWR VGND sky130_ef_sc_hd__decap_12
XFILLER_97_685 VPWR VGND VPWR VGND sky130_ef_sc_hd__decap_12
X_2346_ _1582_ _1590_ VGND VGND VPWR VPWR _1599_ sky130_fd_sc_hd__xnor2_1
XFILLER_57_505 VPWR VGND VPWR VGND sky130_ef_sc_hd__decap_12
XFILLER_123_39 VPWR VGND VPWR VGND sky130_ef_sc_hd__decap_12
XFILLER_96_195 VGND VGND VPWR VPWR sky130_fd_sc_hd__fill_1
X_2277_ _1532_ _1533_ VGND VGND VPWR VPWR _1534_ sky130_fd_sc_hd__nand2_1
XTAP_TAPCELL_ROW_123_2307 VGND VPWR sky130_fd_sc_hd__tapvpwrvgnd_1
XFILLER_16_15 VPWR VGND VPWR VGND sky130_ef_sc_hd__decap_12
XFILLER_52_221 VPWR VGND VPWR VGND sky130_ef_sc_hd__decap_12
XFILLER_25_435 VPWR VGND VPWR VGND sky130_ef_sc_hd__decap_12
XTAP_TAPCELL_ROW_101_1948 VGND VPWR sky130_fd_sc_hd__tapvpwrvgnd_1
XTAP_TAPCELL_ROW_43_1022 VGND VPWR sky130_fd_sc_hd__tapvpwrvgnd_1
XFILLER_21_641 VPWR VGND VPWR VGND sky130_ef_sc_hd__decap_12
XFILLER_21_685 VPWR VGND VPWR VGND sky130_ef_sc_hd__decap_12
XFILLER_119_573 VPWR VGND VPWR VGND sky130_ef_sc_hd__decap_12
XFILLER_20_195 VGND VGND VPWR VPWR sky130_fd_sc_hd__fill_1
XTAP_TAPCELL_ROW_151_2750 VGND VPWR sky130_fd_sc_hd__tapvpwrvgnd_1
XTAP_TAPCELL_ROW_134_2469 VGND VPWR sky130_fd_sc_hd__tapvpwrvgnd_1
XFILLER_106_245 VGND VGND VPWR VPWR sky130_fd_sc_hd__decap_6
XFILLER_134_587 VGND VGND VPWR VPWR sky130_fd_sc_hd__fill_1
XFILLER_122_749 VGND VGND VPWR VPWR sky130_fd_sc_hd__decap_6
XFILLER_106_289 VPWR VGND VPWR VGND sky130_ef_sc_hd__decap_12
XFILLER_0_501 VGND VGND VPWR VPWR sky130_fd_sc_hd__decap_3
XANTENNA__3315__CLK clknet_3_7__leaf_clk VGND VGND VPWR VPWR sky130_fd_sc_hd__diode_2
XFILLER_121_237 VPWR VGND VPWR VGND sky130_ef_sc_hd__decap_12
XFILLER_0_545 VGND VGND VPWR VPWR sky130_fd_sc_hd__fill_2
XFILLER_76_825 VPWR VGND VPWR VGND sky130_ef_sc_hd__decap_12
XTAP_TAPCELL_ROW_54_1195 VGND VPWR sky130_fd_sc_hd__tapvpwrvgnd_1
XFILLER_0_589 VGND VGND VPWR VPWR sky130_fd_sc_hd__decap_8
XFILLER_130_793 VPWR VGND VPWR VGND sky130_ef_sc_hd__decap_12
XFILLER_76_869 VPWR VGND VPWR VGND sky130_ef_sc_hd__decap_12
XFILLER_57_99 VPWR VGND VPWR VGND sky130_ef_sc_hd__decap_12
XTAP_TAPCELL_ROW_3_372 VGND VPWR sky130_fd_sc_hd__tapvpwrvgnd_1
XFILLER_29_741 VPWR VGND VPWR VGND sky130_ef_sc_hd__decap_12
XFILLER_91_839 VGND VGND VPWR VPWR sky130_fd_sc_hd__fill_1
XFILLER_56_571 VPWR VGND VPWR VGND sky130_ef_sc_hd__decap_12
XTAP_TAPCELL_ROW_3_383 VGND VPWR sky130_fd_sc_hd__tapvpwrvgnd_1
XFILLER_16_413 VGND VGND VPWR VPWR sky130_fd_sc_hd__decap_6
XFILLER_29_785 VPWR VGND VPWR VGND sky130_ef_sc_hd__decap_12
XFILLER_31_405 VPWR VGND VPWR VGND sky130_ef_sc_hd__decap_12
XFILLER_43_276 VGND VGND VPWR VPWR sky130_fd_sc_hd__decap_4
XFILLER_44_777 VGND VGND VPWR VPWR sky130_fd_sc_hd__fill_1
XFILLER_31_449 VPWR VGND VPWR VGND sky130_ef_sc_hd__decap_12
XFILLER_8_601 VPWR VGND VPWR VGND sky130_ef_sc_hd__decap_12
XFILLER_129_337 VPWR VGND VPWR VGND sky130_ef_sc_hd__decap_12
XFILLER_8_645 VPWR VGND VPWR VGND sky130_ef_sc_hd__decap_12
XFILLER_7_111 VGND VGND VPWR VPWR sky130_fd_sc_hd__fill_1
XTAP_TAPCELL_ROW_22_680 VGND VPWR sky130_fd_sc_hd__tapvpwrvgnd_1
XFILLER_144_307 VGND VGND VPWR VPWR sky130_fd_sc_hd__fill_1
XTAP_TAPCELL_ROW_22_691 VGND VPWR sky130_fd_sc_hd__tapvpwrvgnd_1
XFILLER_153_841 VPWR VGND VPWR VGND sky130_ef_sc_hd__decap_12
XFILLER_138_893 VPWR VGND VPWR VGND sky130_ef_sc_hd__decap_12
XTAP_TAPCELL_ROW_74_1516 VGND VPWR sky130_fd_sc_hd__tapvpwrvgnd_1
XFILLER_140_513 VPWR VGND VPWR VGND sky130_ef_sc_hd__decap_12
XFILLER_113_727 VGND VGND VPWR VPWR sky130_fd_sc_hd__fill_1
XFILLER_140_557 VPWR VGND VPWR VGND sky130_ef_sc_hd__decap_12
X_2200_ A_reg\[8\] _1452_ _1442_ VGND VGND VPWR VPWR _1457_ sky130_fd_sc_hd__a21oi_1
XFILLER_79_685 VPWR VGND VPWR VGND sky130_ef_sc_hd__decap_12
XFILLER_39_505 VPWR VGND VPWR VGND sky130_ef_sc_hd__decap_12
X_3180_ X_crt\[2\] CRT_Start _0864_ _0865_ VGND VGND VPWR VPWR _0091_ sky130_fd_sc_hd__o22a_1
X_2131_ B_reg\[4\] _1387_ _1389_ VGND VGND VPWR VPWR _1390_ sky130_fd_sc_hd__o21a_1
XFILLER_78_195 VGND VGND VPWR VPWR sky130_fd_sc_hd__fill_1
XANTENNA__3306__RESET_B net36 VGND VGND VPWR VPWR sky130_fd_sc_hd__diode_2
XTAP_TAPCELL_ROW_105_2015 VGND VPWR sky130_fd_sc_hd__tapvpwrvgnd_1
XTAP_TAPCELL_ROW_105_2004 VGND VPWR sky130_fd_sc_hd__tapvpwrvgnd_1
X_2062_ _1316_ _1321_ _1323_ VGND VGND VPWR VPWR _1324_ sky130_fd_sc_hd__o21ai_2
XFILLER_81_305 VPWR VGND VPWR VGND sky130_ef_sc_hd__decap_12
XFILLER_66_357 VGND VGND VPWR VPWR sky130_fd_sc_hd__fill_2
XFILLER_94_699 VGND VGND VPWR VPWR sky130_fd_sc_hd__fill_1
XANTENNA__2095__S Encode_EN VGND VGND VPWR VPWR sky130_fd_sc_hd__diode_2
XFILLER_90_861 VGND VGND VPWR VPWR sky130_fd_sc_hd__decap_6
XTAP_TAPCELL_ROW_85_1689 VGND VPWR sky130_fd_sc_hd__tapvpwrvgnd_1
XFILLER_50_714 VPWR VGND VPWR VGND sky130_ef_sc_hd__decap_12
XFILLER_34_265 VPWR VGND VPWR VGND sky130_ef_sc_hd__decap_12
XFILLER_35_777 VGND VGND VPWR VPWR sky130_fd_sc_hd__decap_6
X_2964_ _0633_ _0651_ VGND VGND VPWR VPWR _0652_ sky130_fd_sc_hd__xor2_1
XANTENNA__2823__S _0553_ VGND VGND VPWR VPWR sky130_fd_sc_hd__diode_2
XFILLER_148_613 VPWR VGND VPWR VGND sky130_ef_sc_hd__decap_12
X_1915_ B_reg\[11\] _1179_ VGND VGND VPWR VPWR _1180_ sky130_fd_sc_hd__and2_1
XFILLER_50_769 VPWR VGND VPWR VGND sky130_ef_sc_hd__decap_12
XFILLER_148_657 VPWR VGND VPWR VGND sky130_ef_sc_hd__decap_12
X_2895_ _0579_ _0582_ VGND VGND VPWR VPWR _0583_ sky130_fd_sc_hd__nor2_1
XFILLER_147_167 VGND VGND VPWR VPWR sky130_fd_sc_hd__fill_1
X_1846_ A_reg\[12\] _1114_ _1112_ _1011_ VGND VGND VPWR VPWR _1116_ sky130_fd_sc_hd__a211o_1
XPHY_EDGE_ROW_7_Left_161 VGND VGND VPWR VPWR sky130_fd_sc_hd__decap_3
XFILLER_135_329 VGND VGND VPWR VPWR sky130_fd_sc_hd__decap_6
X_1777_ _1048_ _1049_ VGND VGND VPWR VPWR _1050_ sky130_fd_sc_hd__and2_1
XTAP_TAPCELL_ROW_116_2188 VGND VPWR sky130_fd_sc_hd__tapvpwrvgnd_1
XANTENNA__1963__A B_reg\[4\] VGND VGND VPWR VPWR sky130_fd_sc_hd__diode_2
XFILLER_143_373 VPWR VGND VPWR VGND sky130_ef_sc_hd__decap_12
XFILLER_116_587 VGND VGND VPWR VPWR sky130_fd_sc_hd__fill_1
XPHY_EDGE_ROW_4_Right_4 VGND VGND VPWR VPWR sky130_fd_sc_hd__decap_3
XFILLER_104_749 VGND VGND VPWR VPWR sky130_fd_sc_hd__decap_6
XFILLER_103_237 VPWR VGND VPWR VGND sky130_ef_sc_hd__decap_12
XFILLER_89_449 VPWR VGND VPWR VGND sky130_ef_sc_hd__decap_12
XFILLER_134_27 VGND VGND VPWR VPWR sky130_fd_sc_hd__fill_1
XFILLER_112_793 VPWR VGND VPWR VGND sky130_ef_sc_hd__decap_12
XFILLER_111_281 VPWR VGND VPWR VGND sky130_ef_sc_hd__decap_12
X_2329_ _1580_ _1581_ VGND VGND VPWR VPWR _1582_ sky130_fd_sc_hd__nor2_1
XFILLER_57_335 VGND VGND VPWR VPWR sky130_fd_sc_hd__fill_1
XFILLER_84_132 VGND VGND VPWR VPWR sky130_fd_sc_hd__decap_8
XFILLER_58_869 VPWR VGND VPWR VGND sky130_ef_sc_hd__decap_12
XFILLER_150_15 VPWR VGND VPWR VGND sky130_ef_sc_hd__decap_12
XFILLER_84_165 VPWR VGND VPWR VGND sky130_ef_sc_hd__decap_12
XFILLER_73_839 VGND VGND VPWR VPWR sky130_fd_sc_hd__fill_1
XTAP_TAPCELL_ROW_0_320 VGND VPWR sky130_fd_sc_hd__tapvpwrvgnd_1
XFILLER_27_69 VPWR VGND VPWR VGND sky130_ef_sc_hd__decap_12
XTAP_TAPCELL_ROW_0_331 VGND VPWR sky130_fd_sc_hd__tapvpwrvgnd_1
XFILLER_26_755 VGND VGND VPWR VPWR sky130_fd_sc_hd__fill_1
XFILLER_13_405 VPWR VGND VPWR VGND sky130_ef_sc_hd__decap_12
XTAP_TAPCELL_ROW_136_2509 VGND VPWR sky130_fd_sc_hd__tapvpwrvgnd_1
XFILLER_40_246 VGND VGND VPWR VPWR sky130_fd_sc_hd__decap_6
XFILLER_43_57 VPWR VGND VPWR VGND sky130_ef_sc_hd__decap_12
XTAP_TAPCELL_ROW_153_2801 VGND VPWR sky130_fd_sc_hd__tapvpwrvgnd_1
XFILLER_126_307 VGND VGND VPWR VPWR sky130_fd_sc_hd__fill_1
XFILLER_153_137 VGND VGND VPWR VPWR sky130_fd_sc_hd__decap_3
XFILLER_138_189 VGND VGND VPWR VPWR sky130_fd_sc_hd__decap_6
XFILLER_111_3 VPWR VGND VPWR VGND sky130_ef_sc_hd__decap_12
XFILLER_5_615 VGND VGND VPWR VPWR sky130_fd_sc_hd__fill_1
XFILLER_135_841 VPWR VGND VPWR VGND sky130_ef_sc_hd__decap_12
XFILLER_150_811 VGND VGND VPWR VPWR sky130_fd_sc_hd__fill_1
XFILLER_122_513 VPWR VGND VPWR VGND sky130_ef_sc_hd__decap_12
XTAP_TAPCELL_ROW_56_1235 VGND VPWR sky130_fd_sc_hd__tapvpwrvgnd_1
XTAP_TAPCELL_ROW_56_1224 VGND VPWR sky130_fd_sc_hd__tapvpwrvgnd_1
XFILLER_4_29 VPWR VGND VPWR VGND sky130_ef_sc_hd__decap_12
XFILLER_122_557 VPWR VGND VPWR VGND sky130_ef_sc_hd__decap_12
XFILLER_108_83 VGND VGND VPWR VPWR sky130_fd_sc_hd__fill_1
XFILLER_96_909 VGND VGND VPWR VPWR sky130_fd_sc_hd__fill_1
XTAP_TAPCELL_ROW_8_464 VGND VPWR sky130_fd_sc_hd__tapvpwrvgnd_1
XTAP_TAPCELL_ROW_8_453 VGND VPWR sky130_fd_sc_hd__tapvpwrvgnd_1
XFILLER_1_821 VPWR VGND VPWR VGND sky130_ef_sc_hd__decap_12
XFILLER_1_865 VPWR VGND VPWR VGND sky130_ef_sc_hd__decap_12
XANTENNA_input31_A B_in[8] VGND VGND VPWR VPWR sky130_fd_sc_hd__diode_2
XFILLER_49_847 VGND VGND VPWR VPWR sky130_fd_sc_hd__fill_1
XFILLER_84_31 VPWR VGND VPWR VGND sky130_ef_sc_hd__decap_12
XFILLER_90_113 VGND VGND VPWR VPWR sky130_fd_sc_hd__fill_1
XFILLER_76_699 VGND VGND VPWR VPWR sky130_fd_sc_hd__fill_1
XFILLER_90_135 VGND VGND VPWR VPWR sky130_fd_sc_hd__decap_4
XFILLER_63_349 VPWR VGND VPWR VGND sky130_ef_sc_hd__decap_12
XFILLER_16_221 VPWR VGND VPWR VGND sky130_ef_sc_hd__decap_12
XFILLER_72_861 VGND VGND VPWR VPWR sky130_fd_sc_hd__decap_6
XFILLER_16_265 VPWR VGND VPWR VGND sky130_ef_sc_hd__decap_12
XFILLER_17_777 VGND VGND VPWR VPWR sky130_fd_sc_hd__decap_6
XTAP_TAPCELL_ROW_27_761 VGND VPWR sky130_fd_sc_hd__tapvpwrvgnd_1
XFILLER_32_725 VPWR VGND VPWR VGND sky130_ef_sc_hd__decap_12
XANTENNA__2643__S _0383_ VGND VGND VPWR VPWR sky130_fd_sc_hd__diode_2
XFILLER_71_393 VPWR VGND VPWR VGND sky130_ef_sc_hd__decap_12
XTAP_TAPCELL_ROW_67_1397 VGND VPWR sky130_fd_sc_hd__tapvpwrvgnd_1
XANTENNA__2471__A2 b_r1\[0\] VGND VGND VPWR VPWR sky130_fd_sc_hd__diode_2
XFILLER_20_909 VGND VGND VPWR VPWR sky130_fd_sc_hd__fill_1
XFILLER_31_279 VGND VGND VPWR VPWR sky130_fd_sc_hd__fill_1
XFILLER_129_167 VGND VGND VPWR VPWR sky130_fd_sc_hd__fill_1
X_2680_ _0410_ _0419_ VGND VGND VPWR VPWR _0420_ sky130_fd_sc_hd__xnor2_1
XFILLER_76_6 VGND VGND VPWR VPWR sky130_fd_sc_hd__fill_1
X_1700_ _0968_ _0975_ VGND VGND VPWR VPWR _0976_ sky130_fd_sc_hd__nor2_1
XFILLER_117_329 VGND VGND VPWR VPWR sky130_fd_sc_hd__decap_6
XFILLER_8_475 VGND VGND VPWR VPWR sky130_fd_sc_hd__fill_1
X_1631_ _0910_ VGND VGND VPWR VPWR ALU_EN sky130_fd_sc_hd__inv_2
XANTENNA__1783__A A_reg\[6\] VGND VGND VPWR VPWR sky130_fd_sc_hd__diode_2
XFILLER_141_833 VGND VGND VPWR VPWR sky130_fd_sc_hd__decap_6
XFILLER_125_373 VPWR VGND VPWR VGND sky130_ef_sc_hd__decap_12
X_3301_ clknet_3_0__leaf_clk _0084_ net36 VGND VGND VPWR VPWR B_reg\[11\] sky130_fd_sc_hd__dfrtp_4
XFILLER_140_321 VPWR VGND VPWR VGND sky130_ef_sc_hd__decap_12
XFILLER_98_246 VGND VGND VPWR VPWR sky130_fd_sc_hd__fill_1
XFILLER_87_909 VGND VGND VPWR VPWR sky130_fd_sc_hd__fill_1
XFILLER_141_877 VPWR VGND VPWR VGND sky130_ef_sc_hd__decap_12
XFILLER_140_365 VPWR VGND VPWR VGND sky130_ef_sc_hd__decap_12
XFILLER_86_419 VGND VGND VPWR VPWR sky130_fd_sc_hd__fill_1
X_3232_ clknet_3_3__leaf_clk _0019_ net36 VGND VGND VPWR VPWR a_r3\[0\] sky130_fd_sc_hd__dfrtp_4
XFILLER_100_229 VGND VGND VPWR VPWR sky130_fd_sc_hd__decap_3
XANTENNA__2818__S _0553_ VGND VGND VPWR VPWR sky130_fd_sc_hd__diode_2
X_3163_ _0815_ _0817_ _0827_ VGND VGND VPWR VPWR _0851_ sky130_fd_sc_hd__o21ai_1
XFILLER_39_335 VGND VGND VPWR VPWR sky130_fd_sc_hd__fill_1
XTAP_TAPCELL_ROW_87_1718 VGND VPWR sky130_fd_sc_hd__tapvpwrvgnd_1
X_2114_ B_reg\[9\] _1369_ _1370_ VGND VGND VPWR VPWR _1373_ sky130_fd_sc_hd__a21oi_1
XFILLER_55_817 VGND VGND VPWR VPWR sky130_fd_sc_hd__fill_2
XFILLER_94_474 VGND VGND VPWR VPWR sky130_fd_sc_hd__fill_2
XTAP_TAPCELL_ROW_87_1729 VGND VPWR sky130_fd_sc_hd__tapvpwrvgnd_1
XFILLER_81_113 VPWR VGND VPWR VGND sky130_ef_sc_hd__decap_12
XFILLER_67_688 VPWR VGND VPWR VGND sky130_ef_sc_hd__decap_12
XFILLER_66_165 VPWR VGND VPWR VGND sky130_ef_sc_hd__decap_12
X_3094_ _0764_ _0781_ VGND VGND VPWR VPWR _0782_ sky130_fd_sc_hd__or2_1
XFILLER_54_327 VPWR VGND VPWR VGND sky130_ef_sc_hd__decap_12
X_2045_ _1305_ _1301_ _1302_ VGND VGND VPWR VPWR _1307_ sky130_fd_sc_hd__mux2_1
XFILLER_82_669 VPWR VGND VPWR VGND sky130_ef_sc_hd__decap_12
XANTENNA__2119__A B_reg\[7\] VGND VGND VPWR VPWR sky130_fd_sc_hd__diode_2
XFILLER_35_541 VGND VGND VPWR VPWR sky130_fd_sc_hd__fill_1
XFILLER_120_29 VPWR VGND VPWR VGND sky130_ef_sc_hd__decap_12
XFILLER_50_533 VPWR VGND VPWR VGND sky130_ef_sc_hd__decap_12
XFILLER_50_566 VPWR VGND VPWR VGND sky130_ef_sc_hd__decap_12
XFILLER_11_909 VGND VGND VPWR VPWR sky130_fd_sc_hd__fill_1
XFILLER_22_257 VPWR VGND VPWR VGND sky130_ef_sc_hd__decap_12
XFILLER_148_421 VPWR VGND VPWR VGND sky130_ef_sc_hd__decap_12
XTAP_TAPCELL_ROW_118_2217 VGND VPWR sky130_fd_sc_hd__tapvpwrvgnd_1
X_2947_ _0633_ _0634_ VGND VGND VPWR VPWR _0635_ sky130_fd_sc_hd__and2_1
XFILLER_13_27 VPWR VGND VPWR VGND sky130_ef_sc_hd__decap_12
XFILLER_129_27 VPWR VGND VPWR VGND sky130_ef_sc_hd__decap_12
XFILLER_108_307 VGND VGND VPWR VPWR sky130_fd_sc_hd__fill_1
X_2878_ u_crt.r3\[2\] _0565_ VGND VGND VPWR VPWR _0566_ sky130_fd_sc_hd__nor2_2
XFILLER_135_137 VPWR VGND VPWR VGND sky130_ef_sc_hd__decap_12
XTAP_TAPCELL_ROW_131_2428 VGND VPWR sky130_fd_sc_hd__tapvpwrvgnd_1
XFILLER_117_841 VPWR VGND VPWR VGND sky130_ef_sc_hd__decap_12
X_1829_ A_reg\[0\] _1101_ VGND VGND VPWR VPWR _1102_ sky130_fd_sc_hd__nor2_1
XFILLER_145_15 VPWR VGND VPWR VGND sky130_ef_sc_hd__decap_12
XFILLER_132_811 VGND VGND VPWR VPWR sky130_fd_sc_hd__fill_1
XFILLER_89_213 VGND VGND VPWR VPWR sky130_fd_sc_hd__fill_1
XANTENNA__3299__RESET_B net36 VGND VGND VPWR VPWR sky130_fd_sc_hd__diode_2
XFILLER_144_693 VGND VGND VPWR VPWR sky130_fd_sc_hd__decap_6
XFILLER_143_181 VPWR VGND VPWR VGND sky130_ef_sc_hd__decap_12
XFILLER_104_557 VPWR VGND VPWR VGND sky130_ef_sc_hd__decap_12
XFILLER_104_524 VGND VGND VPWR VPWR sky130_fd_sc_hd__decap_8
XFILLER_78_909 VGND VGND VPWR VPWR sky130_fd_sc_hd__fill_1
XANTENNA__3228__RESET_B net36 VGND VGND VPWR VPWR sky130_fd_sc_hd__diode_2
XTAP_TAPCELL_ROW_5_412 VGND VPWR sky130_fd_sc_hd__tapvpwrvgnd_1
XTAP_TAPCELL_ROW_51_1143 VGND VPWR sky130_fd_sc_hd__tapvpwrvgnd_1
XTAP_TAPCELL_ROW_146_2671 VGND VPWR sky130_fd_sc_hd__tapvpwrvgnd_1
XTAP_TAPCELL_ROW_146_2660 VGND VPWR sky130_fd_sc_hd__tapvpwrvgnd_1
XFILLER_85_441 VGND VGND VPWR VPWR sky130_fd_sc_hd__decap_6
XTAP_TAPCELL_ROW_51_1154 VGND VPWR sky130_fd_sc_hd__tapvpwrvgnd_1
XFILLER_85_485 VPWR VGND VPWR VGND sky130_ef_sc_hd__decap_12
XPHY_EDGE_ROW_79_Right_79 VGND VGND VPWR VPWR sky130_fd_sc_hd__decap_3
XFILLER_46_839 VPWR VGND VPWR VGND sky130_ef_sc_hd__decap_12
XFILLER_45_305 VPWR VGND VPWR VGND sky130_ef_sc_hd__decap_12
XFILLER_61_809 VPWR VGND VPWR VGND sky130_ef_sc_hd__decap_12
XFILLER_57_198 VPWR VGND VPWR VGND sky130_ef_sc_hd__decap_12
XFILLER_45_349 VPWR VGND VPWR VGND sky130_ef_sc_hd__decap_12
XFILLER_53_393 VPWR VGND VPWR VGND sky130_ef_sc_hd__decap_12
XFILLER_14_725 VPWR VGND VPWR VGND sky130_ef_sc_hd__decap_12
XTAP_TAPCELL_ROW_24_720 VGND VPWR sky130_fd_sc_hd__tapvpwrvgnd_1
XFILLER_14_769 VPWR VGND VPWR VGND sky130_ef_sc_hd__decap_12
XFILLER_9_217 VGND VGND VPWR VPWR sky130_fd_sc_hd__decap_6
XFILLER_70_77 VGND VGND VPWR VPWR sky130_fd_sc_hd__decap_4
XPHY_EDGE_ROW_88_Right_88 VGND VGND VPWR VPWR sky130_fd_sc_hd__decap_3
XANTENNA__1964__A1 B_reg\[4\] VGND VGND VPWR VPWR sky130_fd_sc_hd__diode_2
XFILLER_79_20 VPWR VGND VPWR VGND sky130_ef_sc_hd__decap_12
XFILLER_135_671 VGND VGND VPWR VPWR sky130_fd_sc_hd__fill_1
XFILLER_119_93 VPWR VGND VPWR VGND sky130_ef_sc_hd__decap_12
XFILLER_107_373 VGND VGND VPWR VPWR sky130_fd_sc_hd__decap_3
XANTENNA__1716__A1 A_reg\[1\] VGND VGND VPWR VPWR sky130_fd_sc_hd__diode_2
XFILLER_123_833 VGND VGND VPWR VPWR sky130_fd_sc_hd__decap_6
XFILLER_122_321 VPWR VGND VPWR VGND sky130_ef_sc_hd__decap_12
XFILLER_107_384 VGND VGND VPWR VPWR sky130_fd_sc_hd__decap_6
XFILLER_69_909 VGND VGND VPWR VPWR sky130_fd_sc_hd__fill_1
XFILLER_123_877 VPWR VGND VPWR VGND sky130_ef_sc_hd__decap_12
XFILLER_122_365 VPWR VGND VPWR VGND sky130_ef_sc_hd__decap_12
XFILLER_110_516 VGND VGND VPWR VPWR sky130_fd_sc_hd__fill_2
XPHY_EDGE_ROW_79_Left_233 VGND VGND VPWR VPWR sky130_fd_sc_hd__decap_3
XANTENNA_input34_X net34 VGND VGND VPWR VPWR sky130_fd_sc_hd__diode_2
XFILLER_135_81 VPWR VGND VPWR VGND sky130_ef_sc_hd__decap_12
XFILLER_49_622 VPWR VGND VPWR VGND sky130_ef_sc_hd__decap_12
XFILLER_1_673 VPWR VGND VPWR VGND sky130_ef_sc_hd__decap_12
XPHY_EDGE_ROW_97_Right_97 VGND VGND VPWR VPWR sky130_fd_sc_hd__decap_3
XFILLER_95_249 VPWR VGND VPWR VGND sky130_ef_sc_hd__decap_12
XFILLER_48_121 VPWR VGND VPWR VGND sky130_ef_sc_hd__decap_12
XTAP_TAPCELL_ROW_69_1437 VGND VPWR sky130_fd_sc_hd__tapvpwrvgnd_1
XFILLER_64_625 VPWR VGND VPWR VGND sky130_ef_sc_hd__decap_12
XFILLER_48_165 VPWR VGND VPWR VGND sky130_ef_sc_hd__decap_12
XFILLER_37_839 VGND VGND VPWR VPWR sky130_fd_sc_hd__fill_1
XFILLER_64_669 VPWR VGND VPWR VGND sky130_ef_sc_hd__decap_12
XFILLER_63_113 VPWR VGND VPWR VGND sky130_ef_sc_hd__decap_12
XFILLER_36_349 VGND VGND VPWR VPWR sky130_fd_sc_hd__fill_1
XFILLER_51_308 VPWR VGND VPWR VGND sky130_ef_sc_hd__decap_12
XFILLER_17_541 VPWR VGND VPWR VGND sky130_ef_sc_hd__decap_12
XPHY_EDGE_ROW_88_Left_242 VGND VGND VPWR VPWR sky130_fd_sc_hd__decap_3
XTAP_TAPCELL_ROW_82_1648 VGND VPWR sky130_fd_sc_hd__tapvpwrvgnd_1
XTAP_TAPCELL_ROW_82_1637 VGND VPWR sky130_fd_sc_hd__tapvpwrvgnd_1
XFILLER_17_585 VPWR VGND VPWR VGND sky130_ef_sc_hd__decap_12
XANTENNA__1778__A A_reg\[8\] VGND VGND VPWR VPWR sky130_fd_sc_hd__diode_2
XFILLER_32_533 VGND VGND VPWR VPWR sky130_fd_sc_hd__decap_4
XFILLER_45_894 VGND VGND VPWR VPWR sky130_fd_sc_hd__fill_2
X_2801_ _0530_ _0522_ _0528_ VGND VGND VPWR VPWR _0541_ sky130_fd_sc_hd__mux2_1
X_2732_ _0423_ _0437_ _0469_ _0470_ VGND VGND VPWR VPWR _0472_ sky130_fd_sc_hd__o22ai_1
XFILLER_117_137 VPWR VGND VPWR VGND sky130_ef_sc_hd__decap_12
X_2663_ b_r3\[1\] _0392_ _0401_ VGND VGND VPWR VPWR _0403_ sky130_fd_sc_hd__and3_1
XFILLER_114_811 VGND VGND VPWR VPWR sky130_fd_sc_hd__fill_1
XTAP_TAPCELL_ROW_113_2147 VGND VPWR sky130_fd_sc_hd__tapvpwrvgnd_1
XTAP_TAPCELL_ROW_113_2136 VGND VPWR sky130_fd_sc_hd__tapvpwrvgnd_1
XTAP_TAPCELL_ROW_97_1891 VGND VPWR sky130_fd_sc_hd__tapvpwrvgnd_1
XTAP_TAPCELL_ROW_97_1880 VGND VPWR sky130_fd_sc_hd__tapvpwrvgnd_1
XPHY_EDGE_ROW_97_Left_251 VGND VGND VPWR VPWR sky130_fd_sc_hd__decap_3
X_2594_ a_r2\[2\] b_r2\[2\] VGND VGND VPWR VPWR _0339_ sky130_fd_sc_hd__nor2_1
XTAP_TAPCELL_ROW_10_491 VGND VPWR sky130_fd_sc_hd__tapvpwrvgnd_1
X_1614_ A_reg\[5\] VGND VGND VPWR VPWR _0894_ sky130_fd_sc_hd__inv_2
XFILLER_141_641 VPWR VGND VPWR VGND sky130_ef_sc_hd__decap_12
XFILLER_126_693 VGND VGND VPWR VPWR sky130_fd_sc_hd__decap_6
XFILLER_125_181 VPWR VGND VPWR VGND sky130_ef_sc_hd__decap_12
XANTENNA__3321__RESET_B net36 VGND VGND VPWR VPWR sky130_fd_sc_hd__diode_2
XFILLER_101_505 VPWR VGND VPWR VGND sky130_ef_sc_hd__decap_12
XFILLER_141_685 VPWR VGND VPWR VGND sky130_ef_sc_hd__decap_12
X_3215_ clknet_3_4__leaf_clk _0003_ net36 VGND VGND VPWR VPWR a_r1\[0\] sky130_fd_sc_hd__dfrtp_4
XFILLER_140_195 VGND VGND VPWR VPWR sky130_fd_sc_hd__fill_1
XANTENNA__2668__C1 OpSel_reg\[0\] VGND VGND VPWR VPWR sky130_fd_sc_hd__diode_2
XFILLER_95_783 VGND VGND VPWR VPWR sky130_fd_sc_hd__fill_1
XFILLER_67_485 VPWR VGND VPWR VGND sky130_ef_sc_hd__decap_12
XFILLER_27_305 VGND VGND VPWR VPWR sky130_fd_sc_hd__decap_8
X_3146_ _0801_ _0833_ VGND VGND VPWR VPWR _0834_ sky130_fd_sc_hd__xnor2_1
XFILLER_131_39 VPWR VGND VPWR VGND sky130_ef_sc_hd__decap_12
XFILLER_82_433 VGND VGND VPWR VPWR sky130_fd_sc_hd__decap_8
X_3077_ _0679_ _0764_ _0663_ VGND VGND VPWR VPWR _0765_ sky130_fd_sc_hd__o21ai_1
XFILLER_55_658 VGND VGND VPWR VPWR sky130_fd_sc_hd__fill_1
XFILLER_27_349 VPWR VGND VPWR VGND sky130_ef_sc_hd__decap_12
XFILLER_43_809 VPWR VGND VPWR VGND sky130_ef_sc_hd__decap_12
X_2028_ _1286_ _1287_ _1289_ VGND VGND VPWR VPWR _1290_ sky130_fd_sc_hd__a21bo_1
XTAP_TAPCELL_ROW_141_2590 VGND VPWR sky130_fd_sc_hd__tapvpwrvgnd_1
XFILLER_24_15 VPWR VGND VPWR VGND sky130_ef_sc_hd__decap_12
XFILLER_51_853 VPWR VGND VPWR VGND sky130_ef_sc_hd__decap_12
XFILLER_35_393 VPWR VGND VPWR VGND sky130_ef_sc_hd__decap_12
XFILLER_149_741 VPWR VGND VPWR VGND sky130_ef_sc_hd__decap_12
XFILLER_51_897 VPWR VGND VPWR VGND sky130_ef_sc_hd__decap_12
XFILLER_50_363 VGND VGND VPWR VPWR sky130_fd_sc_hd__fill_1
XFILLER_148_251 VGND VGND VPWR VPWR sky130_fd_sc_hd__fill_1
XFILLER_149_785 VPWR VGND VPWR VGND sky130_ef_sc_hd__decap_12
XFILLER_136_413 VGND VGND VPWR VPWR sky130_fd_sc_hd__decap_6
XFILLER_6_209 VPWR VGND VPWR VGND sky130_ef_sc_hd__decap_12
XFILLER_136_457 VPWR VGND VPWR VGND sky130_ef_sc_hd__decap_12
XFILLER_151_405 VPWR VGND VPWR VGND sky130_ef_sc_hd__decap_12
XFILLER_117_671 VGND VGND VPWR VPWR sky130_fd_sc_hd__fill_1
XFILLER_151_449 VPWR VGND VPWR VGND sky130_ef_sc_hd__decap_12
XFILLER_105_833 VGND VGND VPWR VPWR sky130_fd_sc_hd__decap_6
XFILLER_104_321 VPWR VGND VPWR VGND sky130_ef_sc_hd__decap_12
XFILLER_2_415 VGND VGND VPWR VPWR sky130_fd_sc_hd__decap_4
XTAP_TAPCELL_ROW_148_2700 VGND VPWR sky130_fd_sc_hd__tapvpwrvgnd_1
XFILLER_105_877 VPWR VGND VPWR VGND sky130_ef_sc_hd__decap_12
XFILLER_77_205 VPWR VGND VPWR VGND sky130_ef_sc_hd__decap_12
XFILLER_120_825 VPWR VGND VPWR VGND sky130_ef_sc_hd__decap_12
XFILLER_104_387 VPWR VGND VPWR VGND sky130_ef_sc_hd__decap_12
XPHY_EDGE_ROW_130_Right_130 VGND VGND VPWR VPWR sky130_fd_sc_hd__decap_3
XFILLER_120_869 VPWR VGND VPWR VGND sky130_ef_sc_hd__decap_12
XFILLER_93_709 VPWR VGND VPWR VGND sky130_ef_sc_hd__decap_12
XFILLER_19_839 VGND VGND VPWR VPWR sky130_fd_sc_hd__fill_1
XTAP_TAPCELL_ROW_29_801 VGND VPWR sky130_fd_sc_hd__tapvpwrvgnd_1
XFILLER_100_582 VGND VGND VPWR VPWR sky130_fd_sc_hd__decap_6
XFILLER_46_658 VPWR VGND VPWR VGND sky130_ef_sc_hd__decap_12
XFILLER_34_809 VGND VGND VPWR VPWR sky130_fd_sc_hd__decap_3
XFILLER_45_113 VPWR VGND VPWR VGND sky130_ef_sc_hd__decap_12
XFILLER_65_99 VGND VGND VPWR VPWR sky130_fd_sc_hd__fill_1
XFILLER_61_617 VPWR VGND VPWR VGND sky130_ef_sc_hd__decap_12
XFILLER_73_488 VPWR VGND VPWR VGND sky130_ef_sc_hd__decap_12
XTAP_TAPCELL_ROW_64_1356 VGND VPWR sky130_fd_sc_hd__tapvpwrvgnd_1
XFILLER_14_533 VPWR VGND VPWR VGND sky130_ef_sc_hd__decap_12
XFILLER_41_341 VGND VGND VPWR VPWR sky130_fd_sc_hd__fill_1
XFILLER_139_273 VGND VGND VPWR VPWR sky130_fd_sc_hd__decap_6
XANTENNA__1937__A1 B_reg\[8\] VGND VGND VPWR VPWR sky130_fd_sc_hd__diode_2
XANTENNA__2222__A A_reg\[6\] VGND VGND VPWR VPWR sky130_fd_sc_hd__diode_2
XFILLER_108_693 VGND VGND VPWR VPWR sky130_fd_sc_hd__decap_6
XFILLER_107_181 VPWR VGND VPWR VGND sky130_ef_sc_hd__decap_12
XFILLER_123_641 VPWR VGND VPWR VGND sky130_ef_sc_hd__decap_12
XFILLER_123_685 VPWR VGND VPWR VGND sky130_ef_sc_hd__decap_12
XFILLER_122_195 VGND VGND VPWR VPWR sky130_fd_sc_hd__fill_1
XFILLER_110_357 VGND VGND VPWR VPWR sky130_fd_sc_hd__decap_6
X_3000_ _0557_ _0623_ VGND VGND VPWR VPWR _0688_ sky130_fd_sc_hd__nand2_2
XFILLER_49_485 VPWR VGND VPWR VGND sky130_ef_sc_hd__decap_12
Xinput7 A_in[15] VGND VGND VPWR VPWR net7 sky130_fd_sc_hd__clkbuf_1
XFILLER_76_271 VGND VGND VPWR VPWR sky130_fd_sc_hd__fill_1
XFILLER_64_477 VGND VGND VPWR VPWR sky130_fd_sc_hd__decap_4
XFILLER_64_466 VGND VGND VPWR VPWR sky130_fd_sc_hd__decap_8
XFILLER_18_861 VGND VGND VPWR VPWR sky130_fd_sc_hd__decap_6
XFILLER_25_809 VPWR VGND VPWR VGND sky130_ef_sc_hd__decap_12
XFILLER_33_831 VGND VGND VPWR VPWR sky130_fd_sc_hd__decap_8
XFILLER_17_393 VPWR VGND VPWR VGND sky130_ef_sc_hd__decap_12
XFILLER_33_853 VGND VGND VPWR VPWR sky130_fd_sc_hd__decap_3
XFILLER_33_897 VGND VGND VPWR VPWR sky130_fd_sc_hd__decap_8
XTAP_TAPCELL_ROW_99_1920 VGND VPWR sky130_fd_sc_hd__tapvpwrvgnd_1
XANTENNA__2831__S _0553_ VGND VGND VPWR VPWR sky130_fd_sc_hd__diode_2
XTAP_TAPCELL_ROW_15_572 VGND VPWR sky130_fd_sc_hd__tapvpwrvgnd_1
XFILLER_20_525 VGND VGND VPWR VPWR sky130_fd_sc_hd__decap_6
XFILLER_118_413 VGND VGND VPWR VPWR sky130_fd_sc_hd__decap_6
XFILLER_20_569 VPWR VGND VPWR VGND sky130_ef_sc_hd__decap_12
XFILLER_146_755 VGND VGND VPWR VPWR sky130_fd_sc_hd__fill_1
XFILLER_118_457 VPWR VGND VPWR VGND sky130_ef_sc_hd__decap_12
X_2715_ _0453_ _0454_ VGND VGND VPWR VPWR _0455_ sky130_fd_sc_hd__and2_1
XFILLER_133_405 VPWR VGND VPWR VGND sky130_ef_sc_hd__decap_12
X_2646_ b_r3\[0\] a_r3\[0\] VGND VGND VPWR VPWR _0386_ sky130_fd_sc_hd__or2_1
XFILLER_133_449 VPWR VGND VPWR VGND sky130_ef_sc_hd__decap_12
XFILLER_87_503 VGND VGND VPWR VPWR sky130_fd_sc_hd__fill_1
X_2577_ _0312_ _0316_ VGND VGND VPWR VPWR _0322_ sky130_fd_sc_hd__and2b_1
XFILLER_102_825 VPWR VGND VPWR VGND sky130_ef_sc_hd__decap_12
XFILLER_102_869 VPWR VGND VPWR VGND sky130_ef_sc_hd__decap_12
XFILLER_101_335 VGND VGND VPWR VPWR sky130_fd_sc_hd__fill_1
XFILLER_59_249 VPWR VGND VPWR VGND sky130_ef_sc_hd__decap_12
XFILLER_19_15 VPWR VGND VPWR VGND sky130_ef_sc_hd__decap_12
XFILLER_142_27 VGND VGND VPWR VPWR sky130_fd_sc_hd__fill_1
XTAP_TAPCELL_ROW_126_2349 VGND VPWR sky130_fd_sc_hd__tapvpwrvgnd_1
XFILLER_28_625 VPWR VGND VPWR VGND sky130_ef_sc_hd__decap_12
XFILLER_83_753 VPWR VGND VPWR VGND sky130_ef_sc_hd__decap_12
XFILLER_67_293 VGND VGND VPWR VPWR sky130_fd_sc_hd__decap_4
XFILLER_27_113 VPWR VGND VPWR VGND sky130_ef_sc_hd__decap_12
X_3129_ _0778_ _0796_ _0798_ _0816_ VGND VGND VPWR VPWR _0817_ sky130_fd_sc_hd__a31oi_4
XFILLER_28_669 VPWR VGND VPWR VGND sky130_ef_sc_hd__decap_12
XFILLER_43_617 VPWR VGND VPWR VGND sky130_ef_sc_hd__decap_12
XFILLER_83_797 VPWR VGND VPWR VGND sky130_ef_sc_hd__decap_12
XFILLER_70_414 VGND VGND VPWR VPWR sky130_fd_sc_hd__decap_6
XFILLER_35_69 VPWR VGND VPWR VGND sky130_ef_sc_hd__decap_12
XTAP_TAPCELL_ROW_46_1075 VGND VPWR sky130_fd_sc_hd__tapvpwrvgnd_1
XFILLER_23_363 VPWR VGND VPWR VGND sky130_ef_sc_hd__decap_12
XTAP_TAPCELL_ROW_34_870 VGND VPWR sky130_fd_sc_hd__tapvpwrvgnd_1
XTAP_TAPCELL_ROW_46_1064 VGND VPWR sky130_fd_sc_hd__tapvpwrvgnd_1
XFILLER_50_193 VGND VGND VPWR VPWR sky130_fd_sc_hd__fill_1
XTAP_TAPCELL_ROW_34_881 VGND VPWR sky130_fd_sc_hd__tapvpwrvgnd_1
XFILLER_7_529 VPWR VGND VPWR VGND sky130_ef_sc_hd__decap_12
XFILLER_136_221 VPWR VGND VPWR VGND sky130_ef_sc_hd__decap_12
XANTENNA__3243__RESET_B net36 VGND VGND VPWR VPWR sky130_fd_sc_hd__diode_2
XANTENNA_clkbuf_3_5__f_clk_X clknet_3_5__leaf_clk VGND VGND VPWR VPWR sky130_fd_sc_hd__diode_2
XFILLER_152_725 VPWR VGND VPWR VGND sky130_ef_sc_hd__decap_12
XFILLER_137_777 VGND VGND VPWR VPWR sky130_fd_sc_hd__decap_6
XFILLER_136_265 VPWR VGND VPWR VGND sky130_ef_sc_hd__decap_12
XFILLER_152_769 VPWR VGND VPWR VGND sky130_ef_sc_hd__decap_12
XFILLER_140_909 VGND VGND VPWR VPWR sky130_fd_sc_hd__fill_1
XFILLER_105_641 VPWR VGND VPWR VGND sky130_ef_sc_hd__decap_12
XFILLER_4_3 VPWR VGND VPWR VGND sky130_ef_sc_hd__decap_12
XFILLER_151_279 VGND VGND VPWR VPWR sky130_fd_sc_hd__fill_1
XFILLER_105_685 VPWR VGND VPWR VGND sky130_ef_sc_hd__decap_12
XFILLER_78_525 VGND VGND VPWR VPWR sky130_fd_sc_hd__decap_6
XFILLER_2_278 VPWR VGND VPWR VGND sky130_ef_sc_hd__decap_12
XFILLER_116_83 VGND VGND VPWR VPWR sky130_fd_sc_hd__fill_1
XFILLER_104_195 VGND VGND VPWR VPWR sky130_fd_sc_hd__fill_1
XFILLER_120_699 VGND VGND VPWR VPWR sky130_fd_sc_hd__fill_1
XFILLER_93_539 VPWR VGND VPWR VGND sky130_ef_sc_hd__decap_12
XFILLER_46_433 VGND VGND VPWR VPWR sky130_fd_sc_hd__fill_1
XFILLER_92_20 VGND VGND VPWR VPWR sky130_fd_sc_hd__decap_8
XFILLER_62_904 VGND VGND VPWR VPWR sky130_fd_sc_hd__decap_3
XANTENNA__1855__B1 A_reg\[9\] VGND VGND VPWR VPWR sky130_fd_sc_hd__diode_2
XFILLER_46_455 VGND VGND VPWR VPWR sky130_fd_sc_hd__decap_4
XFILLER_92_53 VPWR VGND VPWR VGND sky130_ef_sc_hd__decap_12
XFILLER_61_414 VPWR VGND VPWR VGND sky130_ef_sc_hd__decap_12
XFILLER_33_105 VGND VGND VPWR VPWR sky130_fd_sc_hd__decap_6
XFILLER_92_97 VPWR VGND VPWR VGND sky130_ef_sc_hd__decap_12
XFILLER_15_853 VPWR VGND VPWR VGND sky130_ef_sc_hd__decap_12
XFILLER_33_149 VPWR VGND VPWR VGND sky130_ef_sc_hd__decap_12
XFILLER_15_897 VPWR VGND VPWR VGND sky130_ef_sc_hd__decap_12
XFILLER_42_683 VPWR VGND VPWR VGND sky130_ef_sc_hd__decap_12
XTAP_TAPCELL_ROW_12_520 VGND VPWR sky130_fd_sc_hd__tapvpwrvgnd_1
XFILLER_14_385 VGND VGND VPWR VPWR sky130_fd_sc_hd__fill_1
XANTENNA__3221__CLK clknet_3_4__leaf_clk VGND VGND VPWR VPWR sky130_fd_sc_hd__diode_2
XFILLER_41_193 VPWR VGND VPWR VGND sky130_ef_sc_hd__decap_12
XTAP_TAPCELL_ROW_12_531 VGND VPWR sky130_fd_sc_hd__tapvpwrvgnd_1
XFILLER_30_867 VGND VGND VPWR VPWR sky130_fd_sc_hd__fill_1
XFILLER_128_755 VGND VGND VPWR VPWR sky130_fd_sc_hd__fill_1
XFILLER_115_405 VPWR VGND VPWR VGND sky130_ef_sc_hd__decap_12
X_2500_ _0246_ _0247_ VGND VGND VPWR VPWR _0248_ sky130_fd_sc_hd__or2_1
XFILLER_115_449 VPWR VGND VPWR VGND sky130_ef_sc_hd__decap_12
X_2431_ b_r3\[3\] _0911_ VGND VGND VPWR VPWR _0182_ sky130_fd_sc_hd__and2_1
XTAP_TAPCELL_ROW_77_1569 VGND VPWR sky130_fd_sc_hd__tapvpwrvgnd_1
XTAP_TAPCELL_ROW_77_1558 VGND VPWR sky130_fd_sc_hd__tapvpwrvgnd_1
XFILLER_131_909 VGND VGND VPWR VPWR sky130_fd_sc_hd__fill_1
XFILLER_130_419 VGND VGND VPWR VPWR sky130_fd_sc_hd__fill_1
X_2362_ _0904_ _0109_ _0111_ VGND VGND VPWR VPWR _0116_ sky130_fd_sc_hd__and3_1
XFILLER_69_503 VGND VGND VPWR VPWR sky130_fd_sc_hd__fill_1
XFILLER_37_3 VPWR VGND VPWR VGND sky130_ef_sc_hd__decap_12
XFILLER_110_121 VPWR VGND VPWR VGND sky130_ef_sc_hd__decap_12
XTAP_TAPCELL_ROW_90_1769 VGND VPWR sky130_fd_sc_hd__tapvpwrvgnd_1
X_2293_ _1535_ _1539_ _1537_ VGND VGND VPWR VPWR _1547_ sky130_fd_sc_hd__a21o_1
XFILLER_110_165 VPWR VGND VPWR VGND sky130_ef_sc_hd__decap_12
XFILLER_97_889 VGND VGND VPWR VPWR sky130_fd_sc_hd__decap_6
XFILLER_96_377 VPWR VGND VPWR VGND sky130_ef_sc_hd__decap_12
XTAP_TAPCELL_ROW_108_2057 VGND VPWR sky130_fd_sc_hd__tapvpwrvgnd_1
XFILLER_37_433 VPWR VGND VPWR VGND sky130_ef_sc_hd__decap_12
XFILLER_80_701 VPWR VGND VPWR VGND sky130_ef_sc_hd__decap_12
XFILLER_65_753 VPWR VGND VPWR VGND sky130_ef_sc_hd__decap_12
XANTENNA__2826__S _0553_ VGND VGND VPWR VPWR sky130_fd_sc_hd__diode_2
XFILLER_65_797 VPWR VGND VPWR VGND sky130_ef_sc_hd__decap_12
XFILLER_25_617 VPWR VGND VPWR VGND sky130_ef_sc_hd__decap_12
XFILLER_37_477 VGND VGND VPWR VPWR sky130_fd_sc_hd__decap_8
XTAP_TAPCELL_ROW_121_2268 VGND VPWR sky130_fd_sc_hd__tapvpwrvgnd_1
XFILLER_20_333 VGND VGND VPWR VPWR sky130_fd_sc_hd__decap_8
XFILLER_21_889 VGND VGND VPWR VPWR sky130_fd_sc_hd__decap_6
XPHY_EDGE_ROW_25_Left_179 VGND VGND VPWR VPWR sky130_fd_sc_hd__decap_3
XFILLER_118_221 VPWR VGND VPWR VGND sky130_ef_sc_hd__decap_12
XFILLER_20_377 VPWR VGND VPWR VGND sky130_ef_sc_hd__decap_12
XFILLER_21_27 VPWR VGND VPWR VGND sky130_ef_sc_hd__decap_12
XFILLER_137_27 VPWR VGND VPWR VGND sky130_ef_sc_hd__decap_12
XFILLER_119_777 VGND VGND VPWR VPWR sky130_fd_sc_hd__decap_6
XFILLER_118_265 VPWR VGND VPWR VGND sky130_ef_sc_hd__decap_12
XFILLER_134_725 VPWR VGND VPWR VGND sky130_ef_sc_hd__decap_12
XFILLER_106_449 VPWR VGND VPWR VGND sky130_ef_sc_hd__decap_12
XFILLER_134_769 VPWR VGND VPWR VGND sky130_ef_sc_hd__decap_12
XFILLER_122_909 VGND VGND VPWR VPWR sky130_fd_sc_hd__fill_1
X_2629_ _0365_ _0372_ VGND VGND VPWR VPWR _0374_ sky130_fd_sc_hd__nand2_1
XFILLER_153_15 VPWR VGND VPWR VGND sky130_ef_sc_hd__decap_12
XFILLER_133_279 VGND VGND VPWR VPWR sky130_fd_sc_hd__fill_1
XFILLER_99_193 VGND VGND VPWR VPWR sky130_fd_sc_hd__fill_2
XFILLER_88_867 VGND VGND VPWR VPWR sky130_fd_sc_hd__fill_1
XFILLER_75_517 VPWR VGND VPWR VGND sky130_ef_sc_hd__decap_12
XPHY_EDGE_ROW_34_Left_188 VGND VGND VPWR VPWR sky130_fd_sc_hd__decap_3
XFILLER_102_699 VGND VGND VPWR VPWR sky130_fd_sc_hd__fill_1
XFILLER_83_561 VPWR VGND VPWR VGND sky130_ef_sc_hd__decap_12
XTAP_TAPCELL_ROW_48_1104 VGND VPWR sky130_fd_sc_hd__tapvpwrvgnd_1
XTAP_TAPCELL_ROW_39_951 VGND VPWR sky130_fd_sc_hd__tapvpwrvgnd_1
XTAP_TAPCELL_ROW_39_962 VGND VPWR sky130_fd_sc_hd__tapvpwrvgnd_1
XFILLER_15_105 VGND VGND VPWR VPWR sky130_fd_sc_hd__decap_6
XFILLER_28_477 VPWR VGND VPWR VGND sky130_ef_sc_hd__decap_12
XFILLER_102_41 VPWR VGND VPWR VGND sky130_ef_sc_hd__decap_12
XANTENNA__3244__CLK clknet_3_6__leaf_clk VGND VGND VPWR VPWR sky130_fd_sc_hd__diode_2
XFILLER_15_149 VPWR VGND VPWR VGND sky130_ef_sc_hd__decap_12
XFILLER_43_447 VGND VGND VPWR VPWR sky130_fd_sc_hd__fill_1
XFILLER_102_85 VPWR VGND VPWR VGND sky130_ef_sc_hd__decap_12
XTAP_TAPCELL_ROW_61_1315 VGND VPWR sky130_fd_sc_hd__tapvpwrvgnd_1
XTAP_TAPCELL_ROW_61_1304 VGND VPWR sky130_fd_sc_hd__tapvpwrvgnd_1
XFILLER_141_3 VPWR VGND VPWR VGND sky130_ef_sc_hd__decap_12
XFILLER_70_288 VPWR VGND VPWR VGND sky130_ef_sc_hd__decap_12
XFILLER_51_480 VGND VGND VPWR VPWR sky130_fd_sc_hd__decap_3
XFILLER_8_805 VGND VGND VPWR VPWR sky130_fd_sc_hd__decap_6
XPHY_EDGE_ROW_43_Left_197 VGND VGND VPWR VPWR sky130_fd_sc_hd__decap_3
XFILLER_11_333 VGND VGND VPWR VPWR sky130_fd_sc_hd__decap_3
XFILLER_12_867 VGND VGND VPWR VPWR sky130_fd_sc_hd__fill_1
XFILLER_23_193 VPWR VGND VPWR VGND sky130_ef_sc_hd__decap_12
XFILLER_137_541 VPWR VGND VPWR VGND sky130_ef_sc_hd__decap_12
XFILLER_8_849 VPWR VGND VPWR VGND sky130_ef_sc_hd__decap_12
XFILLER_7_337 VPWR VGND VPWR VGND sky130_ef_sc_hd__decap_12
XFILLER_152_533 VPWR VGND VPWR VGND sky130_ef_sc_hd__decap_12
XFILLER_137_585 VPWR VGND VPWR VGND sky130_ef_sc_hd__decap_12
XFILLER_113_909 VGND VGND VPWR VPWR sky130_fd_sc_hd__fill_1
XTAP_TAPCELL_ROW_59_1277 VGND VPWR sky130_fd_sc_hd__tapvpwrvgnd_1
XFILLER_11_93 VPWR VGND VPWR VGND sky130_ef_sc_hd__decap_12
XFILLER_127_93 VPWR VGND VPWR VGND sky130_ef_sc_hd__decap_12
XFILLER_112_419 VGND VGND VPWR VPWR sky130_fd_sc_hd__fill_1
XFILLER_78_333 VPWR VGND VPWR VGND sky130_ef_sc_hd__decap_12
XTAP_TAPCELL_ROW_72_1477 VGND VPWR sky130_fd_sc_hd__tapvpwrvgnd_1
XFILLER_94_837 VPWR VGND VPWR VGND sky130_ef_sc_hd__decap_12
XFILLER_79_889 VGND VGND VPWR VPWR sky130_fd_sc_hd__decap_6
XTAP_TAPCELL_ROW_72_1488 VGND VPWR sky130_fd_sc_hd__tapvpwrvgnd_1
XFILLER_143_81 VPWR VGND VPWR VGND sky130_ef_sc_hd__decap_12
XFILLER_59_591 VPWR VGND VPWR VGND sky130_ef_sc_hd__decap_12
XFILLER_62_701 VPWR VGND VPWR VGND sky130_ef_sc_hd__decap_12
XFILLER_47_764 VGND VGND VPWR VPWR sky130_fd_sc_hd__decap_4
XFILLER_47_797 VPWR VGND VPWR VGND sky130_ef_sc_hd__decap_12
XTAP_TAPCELL_ROW_17_601 VGND VPWR sky130_fd_sc_hd__tapvpwrvgnd_1
X_2980_ _0572_ _0577_ VGND VGND VPWR VPWR _0668_ sky130_fd_sc_hd__xnor2_1
XFILLER_34_469 VGND VGND VPWR VPWR sky130_fd_sc_hd__decap_6
X_1931_ _1186_ _1194_ _1190_ B_reg\[9\] VGND VGND VPWR VPWR _1196_ sky130_fd_sc_hd__o211a_1
XFILLER_147_305 VPWR VGND VPWR VGND sky130_ef_sc_hd__decap_12
X_1862_ _1130_ _1131_ A_reg\[7\] VGND VGND VPWR VPWR _1132_ sky130_fd_sc_hd__o21a_1
XFILLER_147_349 VPWR VGND VPWR VGND sky130_ef_sc_hd__decap_12
Xinput10 A_in[3] VGND VGND VPWR VPWR net10 sky130_fd_sc_hd__clkbuf_1
Xinput21 B_in[13] VGND VGND VPWR VPWR net21 sky130_fd_sc_hd__clkbuf_1
Xinput32 B_in[9] VGND VGND VPWR VPWR net32 sky130_fd_sc_hd__clkbuf_1
X_1793_ _1064_ _1065_ VGND VGND VPWR VPWR _1066_ sky130_fd_sc_hd__nand2_1
XFILLER_116_725 VPWR VGND VPWR VGND sky130_ef_sc_hd__decap_12
XTAP_TAPCELL_ROW_92_1809 VGND VPWR sky130_fd_sc_hd__tapvpwrvgnd_1
XFILLER_116_769 VPWR VGND VPWR VGND sky130_ef_sc_hd__decap_12
XFILLER_104_909 VGND VGND VPWR VPWR sky130_fd_sc_hd__fill_1
XFILLER_89_609 VGND VGND VPWR VPWR sky130_fd_sc_hd__decap_6
XFILLER_6_392 VGND VGND VPWR VPWR sky130_fd_sc_hd__decap_6
XFILLER_115_279 VGND VGND VPWR VPWR sky130_fd_sc_hd__fill_1
X_2414_ _0166_ _0167_ VGND VGND VPWR VPWR _0168_ sky130_fd_sc_hd__nor2_1
XFILLER_97_653 VPWR VGND VPWR VGND sky130_ef_sc_hd__decap_12
XFILLER_111_441 VGND VGND VPWR VPWR sky130_fd_sc_hd__decap_6
XFILLER_96_141 VPWR VGND VPWR VGND sky130_ef_sc_hd__decap_12
X_2345_ _0903_ _1590_ _1591_ VGND VGND VPWR VPWR _1598_ sky130_fd_sc_hd__or3_1
XFILLER_57_517 VPWR VGND VPWR VGND sky130_ef_sc_hd__decap_12
XFILLER_111_485 VGND VGND VPWR VPWR sky130_fd_sc_hd__fill_1
XFILLER_97_697 VPWR VGND VPWR VGND sky130_ef_sc_hd__decap_12
X_2276_ A_reg\[1\] _1530_ _1527_ VGND VGND VPWR VPWR _1533_ sky130_fd_sc_hd__a21o_1
XANTENNA__3267__CLK clknet_3_7__leaf_clk VGND VGND VPWR VPWR sky130_fd_sc_hd__diode_2
XFILLER_65_561 VPWR VGND VPWR VGND sky130_ef_sc_hd__decap_12
XTAP_TAPCELL_ROW_36_910 VGND VPWR sky130_fd_sc_hd__tapvpwrvgnd_1
XFILLER_92_391 VPWR VGND VPWR VGND sky130_ef_sc_hd__decap_12
XFILLER_80_531 VGND VGND VPWR VPWR sky130_fd_sc_hd__fill_1
XFILLER_80_520 VGND VGND VPWR VPWR sky130_fd_sc_hd__decap_4
XFILLER_52_233 VGND VGND VPWR VPWR sky130_fd_sc_hd__fill_2
XFILLER_16_27 VGND VGND VPWR VPWR sky130_fd_sc_hd__fill_1
XFILLER_25_447 VGND VGND VPWR VPWR sky130_fd_sc_hd__fill_1
XFILLER_52_255 VPWR VGND VPWR VGND sky130_ef_sc_hd__decap_12
XFILLER_13_609 VGND VGND VPWR VPWR sky130_fd_sc_hd__decap_6
XTAP_TAPCELL_ROW_101_1949 VGND VPWR sky130_fd_sc_hd__tapvpwrvgnd_1
XFILLER_52_299 VGND VGND VPWR VPWR sky130_fd_sc_hd__fill_1
XTAP_TAPCELL_ROW_43_1012 VGND VPWR sky130_fd_sc_hd__tapvpwrvgnd_1
XTAP_TAPCELL_ROW_43_1023 VGND VPWR sky130_fd_sc_hd__tapvpwrvgnd_1
XFILLER_139_839 VGND VGND VPWR VPWR sky130_fd_sc_hd__fill_1
XTAP_TAPCELL_ROW_138_2540 VGND VPWR sky130_fd_sc_hd__tapvpwrvgnd_1
XFILLER_20_141 VPWR VGND VPWR VGND sky130_ef_sc_hd__decap_12
XFILLER_21_653 VPWR VGND VPWR VGND sky130_ef_sc_hd__decap_12
XFILLER_32_15 VPWR VGND VPWR VGND sky130_ef_sc_hd__decap_12
XFILLER_148_15 VPWR VGND VPWR VGND sky130_ef_sc_hd__decap_12
XFILLER_21_697 VPWR VGND VPWR VGND sky130_ef_sc_hd__decap_12
XFILLER_119_541 VPWR VGND VPWR VGND sky130_ef_sc_hd__decap_12
XTAP_TAPCELL_ROW_151_2751 VGND VPWR sky130_fd_sc_hd__tapvpwrvgnd_1
XTAP_TAPCELL_ROW_151_2740 VGND VPWR sky130_fd_sc_hd__tapvpwrvgnd_1
XFILLER_134_533 VPWR VGND VPWR VGND sky130_ef_sc_hd__decap_12
XFILLER_119_585 VPWR VGND VPWR VGND sky130_ef_sc_hd__decap_12
XFILLER_4_329 VGND VGND VPWR VPWR sky130_fd_sc_hd__fill_1
XFILLER_121_205 VPWR VGND VPWR VGND sky130_ef_sc_hd__decap_12
XFILLER_121_249 VPWR VGND VPWR VGND sky130_ef_sc_hd__decap_12
XFILLER_0_524 VGND VGND VPWR VPWR sky130_fd_sc_hd__decap_8
XFILLER_102_441 VPWR VGND VPWR VGND sky130_ef_sc_hd__decap_12
XFILLER_57_34 VGND VGND VPWR VPWR sky130_fd_sc_hd__fill_1
XTAP_TAPCELL_ROW_54_1196 VGND VPWR sky130_fd_sc_hd__tapvpwrvgnd_1
XFILLER_0_568 VGND VGND VPWR VPWR sky130_fd_sc_hd__fill_2
XFILLER_76_837 VPWR VGND VPWR VGND sky130_ef_sc_hd__decap_12
XFILLER_75_314 VGND VGND VPWR VPWR sky130_fd_sc_hd__fill_2
XFILLER_63_509 VGND VGND VPWR VPWR sky130_fd_sc_hd__fill_1
XFILLER_28_230 VPWR VGND VPWR VGND sky130_ef_sc_hd__decap_12
XFILLER_29_753 VPWR VGND VPWR VGND sky130_ef_sc_hd__decap_12
XFILLER_113_51 VGND VGND VPWR VPWR sky130_fd_sc_hd__decap_4
XFILLER_84_881 VPWR VGND VPWR VGND sky130_ef_sc_hd__decap_12
XFILLER_56_583 VGND VGND VPWR VPWR sky130_fd_sc_hd__decap_4
XTAP_TAPCELL_ROW_3_384 VGND VPWR sky130_fd_sc_hd__tapvpwrvgnd_1
XTAP_TAPCELL_ROW_3_373 VGND VPWR sky130_fd_sc_hd__tapvpwrvgnd_1
XFILLER_29_797 VPWR VGND VPWR VGND sky130_ef_sc_hd__decap_12
XFILLER_83_391 VGND VGND VPWR VPWR sky130_fd_sc_hd__fill_1
XFILLER_73_55 VGND VGND VPWR VPWR sky130_fd_sc_hd__fill_1
XFILLER_43_211 VPWR VGND VPWR VGND sky130_ef_sc_hd__decap_12
XPHY_EDGE_ROW_51_Left_205 VGND VGND VPWR VPWR sky130_fd_sc_hd__decap_3
XFILLER_31_417 VPWR VGND VPWR VGND sky130_ef_sc_hd__decap_12
XFILLER_129_305 VPWR VGND VPWR VGND sky130_ef_sc_hd__decap_12
XFILLER_8_613 VPWR VGND VPWR VGND sky130_ef_sc_hd__decap_12
XFILLER_145_809 VPWR VGND VPWR VGND sky130_ef_sc_hd__decap_12
XFILLER_129_349 VPWR VGND VPWR VGND sky130_ef_sc_hd__decap_12
XFILLER_138_861 VGND VGND VPWR VPWR sky130_fd_sc_hd__decap_6
XFILLER_8_657 VPWR VGND VPWR VGND sky130_ef_sc_hd__decap_12
XTAP_TAPCELL_ROW_22_681 VGND VPWR sky130_fd_sc_hd__tapvpwrvgnd_1
XFILLER_7_167 VGND VGND VPWR VPWR sky130_fd_sc_hd__fill_1
XFILLER_153_853 VPWR VGND VPWR VGND sky130_ef_sc_hd__decap_12
XFILLER_137_393 VPWR VGND VPWR VGND sky130_ef_sc_hd__decap_12
XFILLER_98_41 VPWR VGND VPWR VGND sky130_ef_sc_hd__decap_12
XTAP_TAPCELL_ROW_74_1517 VGND VPWR sky130_fd_sc_hd__tapvpwrvgnd_1
XPHY_EDGE_ROW_60_Left_214 VGND VGND VPWR VPWR sky130_fd_sc_hd__decap_3
XFILLER_153_897 VPWR VGND VPWR VGND sky130_ef_sc_hd__decap_12
XFILLER_152_363 VGND VGND VPWR VPWR sky130_fd_sc_hd__fill_1
XFILLER_140_525 VGND VGND VPWR VPWR sky130_fd_sc_hd__decap_6
XFILLER_98_428 VPWR VGND VPWR VGND sky130_ef_sc_hd__decap_12
XFILLER_98_417 VGND VGND VPWR VPWR sky130_fd_sc_hd__decap_3
XFILLER_98_85 VPWR VGND VPWR VGND sky130_ef_sc_hd__decap_12
XFILLER_140_569 VPWR VGND VPWR VGND sky130_ef_sc_hd__decap_12
XFILLER_94_601 VPWR VGND VPWR VGND sky130_ef_sc_hd__decap_12
XFILLER_78_141 VPWR VGND VPWR VGND sky130_ef_sc_hd__decap_12
XFILLER_78_130 VGND VGND VPWR VPWR sky130_fd_sc_hd__fill_1
XFILLER_39_517 VPWR VGND VPWR VGND sky130_ef_sc_hd__decap_12
XFILLER_121_783 VGND VGND VPWR VPWR sky130_fd_sc_hd__fill_1
XFILLER_94_645 VPWR VGND VPWR VGND sky130_ef_sc_hd__decap_12
XFILLER_93_111 VGND VGND VPWR VPWR sky130_fd_sc_hd__fill_1
X_2130_ _0906_ _1388_ VGND VGND VPWR VPWR _1389_ sky130_fd_sc_hd__or2_1
XFILLER_79_697 VPWR VGND VPWR VGND sky130_ef_sc_hd__decap_12
XTAP_TAPCELL_ROW_105_2005 VGND VPWR sky130_fd_sc_hd__tapvpwrvgnd_1
X_2061_ _1316_ _1318_ VGND VGND VPWR VPWR _1323_ sky130_fd_sc_hd__nand2_1
XTAP_TAPCELL_ROW_89_1760 VGND VPWR sky130_fd_sc_hd__tapvpwrvgnd_1
XTAP_TAPCELL_ROW_105_2016 VGND VPWR sky130_fd_sc_hd__tapvpwrvgnd_1
XFILLER_81_317 VPWR VGND VPWR VGND sky130_ef_sc_hd__decap_12
XFILLER_47_561 VPWR VGND VPWR VGND sky130_ef_sc_hd__decap_12
XFILLER_50_726 VPWR VGND VPWR VGND sky130_ef_sc_hd__decap_12
X_2963_ _0649_ _0650_ VGND VGND VPWR VPWR _0651_ sky130_fd_sc_hd__nand2_1
XFILLER_34_277 VPWR VGND VPWR VGND sky130_ef_sc_hd__decap_12
XFILLER_148_625 VPWR VGND VPWR VGND sky130_ef_sc_hd__decap_12
X_1914_ B_reg\[14\] _1174_ _1176_ _1178_ VGND VGND VPWR VPWR _1179_ sky130_fd_sc_hd__a31o_1
XFILLER_147_113 VPWR VGND VPWR VGND sky130_ef_sc_hd__decap_12
X_2894_ _0570_ _0580_ VGND VGND VPWR VPWR _0582_ sky130_fd_sc_hd__xnor2_2
XFILLER_148_669 VPWR VGND VPWR VGND sky130_ef_sc_hd__decap_12
XFILLER_8_83 VGND VGND VPWR VPWR sky130_fd_sc_hd__fill_1
X_1845_ A_reg\[12\] _1114_ VGND VGND VPWR VPWR _1115_ sky130_fd_sc_hd__xor2_1
XTAP_TAPCELL_ROW_41_990 VGND VPWR sky130_fd_sc_hd__tapvpwrvgnd_1
XFILLER_118_29 VPWR VGND VPWR VGND sky130_ef_sc_hd__decap_12
X_1776_ _0891_ _1045_ _1041_ VGND VGND VPWR VPWR _1049_ sky130_fd_sc_hd__a21bo_1
XTAP_TAPCELL_ROW_116_2189 VGND VPWR sky130_fd_sc_hd__tapvpwrvgnd_1
XFILLER_116_533 VPWR VGND VPWR VGND sky130_ef_sc_hd__decap_12
XFILLER_131_503 VGND VGND VPWR VPWR sky130_fd_sc_hd__fill_1
XFILLER_103_205 VPWR VGND VPWR VGND sky130_ef_sc_hd__decap_12
XFILLER_143_385 VGND VGND VPWR VPWR sky130_fd_sc_hd__decap_6
XFILLER_103_249 VPWR VGND VPWR VGND sky130_ef_sc_hd__decap_12
XFILLER_97_461 VPWR VGND VPWR VGND sky130_ef_sc_hd__decap_12
XFILLER_69_141 VPWR VGND VPWR VGND sky130_ef_sc_hd__decap_12
XFILLER_85_612 VGND VGND VPWR VPWR sky130_fd_sc_hd__decap_4
XFILLER_69_185 VGND VGND VPWR VPWR sky130_fd_sc_hd__fill_1
X_2328_ _0901_ _1570_ _1579_ VGND VGND VPWR VPWR _1581_ sky130_fd_sc_hd__and3_1
XFILLER_111_293 VPWR VGND VPWR VGND sky130_ef_sc_hd__decap_12
XFILLER_27_15 VPWR VGND VPWR VGND sky130_ef_sc_hd__decap_12
XFILLER_150_27 VGND VGND VPWR VPWR sky130_fd_sc_hd__fill_1
XPHY_EDGE_ROW_108_Left_262 VGND VGND VPWR VPWR sky130_fd_sc_hd__decap_3
XFILLER_84_177 VGND VGND VPWR VPWR sky130_fd_sc_hd__fill_1
XFILLER_72_306 VGND VGND VPWR VPWR sky130_fd_sc_hd__fill_2
XFILLER_66_881 VPWR VGND VPWR VGND sky130_ef_sc_hd__decap_12
XTAP_TAPCELL_ROW_0_310 VGND VPWR sky130_fd_sc_hd__tapvpwrvgnd_1
XTAP_TAPCELL_ROW_0_321 VGND VPWR sky130_fd_sc_hd__tapvpwrvgnd_1
XFILLER_26_701 VPWR VGND VPWR VGND sky130_ef_sc_hd__decap_12
X_2259_ _1503_ _1507_ _1514_ _1515_ VGND VGND VPWR VPWR _1516_ sky130_fd_sc_hd__o2bb2a_1
XFILLER_65_380 VPWR VGND VPWR VGND sky130_ef_sc_hd__decap_12
XTAP_TAPCELL_ROW_0_332 VGND VPWR sky130_fd_sc_hd__tapvpwrvgnd_1
XFILLER_81_895 VGND VGND VPWR VPWR sky130_fd_sc_hd__fill_1
XFILLER_13_417 VPWR VGND VPWR VGND sky130_ef_sc_hd__decap_12
XFILLER_43_69 VPWR VGND VPWR VGND sky130_ef_sc_hd__decap_12
XTAP_TAPCELL_ROW_153_2802 VGND VPWR sky130_fd_sc_hd__tapvpwrvgnd_1
XFILLER_21_461 VPWR VGND VPWR VGND sky130_ef_sc_hd__decap_12
XFILLER_127_809 VPWR VGND VPWR VGND sky130_ef_sc_hd__decap_12
XPHY_EDGE_ROW_117_Left_271 VGND VGND VPWR VPWR sky130_fd_sc_hd__decap_3
XFILLER_135_853 VPWR VGND VPWR VGND sky130_ef_sc_hd__decap_12
XFILLER_119_393 VPWR VGND VPWR VGND sky130_ef_sc_hd__decap_12
XFILLER_104_3 VPWR VGND VPWR VGND sky130_ef_sc_hd__decap_12
XFILLER_135_897 VPWR VGND VPWR VGND sky130_ef_sc_hd__decap_12
XFILLER_134_363 VGND VGND VPWR VPWR sky130_fd_sc_hd__fill_1
XTAP_TAPCELL_ROW_56_1225 VGND VPWR sky130_fd_sc_hd__tapvpwrvgnd_1
XFILLER_150_867 VGND VGND VPWR VPWR sky130_fd_sc_hd__fill_1
XFILLER_122_525 VGND VGND VPWR VPWR sky130_fd_sc_hd__decap_6
XTAP_TAPCELL_ROW_8_454 VGND VPWR sky130_fd_sc_hd__tapvpwrvgnd_1
XFILLER_0_321 VPWR VGND VPWR VGND sky130_ef_sc_hd__decap_12
XFILLER_1_833 VGND VGND VPWR VPWR sky130_fd_sc_hd__decap_6
XFILLER_122_569 VPWR VGND VPWR VGND sky130_ef_sc_hd__decap_12
XTAP_TAPCELL_ROW_8_465 VGND VPWR sky130_fd_sc_hd__tapvpwrvgnd_1
XFILLER_1_877 VPWR VGND VPWR VGND sky130_ef_sc_hd__decap_12
XPHY_EDGE_ROW_126_Left_280 VGND VGND VPWR VPWR sky130_fd_sc_hd__decap_3
XFILLER_103_783 VGND VGND VPWR VPWR sky130_fd_sc_hd__fill_1
XFILLER_75_111 VGND VGND VPWR VPWR sky130_fd_sc_hd__fill_1
XFILLER_0_365 VPWR VGND VPWR VGND sky130_ef_sc_hd__decap_12
XFILLER_124_83 VGND VGND VPWR VPWR sky130_fd_sc_hd__fill_1
XANTENNA_input24_A B_in[1] VGND VGND VPWR VPWR sky130_fd_sc_hd__diode_2
XFILLER_76_667 VGND VGND VPWR VPWR sky130_fd_sc_hd__decap_8
XFILLER_91_615 VGND VGND VPWR VPWR sky130_fd_sc_hd__fill_1
XFILLER_84_43 VGND VGND VPWR VPWR sky130_fd_sc_hd__decap_6
XFILLER_63_306 VGND VGND VPWR VPWR sky130_fd_sc_hd__decap_3
XFILLER_16_233 VGND VGND VPWR VPWR sky130_fd_sc_hd__decap_4
XFILLER_71_361 VPWR VGND VPWR VGND sky130_ef_sc_hd__decap_12
XFILLER_17_81 VPWR VGND VPWR VGND sky130_ef_sc_hd__decap_12
XTAP_TAPCELL_ROW_27_762 VGND VPWR sky130_fd_sc_hd__tapvpwrvgnd_1
XTAP_TAPCELL_ROW_67_1398 VGND VPWR sky130_fd_sc_hd__tapvpwrvgnd_1
XFILLER_16_277 VPWR VGND VPWR VGND sky130_ef_sc_hd__decap_12
XFILLER_31_225 VPWR VGND VPWR VGND sky130_ef_sc_hd__decap_12
XFILLER_32_737 VPWR VGND VPWR VGND sky130_ef_sc_hd__decap_12
XFILLER_129_113 VPWR VGND VPWR VGND sky130_ef_sc_hd__decap_12
XFILLER_8_421 VGND VGND VPWR VPWR sky130_fd_sc_hd__decap_6
XFILLER_145_617 VPWR VGND VPWR VGND sky130_ef_sc_hd__decap_12
X_1630_ CU_state_dbg\[2\] _0884_ CU_state_dbg\[1\] VGND VGND VPWR VPWR _0910_ sky130_fd_sc_hd__or3b_4
XPHY_EDGE_ROW_144_Right_144 VGND VGND VPWR VPWR sky130_fd_sc_hd__decap_3
XANTENNA__3184__A1 CRT_Start VGND VGND VPWR VPWR sky130_fd_sc_hd__diode_2
XFILLER_113_503 VGND VGND VPWR VPWR sky130_fd_sc_hd__fill_1
X_3300_ clknet_3_2__leaf_clk _0083_ net36 VGND VGND VPWR VPWR B_reg\[10\] sky130_fd_sc_hd__dfrtp_4
XANTENNA__1734__A2 A_reg\[13\] VGND VGND VPWR VPWR sky130_fd_sc_hd__diode_2
XFILLER_140_333 VPWR VGND VPWR VGND sky130_ef_sc_hd__decap_12
XFILLER_125_385 VGND VGND VPWR VPWR sky130_fd_sc_hd__decap_6
XFILLER_3_181 VPWR VGND VPWR VGND sky130_ef_sc_hd__decap_12
XFILLER_141_889 VGND VGND VPWR VPWR sky130_fd_sc_hd__decap_6
XFILLER_101_709 VPWR VGND VPWR VGND sky130_ef_sc_hd__decap_12
X_3231_ clknet_3_2__leaf_clk _0018_ net36 VGND VGND VPWR VPWR b_r0\[1\] sky130_fd_sc_hd__dfrtp_2
XFILLER_79_461 VPWR VGND VPWR VGND sky130_ef_sc_hd__decap_12
XFILLER_140_377 VPWR VGND VPWR VGND sky130_ef_sc_hd__decap_12
X_3162_ _0817_ _0849_ VGND VGND VPWR VPWR _0850_ sky130_fd_sc_hd__xnor2_1
XTAP_TAPCELL_ROW_87_1719 VGND VPWR sky130_fd_sc_hd__tapvpwrvgnd_1
X_2113_ B_reg\[9\] _1369_ _1371_ VGND VGND VPWR VPWR _1372_ sky130_fd_sc_hd__o21a_1
XFILLER_67_645 VPWR VGND VPWR VGND sky130_ef_sc_hd__decap_12
XFILLER_66_177 VGND VGND VPWR VPWR sky130_fd_sc_hd__decap_4
X_3093_ _0680_ _0697_ _0763_ VGND VGND VPWR VPWR _0781_ sky130_fd_sc_hd__and3_1
XFILLER_54_306 VGND VGND VPWR VPWR sky130_fd_sc_hd__fill_2
X_2044_ _1301_ _1302_ _1304_ VGND VGND VPWR VPWR _1306_ sky130_fd_sc_hd__a21oi_1
XFILLER_81_147 VGND VGND VPWR VPWR sky130_fd_sc_hd__decap_6
XFILLER_81_125 VPWR VGND VPWR VGND sky130_ef_sc_hd__decap_12
XFILLER_54_339 VPWR VGND VPWR VGND sky130_ef_sc_hd__decap_12
XFILLER_50_501 VPWR VGND VPWR VGND sky130_ef_sc_hd__decap_12
XANTENNA__2834__S _0383_ VGND VGND VPWR VPWR sky130_fd_sc_hd__diode_2
XFILLER_90_681 VPWR VGND VPWR VGND sky130_ef_sc_hd__decap_12
XFILLER_63_895 VGND VGND VPWR VPWR sky130_fd_sc_hd__fill_1
XANTENNA__3305__CLK clknet_3_0__leaf_clk VGND VGND VPWR VPWR sky130_fd_sc_hd__diode_2
XFILLER_50_545 VPWR VGND VPWR VGND sky130_ef_sc_hd__decap_12
XFILLER_148_433 VPWR VGND VPWR VGND sky130_ef_sc_hd__decap_12
XTAP_TAPCELL_ROW_118_2218 VGND VPWR sky130_fd_sc_hd__tapvpwrvgnd_1
X_2946_ _0564_ _0632_ VGND VGND VPWR VPWR _0634_ sky130_fd_sc_hd__nand2_1
XFILLER_50_589 VPWR VGND VPWR VGND sky130_ef_sc_hd__decap_12
XFILLER_50_578 VGND VGND VPWR VPWR sky130_fd_sc_hd__decap_8
XFILLER_13_39 VPWR VGND VPWR VGND sky130_ef_sc_hd__decap_12
XFILLER_22_269 VPWR VGND VPWR VGND sky130_ef_sc_hd__decap_12
XFILLER_129_39 VPWR VGND VPWR VGND sky130_ef_sc_hd__decap_12
XFILLER_109_809 VPWR VGND VPWR VGND sky130_ef_sc_hd__decap_12
X_2877_ u_crt.r3\[1\] u_crt.r3\[0\] u_crt.r3\[3\] VGND VGND VPWR VPWR _0565_ sky130_fd_sc_hd__a21bo_1
XFILLER_148_477 VPWR VGND VPWR VGND sky130_ef_sc_hd__decap_12
XFILLER_135_105 VGND VGND VPWR VPWR sky130_fd_sc_hd__decap_6
X_1828_ A_reg\[1\] _1099_ VGND VGND VPWR VPWR _1101_ sky130_fd_sc_hd__xnor2_1
XFILLER_151_609 VGND VGND VPWR VPWR sky130_fd_sc_hd__decap_6
XFILLER_135_149 VPWR VGND VPWR VGND sky130_ef_sc_hd__decap_12
XTAP_TAPCELL_ROW_131_2429 VGND VPWR sky130_fd_sc_hd__tapvpwrvgnd_1
XFILLER_117_853 VPWR VGND VPWR VGND sky130_ef_sc_hd__decap_12
XPHY_EDGE_ROW_111_Right_111 VGND VGND VPWR VPWR sky130_fd_sc_hd__decap_3
XFILLER_145_27 VPWR VGND VPWR VGND sky130_ef_sc_hd__decap_12
XFILLER_117_897 VPWR VGND VPWR VGND sky130_ef_sc_hd__decap_12
XFILLER_116_363 VGND VGND VPWR VPWR sky130_fd_sc_hd__fill_1
X_1759_ _1021_ _1023_ _1026_ VGND VGND VPWR VPWR _1032_ sky130_fd_sc_hd__a21oi_1
XFILLER_143_193 VPWR VGND VPWR VGND sky130_ef_sc_hd__decap_12
XFILLER_132_867 VGND VGND VPWR VPWR sky130_fd_sc_hd__fill_1
XFILLER_104_569 VPWR VGND VPWR VGND sky130_ef_sc_hd__decap_12
XTAP_TAPCELL_ROW_5_413 VGND VPWR sky130_fd_sc_hd__tapvpwrvgnd_1
XFILLER_98_781 VPWR VGND VPWR VGND sky130_ef_sc_hd__decap_12
XANTENNA__3268__RESET_B net36 VGND VGND VPWR VPWR sky130_fd_sc_hd__diode_2
XFILLER_57_111 VGND VGND VPWR VPWR sky130_fd_sc_hd__fill_1
XTAP_TAPCELL_ROW_51_1144 VGND VPWR sky130_fd_sc_hd__tapvpwrvgnd_1
XTAP_TAPCELL_ROW_146_2661 VGND VPWR sky130_fd_sc_hd__tapvpwrvgnd_1
XANTENNA__2150__A2 _0911_ VGND VGND VPWR VPWR sky130_fd_sc_hd__diode_2
XTAP_TAPCELL_ROW_51_1155 VGND VPWR sky130_fd_sc_hd__tapvpwrvgnd_1
XTAP_TAPCELL_ROW_146_2672 VGND VPWR sky130_fd_sc_hd__tapvpwrvgnd_1
XFILLER_73_615 VGND VGND VPWR VPWR sky130_fd_sc_hd__fill_1
XFILLER_39_870 VPWR VGND VPWR VGND sky130_ef_sc_hd__decap_12
XFILLER_45_317 VPWR VGND VPWR VGND sky130_ef_sc_hd__decap_12
XFILLER_85_497 VGND VGND VPWR VPWR sky130_fd_sc_hd__decap_6
XFILLER_26_531 VGND VGND VPWR VPWR sky130_fd_sc_hd__fill_1
XFILLER_54_851 VGND VGND VPWR VPWR sky130_fd_sc_hd__fill_1
XFILLER_53_361 VPWR VGND VPWR VGND sky130_ef_sc_hd__decap_12
XFILLER_13_225 VPWR VGND VPWR VGND sky130_ef_sc_hd__decap_12
XFILLER_14_737 VPWR VGND VPWR VGND sky130_ef_sc_hd__decap_12
XTAP_TAPCELL_ROW_24_710 VGND VPWR sky130_fd_sc_hd__tapvpwrvgnd_1
XTAP_TAPCELL_ROW_24_721 VGND VPWR sky130_fd_sc_hd__tapvpwrvgnd_1
XFILLER_110_41 VPWR VGND VPWR VGND sky130_ef_sc_hd__decap_12
XFILLER_13_247 VGND VGND VPWR VPWR sky130_fd_sc_hd__decap_4
XFILLER_13_258 VPWR VGND VPWR VGND sky130_ef_sc_hd__decap_12
XFILLER_110_85 VPWR VGND VPWR VGND sky130_ef_sc_hd__decap_12
XFILLER_22_781 VPWR VGND VPWR VGND sky130_ef_sc_hd__decap_12
XFILLER_127_617 VPWR VGND VPWR VGND sky130_ef_sc_hd__decap_12
XFILLER_79_32 VPWR VGND VPWR VGND sky130_ef_sc_hd__decap_12
XFILLER_122_333 VPWR VGND VPWR VGND sky130_ef_sc_hd__decap_12
XFILLER_123_889 VGND VGND VPWR VPWR sky130_fd_sc_hd__decap_6
XFILLER_1_641 VPWR VGND VPWR VGND sky130_ef_sc_hd__decap_12
XFILLER_122_377 VPWR VGND VPWR VGND sky130_ef_sc_hd__decap_12
XFILLER_49_634 VPWR VGND VPWR VGND sky130_ef_sc_hd__decap_12
XFILLER_1_685 VPWR VGND VPWR VGND sky130_ef_sc_hd__decap_12
XFILLER_135_93 VPWR VGND VPWR VGND sky130_ef_sc_hd__decap_12
XFILLER_95_75 VPWR VGND VPWR VGND sky130_ef_sc_hd__decap_12
XFILLER_48_133 VGND VGND VPWR VPWR sky130_fd_sc_hd__decap_6
XFILLER_76_475 VGND VGND VPWR VPWR sky130_fd_sc_hd__fill_1
XFILLER_48_177 VPWR VGND VPWR VGND sky130_ef_sc_hd__decap_12
XTAP_TAPCELL_ROW_69_1438 VGND VPWR sky130_fd_sc_hd__tapvpwrvgnd_1
XFILLER_64_637 VGND VGND VPWR VPWR sky130_fd_sc_hd__decap_6
XFILLER_63_125 VGND VGND VPWR VPWR sky130_fd_sc_hd__decap_8
XFILLER_29_391 VGND VGND VPWR VPWR sky130_fd_sc_hd__fill_1
XFILLER_151_81 VPWR VGND VPWR VGND sky130_ef_sc_hd__decap_12
XFILLER_63_169 VPWR VGND VPWR VGND sky130_ef_sc_hd__decap_12
XFILLER_17_553 VGND VGND VPWR VPWR sky130_fd_sc_hd__decap_6
XTAP_TAPCELL_ROW_82_1649 VGND VPWR sky130_fd_sc_hd__tapvpwrvgnd_1
XTAP_TAPCELL_ROW_82_1638 VGND VPWR sky130_fd_sc_hd__tapvpwrvgnd_1
XFILLER_72_681 VPWR VGND VPWR VGND sky130_ef_sc_hd__decap_12
XFILLER_17_597 VPWR VGND VPWR VGND sky130_ef_sc_hd__decap_12
XFILLER_32_501 VGND VGND VPWR VPWR sky130_fd_sc_hd__fill_2
X_2800_ _0535_ _0536_ _0539_ VGND VGND VPWR VPWR _0540_ sky130_fd_sc_hd__o21ai_1
XFILLER_32_589 VPWR VGND VPWR VGND sky130_ef_sc_hd__decap_12
X_2731_ _0469_ _0463_ b_r3\[2\] a_r3\[1\] VGND VGND VPWR VPWR _0471_ sky130_fd_sc_hd__or4bb_1
XFILLER_9_741 VPWR VGND VPWR VGND sky130_ef_sc_hd__decap_12
XFILLER_117_105 VGND VGND VPWR VPWR sky130_fd_sc_hd__decap_6
XFILLER_9_785 VPWR VGND VPWR VGND sky130_ef_sc_hd__decap_12
XFILLER_8_251 VGND VGND VPWR VPWR sky130_fd_sc_hd__fill_1
XFILLER_12_291 VPWR VGND VPWR VGND sky130_ef_sc_hd__decap_12
XANTENNA__1794__A A_reg\[6\] VGND VGND VPWR VPWR sky130_fd_sc_hd__diode_2
XFILLER_145_447 VGND VGND VPWR VPWR sky130_fd_sc_hd__fill_1
XFILLER_133_609 VGND VGND VPWR VPWR sky130_fd_sc_hd__decap_6
XFILLER_117_149 VPWR VGND VPWR VGND sky130_ef_sc_hd__decap_12
X_2662_ _0392_ _0401_ b_r3\[1\] VGND VGND VPWR VPWR _0402_ sky130_fd_sc_hd__a21oi_1
XTAP_TAPCELL_ROW_113_2137 VGND VPWR sky130_fd_sc_hd__tapvpwrvgnd_1
XTAP_TAPCELL_ROW_97_1881 VGND VPWR sky130_fd_sc_hd__tapvpwrvgnd_1
X_2593_ _0328_ _0337_ VGND VGND VPWR VPWR _0338_ sky130_fd_sc_hd__nand2_1
XTAP_TAPCELL_ROW_10_492 VGND VPWR sky130_fd_sc_hd__tapvpwrvgnd_1
X_1613_ A_reg\[6\] VGND VGND VPWR VPWR _0893_ sky130_fd_sc_hd__inv_2
XFILLER_5_51 VGND VGND VPWR VPWR sky130_fd_sc_hd__decap_4
XFILLER_141_653 VPWR VGND VPWR VGND sky130_ef_sc_hd__decap_12
XFILLER_140_141 VPWR VGND VPWR VGND sky130_ef_sc_hd__decap_12
XFILLER_125_193 VPWR VGND VPWR VGND sky130_ef_sc_hd__decap_12
XFILLER_114_867 VGND VGND VPWR VPWR sky130_fd_sc_hd__fill_1
XFILLER_87_729 VPWR VGND VPWR VGND sky130_ef_sc_hd__decap_12
XANTENNA__2829__S _0553_ VGND VGND VPWR VPWR sky130_fd_sc_hd__diode_2
XFILLER_141_697 VPWR VGND VPWR VGND sky130_ef_sc_hd__decap_12
XFILLER_101_517 VPWR VGND VPWR VGND sky130_ef_sc_hd__decap_12
X_3214_ clknet_3_3__leaf_clk _0002_ net36 VGND VGND VPWR VPWR a_r2\[2\] sky130_fd_sc_hd__dfrtp_2
XFILLER_39_111 VGND VGND VPWR VPWR sky130_fd_sc_hd__fill_1
XTAP_TAPCELL_ROW_128_2380 VGND VPWR sky130_fd_sc_hd__tapvpwrvgnd_1
X_3145_ _0805_ _0827_ VGND VGND VPWR VPWR _0833_ sky130_fd_sc_hd__nand2_1
XFILLER_67_497 VGND VGND VPWR VPWR sky130_fd_sc_hd__decap_6
X_3076_ _0697_ _0763_ _0680_ VGND VGND VPWR VPWR _0764_ sky130_fd_sc_hd__a21oi_1
XFILLER_82_467 VGND VGND VPWR VPWR sky130_fd_sc_hd__decap_8
X_2027_ _1288_ _1280_ _1275_ VGND VGND VPWR VPWR _1289_ sky130_fd_sc_hd__mux2_1
XTAP_TAPCELL_ROW_141_2591 VGND VPWR sky130_fd_sc_hd__tapvpwrvgnd_1
XTAP_TAPCELL_ROW_141_2580 VGND VPWR sky130_fd_sc_hd__tapvpwrvgnd_1
XFILLER_51_865 VPWR VGND VPWR VGND sky130_ef_sc_hd__decap_12
XFILLER_24_27 VGND VGND VPWR VPWR sky130_fd_sc_hd__fill_1
XFILLER_11_729 VPWR VGND VPWR VGND sky130_ef_sc_hd__decap_12
XFILLER_149_753 VPWR VGND VPWR VGND sky130_ef_sc_hd__decap_12
X_2929_ _0613_ _0614_ VGND VGND VPWR VPWR _0617_ sky130_fd_sc_hd__xor2_1
XFILLER_149_797 VPWR VGND VPWR VGND sky130_ef_sc_hd__decap_12
XFILLER_109_617 VPWR VGND VPWR VGND sky130_ef_sc_hd__decap_12
XFILLER_40_15 VPWR VGND VPWR VGND sky130_ef_sc_hd__decap_12
XFILLER_151_417 VPWR VGND VPWR VGND sky130_ef_sc_hd__decap_12
XFILLER_136_469 VGND VGND VPWR VPWR sky130_fd_sc_hd__decap_6
XTAP_TAPCELL_ROW_148_2701 VGND VPWR sky130_fd_sc_hd__tapvpwrvgnd_1
XFILLER_105_889 VGND VGND VPWR VPWR sky130_fd_sc_hd__decap_6
XFILLER_104_333 VPWR VGND VPWR VGND sky130_ef_sc_hd__decap_12
XFILLER_120_837 VPWR VGND VPWR VGND sky130_ef_sc_hd__decap_12
XFILLER_104_399 VPWR VGND VPWR VGND sky130_ef_sc_hd__decap_12
XFILLER_77_217 VGND VGND VPWR VPWR sky130_fd_sc_hd__decap_6
XFILLER_49_57 VPWR VGND VPWR VGND sky130_ef_sc_hd__decap_12
XFILLER_92_209 VPWR VGND VPWR VGND sky130_ef_sc_hd__decap_12
XTAP_TAPCELL_ROW_29_802 VGND VPWR sky130_fd_sc_hd__tapvpwrvgnd_1
XFILLER_45_125 VPWR VGND VPWR VGND sky130_ef_sc_hd__decap_12
XFILLER_45_169 VPWR VGND VPWR VGND sky130_ef_sc_hd__decap_12
XFILLER_121_51 VGND VGND VPWR VPWR sky130_fd_sc_hd__decap_4
XFILLER_61_629 VPWR VGND VPWR VGND sky130_ef_sc_hd__decap_12
XFILLER_14_501 VPWR VGND VPWR VGND sky130_ef_sc_hd__decap_12
XFILLER_26_383 VGND VGND VPWR VPWR sky130_fd_sc_hd__fill_1
XFILLER_27_895 VGND VGND VPWR VPWR sky130_fd_sc_hd__fill_1
XTAP_TAPCELL_ROW_64_1357 VGND VPWR sky130_fd_sc_hd__tapvpwrvgnd_1
XFILLER_60_139 VGND VGND VPWR VPWR sky130_fd_sc_hd__fill_1
XFILLER_14_545 VPWR VGND VPWR VGND sky130_ef_sc_hd__decap_12
XFILLER_81_55 VGND VGND VPWR VPWR sky130_fd_sc_hd__fill_1
XFILLER_14_589 VPWR VGND VPWR VGND sky130_ef_sc_hd__decap_12
XFILLER_127_447 VGND VGND VPWR VPWR sky130_fd_sc_hd__fill_1
XANTENNA__2503__A b_r1\[0\] VGND VGND VPWR VPWR sky130_fd_sc_hd__diode_2
XFILLER_115_609 VGND VGND VPWR VPWR sky130_fd_sc_hd__decap_6
XFILLER_6_755 VGND VGND VPWR VPWR sky130_fd_sc_hd__fill_1
XFILLER_5_265 VPWR VGND VPWR VGND sky130_ef_sc_hd__decap_12
XFILLER_123_653 VPWR VGND VPWR VGND sky130_ef_sc_hd__decap_12
XFILLER_122_141 VPWR VGND VPWR VGND sky130_ef_sc_hd__decap_12
XFILLER_107_193 VPWR VGND VPWR VGND sky130_ef_sc_hd__decap_12
XFILLER_46_8 VPWR VGND VPWR VGND sky130_ef_sc_hd__decap_12
XFILLER_123_697 VPWR VGND VPWR VGND sky130_ef_sc_hd__decap_12
XFILLER_69_729 VPWR VGND VPWR VGND sky130_ef_sc_hd__decap_12
Xinput8 A_in[1] VGND VGND VPWR VPWR net8 sky130_fd_sc_hd__buf_1
XFILLER_64_401 VPWR VGND VPWR VGND sky130_ef_sc_hd__decap_12
XFILLER_37_615 VGND VGND VPWR VPWR sky130_fd_sc_hd__fill_1
XFILLER_49_497 VGND VGND VPWR VPWR sky130_fd_sc_hd__decap_6
XFILLER_80_905 VGND VGND VPWR VPWR sky130_fd_sc_hd__decap_4
XFILLER_24_309 VPWR VGND VPWR VGND sky130_ef_sc_hd__decap_12
XFILLER_17_361 VPWR VGND VPWR VGND sky130_ef_sc_hd__decap_12
XTAP_TAPCELL_ROW_99_1921 VGND VPWR sky130_fd_sc_hd__tapvpwrvgnd_1
XTAP_TAPCELL_ROW_99_1910 VGND VPWR sky130_fd_sc_hd__tapvpwrvgnd_1
XTAP_TAPCELL_ROW_15_573 VGND VPWR sky130_fd_sc_hd__tapvpwrvgnd_1
XFILLER_146_701 VPWR VGND VPWR VGND sky130_ef_sc_hd__decap_12
X_2714_ a_r3\[3\] b_r3\[3\] VGND VGND VPWR VPWR _0454_ sky130_fd_sc_hd__or2_1
XFILLER_133_417 VPWR VGND VPWR VGND sky130_ef_sc_hd__decap_12
XFILLER_118_469 VGND VGND VPWR VPWR sky130_fd_sc_hd__decap_6
X_2645_ b_r3\[0\] a_r3\[0\] VGND VGND VPWR VPWR _0385_ sky130_fd_sc_hd__nand2_1
XFILLER_10_29 VPWR VGND VPWR VGND sky130_ef_sc_hd__decap_12
XFILLER_126_29 VPWR VGND VPWR VGND sky130_ef_sc_hd__decap_12
X_2576_ _0319_ _0320_ VGND VGND VPWR VPWR _0321_ sky130_fd_sc_hd__and2_1
XFILLER_0_909 VGND VGND VPWR VPWR sky130_fd_sc_hd__fill_1
XFILLER_141_461 VPWR VGND VPWR VGND sky130_ef_sc_hd__decap_12
XFILLER_102_837 VPWR VGND VPWR VGND sky130_ef_sc_hd__decap_12
XFILLER_87_559 VGND VGND VPWR VPWR sky130_fd_sc_hd__fill_1
XFILLER_19_27 VPWR VGND VPWR VGND sky130_ef_sc_hd__decap_12
XFILLER_74_209 VPWR VGND VPWR VGND sky130_ef_sc_hd__decap_12
XFILLER_67_261 VPWR VGND VPWR VGND sky130_ef_sc_hd__decap_12
XTAP_TAPCELL_ROW_143_2620 VGND VPWR sky130_fd_sc_hd__tapvpwrvgnd_1
XFILLER_110_881 VPWR VGND VPWR VGND sky130_ef_sc_hd__decap_12
XFILLER_83_721 VGND VGND VPWR VPWR sky130_fd_sc_hd__decap_6
X_3128_ _0795_ _0799_ _0784_ VGND VGND VPWR VPWR _0816_ sky130_fd_sc_hd__o21a_1
XFILLER_27_125 VPWR VGND VPWR VGND sky130_ef_sc_hd__decap_12
XANTENNA__1864__A1 A_reg\[7\] VGND VGND VPWR VPWR sky130_fd_sc_hd__diode_2
XFILLER_28_637 VGND VGND VPWR VPWR sky130_fd_sc_hd__decap_6
XFILLER_83_765 VPWR VGND VPWR VGND sky130_ef_sc_hd__decap_12
XFILLER_82_253 VPWR VGND VPWR VGND sky130_ef_sc_hd__decap_12
XFILLER_35_15 VPWR VGND VPWR VGND sky130_ef_sc_hd__decap_12
X_3059_ _0744_ _0746_ VGND VGND VPWR VPWR _0747_ sky130_fd_sc_hd__or2_1
XFILLER_27_169 VPWR VGND VPWR VGND sky130_ef_sc_hd__decap_12
XFILLER_36_681 VPWR VGND VPWR VGND sky130_ef_sc_hd__decap_12
XFILLER_43_629 VGND VGND VPWR VPWR sky130_fd_sc_hd__decap_4
XANTENNA__2813__B1 _0184_ VGND VGND VPWR VPWR sky130_fd_sc_hd__diode_2
XFILLER_42_139 VGND VGND VPWR VPWR sky130_fd_sc_hd__fill_1
XFILLER_23_375 VPWR VGND VPWR VGND sky130_ef_sc_hd__decap_12
XTAP_TAPCELL_ROW_34_871 VGND VPWR sky130_fd_sc_hd__tapvpwrvgnd_1
XTAP_TAPCELL_ROW_46_1065 VGND VPWR sky130_fd_sc_hd__tapvpwrvgnd_1
XTAP_TAPCELL_ROW_34_882 VGND VPWR sky130_fd_sc_hd__tapvpwrvgnd_1
XFILLER_149_561 VPWR VGND VPWR VGND sky130_ef_sc_hd__decap_12
XFILLER_11_559 VGND VGND VPWR VPWR sky130_fd_sc_hd__fill_1
XFILLER_136_233 VPWR VGND VPWR VGND sky130_ef_sc_hd__decap_12
XFILLER_109_425 VGND VGND VPWR VPWR sky130_fd_sc_hd__fill_2
XFILLER_109_469 VGND VGND VPWR VPWR sky130_fd_sc_hd__fill_1
XFILLER_152_737 VPWR VGND VPWR VGND sky130_ef_sc_hd__decap_12
XFILLER_151_225 VPWR VGND VPWR VGND sky130_ef_sc_hd__decap_12
XFILLER_136_277 VPWR VGND VPWR VGND sky130_ef_sc_hd__decap_12
XANTENNA__3283__RESET_B net36 VGND VGND VPWR VPWR sky130_fd_sc_hd__diode_2
XFILLER_105_653 VPWR VGND VPWR VGND sky130_ef_sc_hd__decap_12
XFILLER_120_601 VPWR VGND VPWR VGND sky130_ef_sc_hd__decap_12
XFILLER_105_697 VPWR VGND VPWR VGND sky130_ef_sc_hd__decap_12
XFILLER_104_141 VPWR VGND VPWR VGND sky130_ef_sc_hd__decap_12
XANTENNA__3212__RESET_B net36 VGND VGND VPWR VPWR sky130_fd_sc_hd__diode_2
XFILLER_120_645 VPWR VGND VPWR VGND sky130_ef_sc_hd__decap_12
XFILLER_76_33 VGND VGND VPWR VPWR sky130_fd_sc_hd__decap_4
XFILLER_59_751 VGND VGND VPWR VPWR sky130_fd_sc_hd__fill_2
XFILLER_19_615 VGND VGND VPWR VPWR sky130_fd_sc_hd__fill_1
XFILLER_86_581 VGND VGND VPWR VPWR sky130_fd_sc_hd__decap_6
XFILLER_74_710 VPWR VGND VPWR VGND sky130_ef_sc_hd__decap_12
XFILLER_58_261 VGND VGND VPWR VPWR sky130_fd_sc_hd__decap_3
XFILLER_46_401 VPWR VGND VPWR VGND sky130_ef_sc_hd__decap_12
XFILLER_74_754 VGND VGND VPWR VPWR sky130_fd_sc_hd__fill_2
XFILLER_132_83 VGND VGND VPWR VPWR sky130_fd_sc_hd__fill_1
XFILLER_61_426 VPWR VGND VPWR VGND sky130_ef_sc_hd__decap_12
XFILLER_15_821 VPWR VGND VPWR VGND sky130_ef_sc_hd__decap_12
XFILLER_92_65 VPWR VGND VPWR VGND sky130_ef_sc_hd__decap_12
XFILLER_15_865 VPWR VGND VPWR VGND sky130_ef_sc_hd__decap_12
XFILLER_25_81 VPWR VGND VPWR VGND sky130_ef_sc_hd__decap_12
XTAP_TAPCELL_ROW_12_521 VGND VPWR sky130_fd_sc_hd__tapvpwrvgnd_1
XFILLER_30_824 VPWR VGND VPWR VGND sky130_ef_sc_hd__decap_12
XFILLER_41_161 VGND VGND VPWR VPWR sky130_fd_sc_hd__decap_6
XFILLER_128_701 VPWR VGND VPWR VGND sky130_ef_sc_hd__decap_12
XFILLER_10_581 VGND VGND VPWR VPWR sky130_fd_sc_hd__decap_6
XFILLER_115_417 VPWR VGND VPWR VGND sky130_ef_sc_hd__decap_12
XTAP_TAPCELL_ROW_94_1840 VGND VPWR sky130_fd_sc_hd__tapvpwrvgnd_1
X_2430_ b_r3\[2\] _0181_ Encode_EN VGND VGND VPWR VPWR _0025_ sky130_fd_sc_hd__mux2_1
XTAP_TAPCELL_ROW_77_1559 VGND VPWR sky130_fd_sc_hd__tapvpwrvgnd_1
XFILLER_123_461 VPWR VGND VPWR VGND sky130_ef_sc_hd__decap_12
X_2361_ _0105_ _0114_ VGND VGND VPWR VPWR _0115_ sky130_fd_sc_hd__xnor2_1
X_2292_ a_r3\[2\] _1546_ Encode_EN VGND VGND VPWR VPWR _0021_ sky130_fd_sc_hd__mux2_1
XFILLER_69_559 VGND VGND VPWR VPWR sky130_fd_sc_hd__fill_1
XFILLER_110_133 VGND VGND VPWR VPWR sky130_fd_sc_hd__decap_6
XFILLER_96_389 VPWR VGND VPWR VGND sky130_ef_sc_hd__decap_12
XFILLER_56_209 VPWR VGND VPWR VGND sky130_ef_sc_hd__decap_12
XFILLER_2_41 VPWR VGND VPWR VGND sky130_ef_sc_hd__decap_12
XFILLER_110_177 VPWR VGND VPWR VGND sky130_ef_sc_hd__decap_12
XTAP_TAPCELL_ROW_108_2058 VGND VPWR sky130_fd_sc_hd__tapvpwrvgnd_1
XFILLER_49_261 VPWR VGND VPWR VGND sky130_ef_sc_hd__decap_12
XFILLER_2_85 VPWR VGND VPWR VGND sky130_ef_sc_hd__decap_12
XFILLER_65_765 VGND VGND VPWR VPWR sky130_fd_sc_hd__decap_6
XFILLER_37_445 VGND VGND VPWR VPWR sky130_fd_sc_hd__decap_3
XFILLER_92_562 VGND VGND VPWR VPWR sky130_fd_sc_hd__fill_1
XFILLER_80_713 VGND VGND VPWR VPWR sky130_fd_sc_hd__fill_2
XFILLER_64_253 VPWR VGND VPWR VGND sky130_ef_sc_hd__decap_12
XFILLER_18_681 VPWR VGND VPWR VGND sky130_ef_sc_hd__decap_12
XFILLER_25_629 VPWR VGND VPWR VGND sky130_ef_sc_hd__decap_12
XTAP_TAPCELL_ROW_121_2269 VGND VPWR sky130_fd_sc_hd__tapvpwrvgnd_1
XFILLER_80_757 VPWR VGND VPWR VGND sky130_ef_sc_hd__decap_12
XFILLER_24_139 VGND VGND VPWR VPWR sky130_fd_sc_hd__fill_1
XANTENNA__2842__S _0383_ VGND VGND VPWR VPWR sky130_fd_sc_hd__diode_2
XFILLER_33_673 VPWR VGND VPWR VGND sky130_ef_sc_hd__decap_12
XTAP_TAPCELL_ROW_103_1980 VGND VPWR sky130_fd_sc_hd__tapvpwrvgnd_1
XTAP_TAPCELL_ROW_31_830 VGND VPWR sky130_fd_sc_hd__tapvpwrvgnd_1
XFILLER_146_531 VGND VGND VPWR VPWR sky130_fd_sc_hd__fill_1
XFILLER_20_389 VPWR VGND VPWR VGND sky130_ef_sc_hd__decap_12
XFILLER_118_233 VPWR VGND VPWR VGND sky130_ef_sc_hd__decap_12
XFILLER_21_39 VPWR VGND VPWR VGND sky130_ef_sc_hd__decap_12
XFILLER_137_39 VPWR VGND VPWR VGND sky130_ef_sc_hd__decap_12
XFILLER_134_737 VPWR VGND VPWR VGND sky130_ef_sc_hd__decap_12
XFILLER_133_225 VPWR VGND VPWR VGND sky130_ef_sc_hd__decap_12
XFILLER_118_277 VPWR VGND VPWR VGND sky130_ef_sc_hd__decap_12
X_2628_ _0368_ _0371_ VGND VGND VPWR VPWR _0373_ sky130_fd_sc_hd__or2_1
XFILLER_142_781 VPWR VGND VPWR VGND sky130_ef_sc_hd__decap_12
XFILLER_102_601 VPWR VGND VPWR VGND sky130_ef_sc_hd__decap_12
XFILLER_99_161 VGND VGND VPWR VPWR sky130_fd_sc_hd__decap_6
XFILLER_88_813 VPWR VGND VPWR VGND sky130_ef_sc_hd__decap_12
XANTENNA__2289__S Encode_EN VGND VGND VPWR VPWR sky130_fd_sc_hd__diode_2
X_2559_ _0296_ _0304_ _0234_ VGND VGND VPWR VPWR _0305_ sky130_fd_sc_hd__a21bo_1
XFILLER_153_27 VGND VGND VPWR VPWR sky130_fd_sc_hd__fill_1
XFILLER_102_645 VPWR VGND VPWR VGND sky130_ef_sc_hd__decap_12
XFILLER_101_111 VGND VGND VPWR VPWR sky130_fd_sc_hd__fill_1
XFILLER_75_529 VPWR VGND VPWR VGND sky130_ef_sc_hd__decap_12
XFILLER_68_581 VGND VGND VPWR VPWR sky130_fd_sc_hd__decap_6
XTAP_TAPCELL_ROW_39_952 VGND VPWR sky130_fd_sc_hd__tapvpwrvgnd_1
XTAP_TAPCELL_ROW_39_963 VGND VPWR sky130_fd_sc_hd__tapvpwrvgnd_1
XFILLER_44_905 VGND VGND VPWR VPWR sky130_fd_sc_hd__fill_2
XFILLER_83_573 VPWR VGND VPWR VGND sky130_ef_sc_hd__decap_12
XFILLER_70_201 VPWR VGND VPWR VGND sky130_ef_sc_hd__decap_12
XTAP_TAPCELL_ROW_48_1105 VGND VPWR sky130_fd_sc_hd__tapvpwrvgnd_1
XFILLER_28_489 VPWR VGND VPWR VGND sky130_ef_sc_hd__decap_12
XFILLER_102_53 VPWR VGND VPWR VGND sky130_ef_sc_hd__decap_12
XFILLER_102_97 VPWR VGND VPWR VGND sky130_ef_sc_hd__decap_12
XTAP_TAPCELL_ROW_61_1305 VGND VPWR sky130_fd_sc_hd__tapvpwrvgnd_1
XFILLER_12_813 VPWR VGND VPWR VGND sky130_ef_sc_hd__decap_12
XFILLER_30_109 VPWR VGND VPWR VGND sky130_ef_sc_hd__decap_12
XFILLER_11_301 VPWR VGND VPWR VGND sky130_ef_sc_hd__decap_12
XFILLER_23_161 VGND VGND VPWR VPWR sky130_fd_sc_hd__decap_6
XFILLER_134_3 VPWR VGND VPWR VGND sky130_ef_sc_hd__decap_12
XFILLER_7_305 VPWR VGND VPWR VGND sky130_ef_sc_hd__decap_12
XFILLER_149_391 VGND VGND VPWR VPWR sky130_fd_sc_hd__fill_1
XFILLER_137_553 VGND VGND VPWR VPWR sky130_fd_sc_hd__decap_6
XFILLER_7_349 VGND VGND VPWR VPWR sky130_fd_sc_hd__decap_4
XFILLER_152_501 VPWR VGND VPWR VGND sky130_ef_sc_hd__decap_12
XFILLER_137_597 VPWR VGND VPWR VGND sky130_ef_sc_hd__decap_12
XFILLER_152_545 VPWR VGND VPWR VGND sky130_ef_sc_hd__decap_12
XTAP_TAPCELL_ROW_59_1278 VGND VPWR sky130_fd_sc_hd__tapvpwrvgnd_1
XFILLER_3_555 VGND VGND VPWR VPWR sky130_fd_sc_hd__decap_4
XFILLER_152_589 VPWR VGND VPWR VGND sky130_ef_sc_hd__decap_12
XFILLER_105_461 VPWR VGND VPWR VGND sky130_ef_sc_hd__decap_12
XFILLER_87_65 VPWR VGND VPWR VGND sky130_ef_sc_hd__decap_12
XFILLER_87_54 VGND VGND VPWR VPWR sky130_fd_sc_hd__fill_2
XFILLER_78_345 VPWR VGND VPWR VGND sky130_ef_sc_hd__decap_12
XTAP_TAPCELL_ROW_72_1478 VGND VPWR sky130_fd_sc_hd__tapvpwrvgnd_1
XFILLER_94_805 VGND VGND VPWR VPWR sky130_fd_sc_hd__decap_6
XTAP_TAPCELL_ROW_72_1489 VGND VPWR sky130_fd_sc_hd__tapvpwrvgnd_1
XFILLER_38_209 VPWR VGND VPWR VGND sky130_ef_sc_hd__decap_12
XFILLER_120_475 VGND VGND VPWR VPWR sky130_fd_sc_hd__fill_1
XFILLER_94_849 VPWR VGND VPWR VGND sky130_ef_sc_hd__decap_12
XFILLER_47_710 VPWR VGND VPWR VGND sky130_ef_sc_hd__decap_12
XFILLER_143_93 VPWR VGND VPWR VGND sky130_ef_sc_hd__decap_12
XFILLER_35_905 VGND VGND VPWR VPWR sky130_fd_sc_hd__decap_3
XFILLER_62_713 VPWR VGND VPWR VGND sky130_ef_sc_hd__decap_12
XTAP_TAPCELL_ROW_17_602 VGND VPWR sky130_fd_sc_hd__tapvpwrvgnd_1
XFILLER_46_253 VPWR VGND VPWR VGND sky130_ef_sc_hd__decap_12
XFILLER_62_757 VPWR VGND VPWR VGND sky130_ef_sc_hd__decap_12
XFILLER_15_673 VPWR VGND VPWR VGND sky130_ef_sc_hd__decap_12
X_1930_ B_reg\[9\] _1186_ _1190_ _1194_ VGND VGND VPWR VPWR _1195_ sky130_fd_sc_hd__a31o_1
XFILLER_147_317 VPWR VGND VPWR VGND sky130_ef_sc_hd__decap_12
X_1861_ _1127_ _1128_ _0891_ VGND VGND VPWR VPWR _1131_ sky130_fd_sc_hd__mux2_1
XFILLER_30_643 VGND VGND VPWR VPWR sky130_fd_sc_hd__fill_1
XFILLER_128_531 VGND VGND VPWR VPWR sky130_fd_sc_hd__fill_1
Xinput11 A_in[4] VGND VGND VPWR VPWR net11 sky130_fd_sc_hd__buf_1
Xinput22 B_in[14] VGND VGND VPWR VPWR net22 sky130_fd_sc_hd__clkbuf_1
Xinput33 Op_Sel[0] VGND VGND VPWR VPWR net33 sky130_fd_sc_hd__dlymetal6s2s_1
X_1792_ _1056_ _1060_ VGND VGND VPWR VPWR _1065_ sky130_fd_sc_hd__nand2_1
XFILLER_116_737 VPWR VGND VPWR VGND sky130_ef_sc_hd__decap_12
XFILLER_115_225 VPWR VGND VPWR VGND sky130_ef_sc_hd__decap_12
XFILLER_131_729 VPWR VGND VPWR VGND sky130_ef_sc_hd__decap_12
XFILLER_124_781 VPWR VGND VPWR VGND sky130_ef_sc_hd__decap_12
X_2413_ _0909_ _0155_ _0164_ VGND VGND VPWR VPWR _0167_ sky130_fd_sc_hd__and3_1
XFILLER_88_109 VPWR VGND VPWR VGND sky130_ef_sc_hd__decap_12
X_2344_ _1583_ _1593_ _1596_ _1584_ VGND VGND VPWR VPWR _1597_ sky130_fd_sc_hd__a22o_1
XFILLER_97_665 VGND VGND VPWR VPWR sky130_fd_sc_hd__decap_6
XFILLER_96_153 VPWR VGND VPWR VGND sky130_ef_sc_hd__decap_12
XFILLER_96_197 VPWR VGND VPWR VGND sky130_ef_sc_hd__decap_12
XANTENNA__2837__S _0383_ VGND VGND VPWR VPWR sky130_fd_sc_hd__diode_2
X_2275_ A_reg\[1\] _1527_ _1530_ VGND VGND VPWR VPWR _1532_ sky130_fd_sc_hd__nand3_1
XFILLER_57_529 VPWR VGND VPWR VGND sky130_ef_sc_hd__decap_12
XFILLER_26_905 VGND VGND VPWR VPWR sky130_fd_sc_hd__decap_4
XFILLER_65_573 VPWR VGND VPWR VGND sky130_ef_sc_hd__decap_12
XTAP_TAPCELL_ROW_36_900 VGND VPWR sky130_fd_sc_hd__tapvpwrvgnd_1
XTAP_TAPCELL_ROW_36_911 VGND VPWR sky130_fd_sc_hd__tapvpwrvgnd_1
XFILLER_80_576 VPWR VGND VPWR VGND sky130_ef_sc_hd__decap_12
XFILLER_52_267 VPWR VGND VPWR VGND sky130_ef_sc_hd__decap_12
XFILLER_12_109 VPWR VGND VPWR VGND sky130_ef_sc_hd__decap_12
XTAP_TAPCELL_ROW_43_1013 VGND VPWR sky130_fd_sc_hd__tapvpwrvgnd_1
XTAP_TAPCELL_ROW_43_1024 VGND VPWR sky130_fd_sc_hd__tapvpwrvgnd_1
XTAP_TAPCELL_ROW_138_2541 VGND VPWR sky130_fd_sc_hd__tapvpwrvgnd_1
XFILLER_21_665 VGND VGND VPWR VPWR sky130_fd_sc_hd__decap_6
XFILLER_32_27 VGND VGND VPWR VPWR sky130_fd_sc_hd__fill_1
XFILLER_148_27 VGND VGND VPWR VPWR sky130_fd_sc_hd__fill_1
XFILLER_20_153 VPWR VGND VPWR VGND sky130_ef_sc_hd__decap_12
XFILLER_153_309 VPWR VGND VPWR VGND sky130_ef_sc_hd__decap_12
XFILLER_119_553 VGND VGND VPWR VPWR sky130_fd_sc_hd__decap_6
XFILLER_5_809 VPWR VGND VPWR VGND sky130_ef_sc_hd__decap_12
XFILLER_20_197 VPWR VGND VPWR VGND sky130_ef_sc_hd__decap_12
XTAP_TAPCELL_ROW_151_2752 VGND VPWR sky130_fd_sc_hd__tapvpwrvgnd_1
XTAP_TAPCELL_ROW_151_2741 VGND VPWR sky130_fd_sc_hd__tapvpwrvgnd_1
XFILLER_147_895 VGND VGND VPWR VPWR sky130_fd_sc_hd__fill_1
XFILLER_134_501 VPWR VGND VPWR VGND sky130_ef_sc_hd__decap_12
XFILLER_119_597 VPWR VGND VPWR VGND sky130_ef_sc_hd__decap_12
XFILLER_134_545 VPWR VGND VPWR VGND sky130_ef_sc_hd__decap_12
XFILLER_134_589 VPWR VGND VPWR VGND sky130_ef_sc_hd__decap_12
XFILLER_121_217 VGND VGND VPWR VPWR sky130_fd_sc_hd__decap_6
XFILLER_88_643 VGND VGND VPWR VPWR sky130_fd_sc_hd__fill_1
XTAP_TAPCELL_ROW_54_1197 VGND VPWR sky130_fd_sc_hd__tapvpwrvgnd_1
XFILLER_102_475 VGND VGND VPWR VPWR sky130_fd_sc_hd__fill_1
XFILLER_88_698 VGND VGND VPWR VPWR sky130_fd_sc_hd__fill_2
XFILLER_76_849 VPWR VGND VPWR VGND sky130_ef_sc_hd__decap_12
XFILLER_75_337 VPWR VGND VPWR VGND sky130_ef_sc_hd__decap_12
XFILLER_57_57 VPWR VGND VPWR VGND sky130_ef_sc_hd__decap_12
XFILLER_29_721 VGND VGND VPWR VPWR sky130_fd_sc_hd__decap_6
XFILLER_29_765 VPWR VGND VPWR VGND sky130_ef_sc_hd__decap_12
XFILLER_90_307 VGND VGND VPWR VPWR sky130_fd_sc_hd__fill_1
XFILLER_84_893 VPWR VGND VPWR VGND sky130_ef_sc_hd__decap_12
XANTENNA__2483__A1 _0187_ VGND VGND VPWR VPWR sky130_fd_sc_hd__diode_2
XTAP_TAPCELL_ROW_3_385 VGND VPWR sky130_fd_sc_hd__tapvpwrvgnd_1
XTAP_TAPCELL_ROW_3_374 VGND VPWR sky130_fd_sc_hd__tapvpwrvgnd_1
XFILLER_28_242 VGND VGND VPWR VPWR sky130_fd_sc_hd__decap_8
XFILLER_28_253 VPWR VGND VPWR VGND sky130_ef_sc_hd__decap_12
XFILLER_71_543 VGND VGND VPWR VPWR sky130_fd_sc_hd__fill_1
XFILLER_28_297 VGND VGND VPWR VPWR sky130_fd_sc_hd__fill_2
XFILLER_43_223 VGND VGND VPWR VPWR sky130_fd_sc_hd__fill_1
XFILLER_44_757 VGND VGND VPWR VPWR sky130_fd_sc_hd__decap_6
XANTENNA__1887__A A_reg\[0\] VGND VGND VPWR VPWR sky130_fd_sc_hd__diode_2
XPHY_EDGE_ROW_125_Right_125 VGND VGND VPWR VPWR sky130_fd_sc_hd__decap_3
XFILLER_31_429 VPWR VGND VPWR VGND sky130_ef_sc_hd__decap_12
XFILLER_129_317 VPWR VGND VPWR VGND sky130_ef_sc_hd__decap_12
XFILLER_12_643 VGND VGND VPWR VPWR sky130_fd_sc_hd__fill_1
XFILLER_8_625 VPWR VGND VPWR VGND sky130_ef_sc_hd__decap_12
XFILLER_7_113 VPWR VGND VPWR VGND sky130_ef_sc_hd__decap_12
XFILLER_144_309 VPWR VGND VPWR VGND sky130_ef_sc_hd__decap_12
XFILLER_8_669 VPWR VGND VPWR VGND sky130_ef_sc_hd__decap_12
XTAP_TAPCELL_ROW_22_682 VGND VPWR sky130_fd_sc_hd__tapvpwrvgnd_1
XFILLER_137_361 VPWR VGND VPWR VGND sky130_ef_sc_hd__decap_12
XFILLER_153_865 VGND VGND VPWR VPWR sky130_fd_sc_hd__decap_3
XFILLER_98_53 VPWR VGND VPWR VGND sky130_ef_sc_hd__decap_12
XTAP_TAPCELL_ROW_74_1518 VGND VPWR sky130_fd_sc_hd__tapvpwrvgnd_1
XFILLER_113_729 VPWR VGND VPWR VGND sky130_ef_sc_hd__decap_12
XFILLER_106_781 VPWR VGND VPWR VGND sky130_ef_sc_hd__decap_12
XFILLER_98_97 VPWR VGND VPWR VGND sky130_ef_sc_hd__decap_12
XFILLER_3_374 VPWR VGND VPWR VGND sky130_ef_sc_hd__decap_12
XFILLER_78_153 VPWR VGND VPWR VGND sky130_ef_sc_hd__decap_12
XFILLER_94_613 VPWR VGND VPWR VGND sky130_ef_sc_hd__decap_12
XFILLER_39_529 VPWR VGND VPWR VGND sky130_ef_sc_hd__decap_12
XTAP_TAPCELL_ROW_105_2006 VGND VPWR sky130_fd_sc_hd__tapvpwrvgnd_1
XFILLER_94_657 VPWR VGND VPWR VGND sky130_ef_sc_hd__decap_12
X_2060_ _1317_ _1318_ _1321_ VGND VGND VPWR VPWR _1322_ sky130_fd_sc_hd__a21boi_1
XTAP_TAPCELL_ROW_89_1750 VGND VPWR sky130_fd_sc_hd__tapvpwrvgnd_1
XFILLER_78_197 VPWR VGND VPWR VGND sky130_ef_sc_hd__decap_12
XTAP_TAPCELL_ROW_105_2017 VGND VPWR sky130_fd_sc_hd__tapvpwrvgnd_1
XFILLER_93_167 VGND VGND VPWR VPWR sky130_fd_sc_hd__fill_1
XTAP_TAPCELL_ROW_89_1761 VGND VPWR sky130_fd_sc_hd__tapvpwrvgnd_1
XFILLER_81_329 VGND VGND VPWR VPWR sky130_fd_sc_hd__decap_4
XFILLER_47_573 VPWR VGND VPWR VGND sky130_ef_sc_hd__decap_12
XFILLER_34_256 VGND VGND VPWR VPWR sky130_fd_sc_hd__fill_1
X_2962_ _0573_ _0648_ VGND VGND VPWR VPWR _0650_ sky130_fd_sc_hd__or2_1
XFILLER_62_587 VGND VGND VPWR VPWR sky130_fd_sc_hd__fill_1
XFILLER_50_738 VPWR VGND VPWR VGND sky130_ef_sc_hd__decap_12
XFILLER_34_289 VGND VGND VPWR VPWR sky130_fd_sc_hd__decap_3
X_1913_ B_reg\[14\] B_reg\[13\] B_reg\[12\] B_reg\[15\] VGND VGND VPWR VPWR _1178_
+ sky130_fd_sc_hd__and4b_1
XANTENNA__3315__RESET_B net36 VGND VGND VPWR VPWR sky130_fd_sc_hd__diode_2
XFILLER_148_637 VGND VGND VPWR VPWR sky130_fd_sc_hd__decap_6
XFILLER_147_125 VPWR VGND VPWR VGND sky130_ef_sc_hd__decap_12
X_2893_ _0570_ _0580_ VGND VGND VPWR VPWR _0581_ sky130_fd_sc_hd__nor2_1
XFILLER_147_169 VPWR VGND VPWR VGND sky130_ef_sc_hd__decap_12
X_1844_ A_reg\[13\] _0917_ _0924_ VGND VGND VPWR VPWR _1114_ sky130_fd_sc_hd__o21a_1
XTAP_TAPCELL_ROW_41_980 VGND VPWR sky130_fd_sc_hd__tapvpwrvgnd_1
XTAP_TAPCELL_ROW_41_991 VGND VPWR sky130_fd_sc_hd__tapvpwrvgnd_1
XFILLER_129_895 VGND VGND VPWR VPWR sky130_fd_sc_hd__fill_1
XFILLER_116_501 VPWR VGND VPWR VGND sky130_ef_sc_hd__decap_12
X_1775_ _1042_ _1044_ VGND VGND VPWR VPWR _1048_ sky130_fd_sc_hd__nand2b_1
XTAP_TAPCELL_ROW_133_2460 VGND VPWR sky130_fd_sc_hd__tapvpwrvgnd_1
XFILLER_116_545 VPWR VGND VPWR VGND sky130_ef_sc_hd__decap_12
XFILLER_116_589 VPWR VGND VPWR VGND sky130_ef_sc_hd__decap_12
XFILLER_89_407 VPWR VGND VPWR VGND sky130_ef_sc_hd__decap_12
XFILLER_103_217 VGND VGND VPWR VPWR sky130_fd_sc_hd__decap_6
XANTENNA__3234__CLK clknet_3_3__leaf_clk VGND VGND VPWR VPWR sky130_fd_sc_hd__diode_2
XFILLER_134_29 VPWR VGND VPWR VGND sky130_ef_sc_hd__decap_12
XFILLER_131_559 VGND VGND VPWR VPWR sky130_fd_sc_hd__fill_1
XFILLER_69_153 VPWR VGND VPWR VGND sky130_ef_sc_hd__decap_12
XFILLER_58_805 VGND VGND VPWR VPWR sky130_fd_sc_hd__decap_6
XFILLER_111_261 VPWR VGND VPWR VGND sky130_ef_sc_hd__decap_12
XFILLER_97_473 VPWR VGND VPWR VGND sky130_ef_sc_hd__decap_12
X_2327_ _1570_ _1579_ _0901_ VGND VGND VPWR VPWR _1580_ sky130_fd_sc_hd__a21oi_1
XFILLER_57_337 VPWR VGND VPWR VGND sky130_ef_sc_hd__decap_12
XFILLER_27_27 VPWR VGND VPWR VGND sky130_ef_sc_hd__decap_12
X_2258_ A_reg\[3\] _1487_ _1500_ VGND VGND VPWR VPWR _1515_ sky130_fd_sc_hd__and3_1
XTAP_TAPCELL_ROW_0_311 VGND VPWR sky130_fd_sc_hd__tapvpwrvgnd_1
XFILLER_26_713 VPWR VGND VPWR VGND sky130_ef_sc_hd__decap_12
XFILLER_81_841 VPWR VGND VPWR VGND sky130_ef_sc_hd__decap_12
XANTENNA__2465__B2 _0910_ VGND VGND VPWR VPWR sky130_fd_sc_hd__diode_2
XFILLER_66_893 VPWR VGND VPWR VGND sky130_ef_sc_hd__decap_12
XFILLER_53_532 VGND VGND VPWR VPWR sky130_fd_sc_hd__decap_3
XTAP_TAPCELL_ROW_0_322 VGND VPWR sky130_fd_sc_hd__tapvpwrvgnd_1
XTAP_TAPCELL_ROW_0_333 VGND VPWR sky130_fd_sc_hd__tapvpwrvgnd_1
X_2189_ _1445_ VGND VGND VPWR VPWR _1446_ sky130_fd_sc_hd__inv_2
XFILLER_25_223 VGND VGND VPWR VPWR sky130_fd_sc_hd__fill_1
XFILLER_26_757 VPWR VGND VPWR VGND sky130_ef_sc_hd__decap_12
XFILLER_13_429 VGND VGND VPWR VPWR sky130_fd_sc_hd__decap_8
XFILLER_40_226 VGND VGND VPWR VPWR sky130_fd_sc_hd__fill_1
XFILLER_43_15 VPWR VGND VPWR VGND sky130_ef_sc_hd__decap_12
XFILLER_139_615 VGND VGND VPWR VPWR sky130_fd_sc_hd__fill_1
XTAP_TAPCELL_ROW_153_2803 VGND VPWR sky130_fd_sc_hd__tapvpwrvgnd_1
XFILLER_21_473 VPWR VGND VPWR VGND sky130_ef_sc_hd__decap_12
XFILLER_126_309 VPWR VGND VPWR VGND sky130_ef_sc_hd__decap_12
XFILLER_135_821 VPWR VGND VPWR VGND sky130_ef_sc_hd__decap_12
XFILLER_119_361 VPWR VGND VPWR VGND sky130_ef_sc_hd__decap_12
XFILLER_5_617 VGND VGND VPWR VPWR sky130_fd_sc_hd__decap_8
XFILLER_135_865 VPWR VGND VPWR VGND sky130_ef_sc_hd__decap_12
XFILLER_150_813 VPWR VGND VPWR VGND sky130_ef_sc_hd__decap_12
XFILLER_108_41 VPWR VGND VPWR VGND sky130_ef_sc_hd__decap_12
XTAP_TAPCELL_ROW_56_1226 VGND VPWR sky130_fd_sc_hd__tapvpwrvgnd_1
XFILLER_108_85 VPWR VGND VPWR VGND sky130_ef_sc_hd__decap_12
XTAP_TAPCELL_ROW_8_455 VGND VPWR sky130_fd_sc_hd__tapvpwrvgnd_1
XFILLER_76_602 VGND VGND VPWR VPWR sky130_fd_sc_hd__decap_8
XTAP_TAPCELL_ROW_8_466 VGND VPWR sky130_fd_sc_hd__tapvpwrvgnd_1
XFILLER_0_333 VGND VGND VPWR VPWR sky130_fd_sc_hd__decap_3
XFILLER_130_581 VGND VGND VPWR VPWR sky130_fd_sc_hd__decap_6
XFILLER_0_377 VPWR VGND VPWR VGND sky130_ef_sc_hd__decap_12
XFILLER_1_889 VGND VGND VPWR VPWR sky130_fd_sc_hd__decap_6
XFILLER_75_123 VPWR VGND VPWR VGND sky130_ef_sc_hd__decap_12
XANTENNA_input17_A B_in[0] VGND VGND VPWR VPWR sky130_fd_sc_hd__diode_2
XFILLER_84_55 VPWR VGND VPWR VGND sky130_ef_sc_hd__decap_12
XFILLER_75_167 VGND VGND VPWR VPWR sky130_fd_sc_hd__fill_1
XTAP_TAPCELL_ROW_27_763 VGND VPWR sky130_fd_sc_hd__tapvpwrvgnd_1
XFILLER_140_83 VGND VGND VPWR VPWR sky130_fd_sc_hd__fill_1
XTAP_TAPCELL_ROW_84_1680 VGND VPWR sky130_fd_sc_hd__tapvpwrvgnd_1
XFILLER_71_373 VPWR VGND VPWR VGND sky130_ef_sc_hd__decap_12
XTAP_TAPCELL_ROW_67_1399 VGND VPWR sky130_fd_sc_hd__tapvpwrvgnd_1
XFILLER_16_289 VPWR VGND VPWR VGND sky130_ef_sc_hd__decap_12
XFILLER_17_93 VPWR VGND VPWR VGND sky130_ef_sc_hd__decap_12
XFILLER_32_749 VGND VGND VPWR VPWR sky130_fd_sc_hd__decap_6
XFILLER_44_587 VGND VGND VPWR VPWR sky130_fd_sc_hd__fill_1
XFILLER_31_237 VPWR VGND VPWR VGND sky130_ef_sc_hd__decap_12
XFILLER_129_125 VPWR VGND VPWR VGND sky130_ef_sc_hd__decap_12
XFILLER_12_473 VGND VGND VPWR VPWR sky130_fd_sc_hd__decap_3
XFILLER_33_81 VPWR VGND VPWR VGND sky130_ef_sc_hd__decap_12
XFILLER_149_81 VPWR VGND VPWR VGND sky130_ef_sc_hd__decap_12
XFILLER_145_629 VPWR VGND VPWR VGND sky130_ef_sc_hd__decap_12
XFILLER_138_681 VPWR VGND VPWR VGND sky130_ef_sc_hd__decap_12
XFILLER_129_169 VPWR VGND VPWR VGND sky130_ef_sc_hd__decap_12
XFILLER_8_477 VPWR VGND VPWR VGND sky130_ef_sc_hd__decap_12
XFILLER_144_139 VGND VGND VPWR VPWR sky130_fd_sc_hd__fill_1
XANTENNA__3257__CLK clknet_3_6__leaf_clk VGND VGND VPWR VPWR sky130_fd_sc_hd__diode_2
XANTENNA__2241__A A_reg\[4\] VGND VGND VPWR VPWR sky130_fd_sc_hd__diode_2
XFILLER_153_673 VPWR VGND VPWR VGND sky130_ef_sc_hd__decap_12
XFILLER_99_727 VGND VGND VPWR VPWR sky130_fd_sc_hd__fill_1
XFILLER_140_301 VGND VGND VPWR VPWR sky130_fd_sc_hd__decap_6
XFILLER_98_237 VGND VGND VPWR VPWR sky130_fd_sc_hd__fill_2
XFILLER_140_345 VPWR VGND VPWR VGND sky130_ef_sc_hd__decap_12
XFILLER_113_559 VGND VGND VPWR VPWR sky130_fd_sc_hd__fill_1
X_3230_ clknet_3_3__leaf_clk _0017_ net36 VGND VGND VPWR VPWR b_r0\[0\] sky130_fd_sc_hd__dfrtp_4
XFILLER_3_193 VPWR VGND VPWR VGND sky130_ef_sc_hd__decap_12
XFILLER_140_389 VPWR VGND VPWR VGND sky130_ef_sc_hd__decap_12
XFILLER_100_209 VPWR VGND VPWR VGND sky130_ef_sc_hd__decap_12
XFILLER_79_473 VPWR VGND VPWR VGND sky130_ef_sc_hd__decap_12
XFILLER_67_613 VGND VGND VPWR VPWR sky130_fd_sc_hd__decap_3
X_3161_ _0815_ _0826_ VGND VGND VPWR VPWR _0849_ sky130_fd_sc_hd__or2_1
XFILLER_94_421 VGND VGND VPWR VPWR sky130_fd_sc_hd__decap_4
X_2112_ _1369_ _1370_ B_reg\[9\] VGND VGND VPWR VPWR _1371_ sky130_fd_sc_hd__o21ai_1
XFILLER_67_668 VGND VGND VPWR VPWR sky130_fd_sc_hd__fill_1
XFILLER_67_657 VGND VGND VPWR VPWR sky130_fd_sc_hd__decap_6
XFILLER_12_3 VPWR VGND VPWR VGND sky130_ef_sc_hd__decap_12
XFILLER_39_337 VPWR VGND VPWR VGND sky130_ef_sc_hd__decap_12
XFILLER_82_605 VGND VGND VPWR VPWR sky130_fd_sc_hd__fill_1
X_3092_ _0765_ _0779_ VGND VGND VPWR VPWR _0780_ sky130_fd_sc_hd__and2_1
X_2043_ _1301_ _1304_ VGND VGND VPWR VPWR _1305_ sky130_fd_sc_hd__nand2_1
XFILLER_81_137 VGND VGND VPWR VPWR sky130_fd_sc_hd__decap_4
XFILLER_63_841 VPWR VGND VPWR VGND sky130_ef_sc_hd__decap_12
XFILLER_90_693 VGND VGND VPWR VPWR sky130_fd_sc_hd__decap_6
XFILLER_50_513 VPWR VGND VPWR VGND sky130_ef_sc_hd__decap_12
XFILLER_23_727 VGND VGND VPWR VPWR sky130_fd_sc_hd__fill_1
XFILLER_50_557 VGND VGND VPWR VPWR sky130_fd_sc_hd__fill_2
XFILLER_148_401 VPWR VGND VPWR VGND sky130_ef_sc_hd__decap_12
XTAP_TAPCELL_ROW_118_2219 VGND VPWR sky130_fd_sc_hd__tapvpwrvgnd_1
X_2945_ _0564_ _0632_ VGND VGND VPWR VPWR _0633_ sky130_fd_sc_hd__or2_1
XFILLER_148_445 VPWR VGND VPWR VGND sky130_ef_sc_hd__decap_12
XANTENNA__2850__S _0383_ VGND VGND VPWR VPWR sky130_fd_sc_hd__diode_2
X_2876_ u_crt.r2\[1\] _0562_ VGND VGND VPWR VPWR _0564_ sky130_fd_sc_hd__xor2_4
XFILLER_31_793 VGND VGND VPWR VPWR sky130_fd_sc_hd__fill_2
XFILLER_148_489 VPWR VGND VPWR VGND sky130_ef_sc_hd__decap_12
XFILLER_117_821 VPWR VGND VPWR VGND sky130_ef_sc_hd__decap_12
XFILLER_108_309 VPWR VGND VPWR VGND sky130_ef_sc_hd__decap_12
X_1827_ A_reg\[1\] _1099_ VGND VGND VPWR VPWR _1100_ sky130_fd_sc_hd__or2_1
XFILLER_150_109 VPWR VGND VPWR VGND sky130_ef_sc_hd__decap_12
XFILLER_132_813 VPWR VGND VPWR VGND sky130_ef_sc_hd__decap_12
XFILLER_117_865 VPWR VGND VPWR VGND sky130_ef_sc_hd__decap_12
X_1758_ _1030_ VGND VGND VPWR VPWR _1031_ sky130_fd_sc_hd__inv_2
XFILLER_145_39 VPWR VGND VPWR VGND sky130_ef_sc_hd__decap_12
XFILLER_143_161 VGND VGND VPWR VPWR sky130_fd_sc_hd__decap_6
X_1689_ _0953_ _0960_ _0956_ A_reg\[6\] VGND VGND VPWR VPWR _0965_ sky130_fd_sc_hd__o211ai_1
XFILLER_98_793 VPWR VGND VPWR VGND sky130_ef_sc_hd__decap_12
XANTENNA_input9_A A_in[2] VGND VGND VPWR VPWR sky130_fd_sc_hd__diode_2
XFILLER_58_602 VPWR VGND VPWR VGND sky130_ef_sc_hd__decap_12
XTAP_TAPCELL_ROW_5_414 VGND VPWR sky130_fd_sc_hd__tapvpwrvgnd_1
XFILLER_38_15 VPWR VGND VPWR VGND sky130_ef_sc_hd__decap_12
XTAP_TAPCELL_ROW_146_2662 VGND VPWR sky130_fd_sc_hd__tapvpwrvgnd_1
XFILLER_112_581 VGND VGND VPWR VPWR sky130_fd_sc_hd__decap_6
XFILLER_97_281 VGND VGND VPWR VPWR sky130_fd_sc_hd__fill_2
XTAP_TAPCELL_ROW_51_1145 VGND VPWR sky130_fd_sc_hd__tapvpwrvgnd_1
XTAP_TAPCELL_ROW_146_2673 VGND VPWR sky130_fd_sc_hd__tapvpwrvgnd_1
XFILLER_57_167 VGND VGND VPWR VPWR sky130_fd_sc_hd__fill_1
XFILLER_39_882 VGND VGND VPWR VPWR sky130_fd_sc_hd__fill_1
XFILLER_45_329 VGND VGND VPWR VPWR sky130_fd_sc_hd__decap_6
XANTENNA__3237__RESET_B net36 VGND VGND VPWR VPWR sky130_fd_sc_hd__diode_2
XFILLER_54_863 VGND VGND VPWR VPWR sky130_fd_sc_hd__decap_4
XFILLER_81_671 VGND VGND VPWR VPWR sky130_fd_sc_hd__fill_1
XFILLER_80_170 VGND VGND VPWR VPWR sky130_fd_sc_hd__fill_1
XFILLER_53_373 VPWR VGND VPWR VGND sky130_ef_sc_hd__decap_12
XTAP_TAPCELL_ROW_24_711 VGND VPWR sky130_fd_sc_hd__tapvpwrvgnd_1
XFILLER_26_587 VGND VGND VPWR VPWR sky130_fd_sc_hd__fill_1
XFILLER_110_53 VPWR VGND VPWR VGND sky130_ef_sc_hd__decap_12
XFILLER_80_192 VGND VGND VPWR VPWR sky130_fd_sc_hd__fill_1
XFILLER_13_237 VGND VGND VPWR VPWR sky130_fd_sc_hd__decap_6
XFILLER_14_749 VGND VGND VPWR VPWR sky130_fd_sc_hd__decap_6
XTAP_TAPCELL_ROW_24_722 VGND VPWR sky130_fd_sc_hd__tapvpwrvgnd_1
XFILLER_110_97 VPWR VGND VPWR VGND sky130_ef_sc_hd__decap_12
XFILLER_21_281 VPWR VGND VPWR VGND sky130_ef_sc_hd__decap_12
XFILLER_22_793 VPWR VGND VPWR VGND sky130_ef_sc_hd__decap_12
XFILLER_127_629 VPWR VGND VPWR VGND sky130_ef_sc_hd__decap_12
XFILLER_126_139 VGND VGND VPWR VPWR sky130_fd_sc_hd__fill_1
XFILLER_119_51 VGND VGND VPWR VPWR sky130_fd_sc_hd__decap_4
XFILLER_5_447 VGND VGND VPWR VPWR sky130_fd_sc_hd__fill_1
XFILLER_135_673 VPWR VGND VPWR VGND sky130_ef_sc_hd__decap_12
XFILLER_79_44 VPWR VGND VPWR VGND sky130_ef_sc_hd__decap_12
XFILLER_122_301 VGND VGND VPWR VPWR sky130_fd_sc_hd__decap_6
XFILLER_150_643 VGND VGND VPWR VPWR sky130_fd_sc_hd__fill_1
XFILLER_122_345 VPWR VGND VPWR VGND sky130_ef_sc_hd__decap_12
XFILLER_1_653 VPWR VGND VPWR VGND sky130_ef_sc_hd__decap_12
XFILLER_122_389 VPWR VGND VPWR VGND sky130_ef_sc_hd__decap_12
XFILLER_0_141 VPWR VGND VPWR VGND sky130_ef_sc_hd__decap_12
XANTENNA__2677__A1 a_r3\[0\] VGND VGND VPWR VPWR sky130_fd_sc_hd__diode_2
XFILLER_76_421 VPWR VGND VPWR VGND sky130_ef_sc_hd__decap_12
XFILLER_49_646 VPWR VGND VPWR VGND sky130_ef_sc_hd__decap_12
XFILLER_1_697 VPWR VGND VPWR VGND sky130_ef_sc_hd__decap_12
XFILLER_95_87 VPWR VGND VPWR VGND sky130_ef_sc_hd__decap_12
XTAP_TAPCELL_ROW_69_1428 VGND VPWR sky130_fd_sc_hd__tapvpwrvgnd_1
XFILLER_36_307 VGND VGND VPWR VPWR sky130_fd_sc_hd__fill_1
XFILLER_91_446 VGND VGND VPWR VPWR sky130_fd_sc_hd__fill_2
XTAP_TAPCELL_ROW_69_1439 VGND VPWR sky130_fd_sc_hd__tapvpwrvgnd_1
XFILLER_48_189 VGND VGND VPWR VPWR sky130_fd_sc_hd__decap_6
XFILLER_151_93 VPWR VGND VPWR VGND sky130_ef_sc_hd__decap_12
XFILLER_45_841 VPWR VGND VPWR VGND sky130_ef_sc_hd__decap_12
XTAP_TAPCELL_ROW_82_1639 VGND VPWR sky130_fd_sc_hd__tapvpwrvgnd_1
XFILLER_72_693 VGND VGND VPWR VPWR sky130_fd_sc_hd__decap_6
XFILLER_71_181 VGND VGND VPWR VPWR sky130_fd_sc_hd__decap_4
XFILLER_32_557 VGND VGND VPWR VPWR sky130_fd_sc_hd__fill_1
XFILLER_146_905 VGND VGND VPWR VPWR sky130_fd_sc_hd__decap_4
X_2730_ a_r3\[3\] b_r3\[2\] _0463_ VGND VGND VPWR VPWR _0470_ sky130_fd_sc_hd__a21boi_1
XANTENNA__2601__A1 _0186_ VGND VGND VPWR VPWR sky130_fd_sc_hd__diode_2
XFILLER_9_753 VPWR VGND VPWR VGND sky130_ef_sc_hd__decap_12
X_2661_ a_r3\[0\] a_r3\[1\] VGND VGND VPWR VPWR _0401_ sky130_fd_sc_hd__nand2_1
XFILLER_9_797 VPWR VGND VPWR VGND sky130_ef_sc_hd__decap_12
X_1612_ A_reg\[7\] VGND VGND VPWR VPWR _0892_ sky130_fd_sc_hd__inv_2
XFILLER_132_109 VPWR VGND VPWR VGND sky130_ef_sc_hd__decap_12
XFILLER_114_813 VPWR VGND VPWR VGND sky130_ef_sc_hd__decap_12
XTAP_TAPCELL_ROW_113_2138 VGND VPWR sky130_fd_sc_hd__tapvpwrvgnd_1
XTAP_TAPCELL_ROW_97_1882 VGND VPWR sky130_fd_sc_hd__tapvpwrvgnd_1
X_2592_ _0335_ _0336_ _0330_ VGND VGND VPWR VPWR _0337_ sky130_fd_sc_hd__a21bo_1
XTAP_TAPCELL_ROW_10_493 VGND VPWR sky130_fd_sc_hd__tapvpwrvgnd_1
XFILLER_125_161 VGND VGND VPWR VPWR sky130_fd_sc_hd__decap_6
XFILLER_141_665 VGND VGND VPWR VPWR sky130_fd_sc_hd__decap_6
XFILLER_140_153 VPWR VGND VPWR VGND sky130_ef_sc_hd__decap_12
XFILLER_101_529 VPWR VGND VPWR VGND sky130_ef_sc_hd__decap_12
X_3213_ clknet_3_1__leaf_clk _0001_ net36 VGND VGND VPWR VPWR a_r2\[1\] sky130_fd_sc_hd__dfrtp_4
XFILLER_140_197 VPWR VGND VPWR VGND sky130_ef_sc_hd__decap_12
XFILLER_95_741 VPWR VGND VPWR VGND sky130_ef_sc_hd__decap_12
XANTENNA__2668__A1 b_r3\[3\] VGND VGND VPWR VPWR sky130_fd_sc_hd__diode_2
XFILLER_79_281 VPWR VGND VPWR VGND sky130_ef_sc_hd__decap_12
XFILLER_79_270 VGND VGND VPWR VPWR sky130_fd_sc_hd__decap_8
XTAP_TAPCELL_ROW_128_2381 VGND VPWR sky130_fd_sc_hd__tapvpwrvgnd_1
XFILLER_95_785 VPWR VGND VPWR VGND sky130_ef_sc_hd__decap_12
XFILLER_94_251 VGND VGND VPWR VPWR sky130_fd_sc_hd__fill_1
XFILLER_55_605 VGND VGND VPWR VPWR sky130_fd_sc_hd__decap_6
X_3144_ _0561_ _0831_ VGND VGND VPWR VPWR _0832_ sky130_fd_sc_hd__nor2_1
XFILLER_39_167 VGND VGND VPWR VPWR sky130_fd_sc_hd__fill_1
X_3075_ _0720_ _0762_ _0698_ VGND VGND VPWR VPWR _0763_ sky130_fd_sc_hd__o21ai_1
XANTENNA__2845__S _0383_ VGND VGND VPWR VPWR sky130_fd_sc_hd__diode_2
X_2026_ _1278_ _1280_ VGND VGND VPWR VPWR _1288_ sky130_fd_sc_hd__nand2_1
XPHY_EDGE_ROW_145_Left_299 VGND VGND VPWR VPWR sky130_fd_sc_hd__decap_3
XTAP_TAPCELL_ROW_141_2592 VGND VPWR sky130_fd_sc_hd__tapvpwrvgnd_1
XTAP_TAPCELL_ROW_141_2581 VGND VPWR sky130_fd_sc_hd__tapvpwrvgnd_1
XFILLER_51_811 VPWR VGND VPWR VGND sky130_ef_sc_hd__decap_12
XFILLER_50_321 VPWR VGND VPWR VGND sky130_ef_sc_hd__decap_12
XANTENNA__2840__A1 A_reg\[6\] VGND VGND VPWR VPWR sky130_fd_sc_hd__diode_2
XFILLER_149_721 VGND VGND VPWR VPWR sky130_fd_sc_hd__decap_6
XFILLER_51_877 VPWR VGND VPWR VGND sky130_ef_sc_hd__decap_12
XFILLER_50_365 VPWR VGND VPWR VGND sky130_ef_sc_hd__decap_12
XFILLER_149_765 VPWR VGND VPWR VGND sky130_ef_sc_hd__decap_12
X_2928_ _0593_ _0613_ VGND VGND VPWR VPWR _0616_ sky130_fd_sc_hd__xnor2_1
XFILLER_148_253 VPWR VGND VPWR VGND sky130_ef_sc_hd__decap_12
XFILLER_109_629 VPWR VGND VPWR VGND sky130_ef_sc_hd__decap_12
XFILLER_40_27 VGND VGND VPWR VPWR sky130_fd_sc_hd__fill_1
XFILLER_108_139 VGND VGND VPWR VPWR sky130_fd_sc_hd__fill_1
X_2859_ net32 B_reg\[9\] _0383_ VGND VGND VPWR VPWR _0082_ sky130_fd_sc_hd__mux2_1
XFILLER_151_429 VPWR VGND VPWR VGND sky130_ef_sc_hd__decap_12
XFILLER_117_673 VPWR VGND VPWR VGND sky130_ef_sc_hd__decap_12
XFILLER_104_301 VGND VGND VPWR VPWR sky130_fd_sc_hd__decap_6
XTAP_TAPCELL_ROW_148_2702 VGND VPWR sky130_fd_sc_hd__tapvpwrvgnd_1
XFILLER_132_643 VGND VGND VPWR VPWR sky130_fd_sc_hd__fill_1
XFILLER_120_805 VGND VGND VPWR VPWR sky130_fd_sc_hd__decap_6
XFILLER_104_345 VPWR VGND VPWR VGND sky130_ef_sc_hd__decap_12
XFILLER_49_69 VPWR VGND VPWR VGND sky130_ef_sc_hd__decap_12
XFILLER_120_849 VPWR VGND VPWR VGND sky130_ef_sc_hd__decap_12
XFILLER_105_20 VPWR VGND VPWR VGND sky130_ef_sc_hd__decap_12
XFILLER_18_307 VGND VGND VPWR VPWR sky130_fd_sc_hd__fill_1
XTAP_TAPCELL_ROW_29_803 VGND VPWR sky130_fd_sc_hd__tapvpwrvgnd_1
XFILLER_73_435 VGND VGND VPWR VPWR sky130_fd_sc_hd__fill_1
XFILLER_65_57 VPWR VGND VPWR VGND sky130_ef_sc_hd__decap_12
XFILLER_46_627 VPWR VGND VPWR VGND sky130_ef_sc_hd__decap_12
XFILLER_39_690 VPWR VGND VPWR VGND sky130_ef_sc_hd__decap_12
XFILLER_27_841 VPWR VGND VPWR VGND sky130_ef_sc_hd__decap_12
XFILLER_45_137 VPWR VGND VPWR VGND sky130_ef_sc_hd__decap_12
XFILLER_54_682 VGND VGND VPWR VPWR sky130_fd_sc_hd__fill_2
XFILLER_14_513 VPWR VGND VPWR VGND sky130_ef_sc_hd__decap_12
XTAP_TAPCELL_ROW_64_1358 VGND VPWR sky130_fd_sc_hd__tapvpwrvgnd_1
XFILLER_53_181 VPWR VGND VPWR VGND sky130_ef_sc_hd__decap_12
XFILLER_14_557 VPWR VGND VPWR VGND sky130_ef_sc_hd__decap_12
XFILLER_128_905 VGND VGND VPWR VPWR sky130_fd_sc_hd__decap_4
XFILLER_6_701 VPWR VGND VPWR VGND sky130_ef_sc_hd__decap_12
XFILLER_14_83 VGND VGND VPWR VPWR sky130_fd_sc_hd__fill_1
XFILLER_5_233 VGND VGND VPWR VPWR sky130_fd_sc_hd__decap_3
XFILLER_114_109 VPWR VGND VPWR VGND sky130_ef_sc_hd__decap_12
XFILLER_107_161 VGND VGND VPWR VPWR sky130_fd_sc_hd__decap_6
XTAP_TAPCELL_ROW_79_1590 VGND VPWR sky130_fd_sc_hd__tapvpwrvgnd_1
XFILLER_5_277 VGND VGND VPWR VPWR sky130_fd_sc_hd__decap_3
XFILLER_123_665 VGND VGND VPWR VPWR sky130_fd_sc_hd__decap_6
XFILLER_122_153 VPWR VGND VPWR VGND sky130_ef_sc_hd__decap_12
XFILLER_68_207 VPWR VGND VPWR VGND sky130_ef_sc_hd__decap_12
XFILLER_1_461 VPWR VGND VPWR VGND sky130_ef_sc_hd__decap_12
XFILLER_122_197 VPWR VGND VPWR VGND sky130_ef_sc_hd__decap_12
XFILLER_49_410 VPWR VGND VPWR VGND sky130_ef_sc_hd__decap_12
XFILLER_77_785 VPWR VGND VPWR VGND sky130_ef_sc_hd__decap_12
XFILLER_76_251 VGND VGND VPWR VPWR sky130_fd_sc_hd__fill_1
Xinput9 A_in[2] VGND VGND VPWR VPWR net9 sky130_fd_sc_hd__clkbuf_1
XFILLER_64_413 VGND VGND VPWR VPWR sky130_fd_sc_hd__decap_6
XFILLER_92_755 VGND VGND VPWR VPWR sky130_fd_sc_hd__fill_1
XFILLER_55_90 VPWR VGND VPWR VGND sky130_ef_sc_hd__decap_12
XFILLER_17_373 VGND VGND VPWR VPWR sky130_fd_sc_hd__decap_4
XFILLER_32_321 VPWR VGND VPWR VGND sky130_ef_sc_hd__decap_12
XFILLER_45_693 VGND VGND VPWR VPWR sky130_fd_sc_hd__fill_2
XFILLER_32_365 VGND VGND VPWR VPWR sky130_fd_sc_hd__fill_1
XTAP_TAPCELL_ROW_99_1911 VGND VPWR sky130_fd_sc_hd__tapvpwrvgnd_1
XTAP_TAPCELL_ROW_15_574 VGND VPWR sky130_fd_sc_hd__tapvpwrvgnd_1
XFILLER_146_713 VPWR VGND VPWR VGND sky130_ef_sc_hd__decap_12
XTAP_TAPCELL_ROW_99_1922 VGND VPWR sky130_fd_sc_hd__tapvpwrvgnd_1
XFILLER_9_561 VPWR VGND VPWR VGND sky130_ef_sc_hd__decap_12
XFILLER_146_757 VPWR VGND VPWR VGND sky130_ef_sc_hd__decap_12
XFILLER_145_223 VGND VGND VPWR VPWR sky130_fd_sc_hd__fill_1
X_2713_ a_r3\[3\] b_r3\[3\] VGND VGND VPWR VPWR _0453_ sky130_fd_sc_hd__nand2_1
X_2644_ b_r3\[0\] a_r3\[0\] VGND VGND VPWR VPWR _0384_ sky130_fd_sc_hd__and2_1
XFILLER_133_429 VPWR VGND VPWR VGND sky130_ef_sc_hd__decap_12
X_2575_ _0309_ _0311_ VGND VGND VPWR VPWR _0320_ sky130_fd_sc_hd__xnor2_1
XFILLER_114_643 VGND VGND VPWR VPWR sky130_fd_sc_hd__fill_1
XFILLER_141_473 VPWR VGND VPWR VGND sky130_ef_sc_hd__decap_12
XFILLER_102_805 VGND VGND VPWR VPWR sky130_fd_sc_hd__decap_6
XFILLER_87_505 VPWR VGND VPWR VGND sky130_ef_sc_hd__decap_12
XFILLER_102_849 VPWR VGND VPWR VGND sky130_ef_sc_hd__decap_12
XFILLER_101_337 VPWR VGND VPWR VGND sky130_ef_sc_hd__decap_12
XFILLER_142_29 VPWR VGND VPWR VGND sky130_ef_sc_hd__decap_12
XFILLER_19_39 VPWR VGND VPWR VGND sky130_ef_sc_hd__decap_12
XTAP_TAPCELL_ROW_143_2621 VGND VPWR sky130_fd_sc_hd__tapvpwrvgnd_1
XFILLER_110_893 VPWR VGND VPWR VGND sky130_ef_sc_hd__decap_12
XFILLER_67_273 VGND VGND VPWR VPWR sky130_fd_sc_hd__decap_6
X_3127_ _0790_ _0810_ _0813_ _0814_ VGND VGND VPWR VPWR _0815_ sky130_fd_sc_hd__and4_1
XPHY_EDGE_ROW_153_Left_307 VGND VGND VPWR VPWR sky130_fd_sc_hd__decap_3
XFILLER_83_777 VGND VGND VPWR VPWR sky130_fd_sc_hd__decap_6
XFILLER_82_221 VPWR VGND VPWR VGND sky130_ef_sc_hd__decap_12
XFILLER_27_137 VPWR VGND VPWR VGND sky130_ef_sc_hd__decap_12
XFILLER_82_265 VPWR VGND VPWR VGND sky130_ef_sc_hd__decap_12
X_3058_ _0733_ _0745_ VGND VGND VPWR VPWR _0746_ sky130_fd_sc_hd__or2_1
XFILLER_24_811 VGND VGND VPWR VPWR sky130_fd_sc_hd__fill_1
XFILLER_35_27 VPWR VGND VPWR VGND sky130_ef_sc_hd__decap_12
X_2009_ B_reg\[11\] _1260_ _1266_ VGND VGND VPWR VPWR _1271_ sky130_fd_sc_hd__o21ba_1
XFILLER_51_641 VPWR VGND VPWR VGND sky130_ef_sc_hd__decap_12
XFILLER_23_310 VPWR VGND VPWR VGND sky130_ef_sc_hd__decap_12
XFILLER_35_181 VPWR VGND VPWR VGND sky130_ef_sc_hd__decap_12
XFILLER_36_693 VGND VGND VPWR VPWR sky130_fd_sc_hd__decap_6
XFILLER_11_505 VPWR VGND VPWR VGND sky130_ef_sc_hd__decap_12
XTAP_TAPCELL_ROW_46_1066 VGND VPWR sky130_fd_sc_hd__tapvpwrvgnd_1
XFILLER_23_387 VGND VGND VPWR VPWR sky130_fd_sc_hd__decap_4
XTAP_TAPCELL_ROW_34_872 VGND VPWR sky130_fd_sc_hd__tapvpwrvgnd_1
XTAP_TAPCELL_ROW_34_883 VGND VPWR sky130_fd_sc_hd__tapvpwrvgnd_1
XFILLER_149_573 VPWR VGND VPWR VGND sky130_ef_sc_hd__decap_12
XFILLER_136_245 VGND VGND VPWR VPWR sky130_fd_sc_hd__decap_6
XFILLER_152_749 VGND VGND VPWR VPWR sky130_fd_sc_hd__decap_6
XFILLER_136_289 VPWR VGND VPWR VGND sky130_ef_sc_hd__decap_12
XANTENNA__3318__CLK clknet_3_5__leaf_clk VGND VGND VPWR VPWR sky130_fd_sc_hd__diode_2
XFILLER_151_237 VPWR VGND VPWR VGND sky130_ef_sc_hd__decap_12
XFILLER_120_613 VPWR VGND VPWR VGND sky130_ef_sc_hd__decap_12
XFILLER_116_41 VPWR VGND VPWR VGND sky130_ef_sc_hd__decap_12
XFILLER_105_665 VGND VGND VPWR VPWR sky130_fd_sc_hd__decap_6
XFILLER_104_153 VPWR VGND VPWR VGND sky130_ef_sc_hd__decap_12
XFILLER_116_85 VPWR VGND VPWR VGND sky130_ef_sc_hd__decap_12
XFILLER_104_197 VPWR VGND VPWR VGND sky130_ef_sc_hd__decap_12
XFILLER_59_741 VGND VGND VPWR VPWR sky130_fd_sc_hd__fill_1
XFILLER_120_657 VPWR VGND VPWR VGND sky130_ef_sc_hd__decap_12
XANTENNA__3252__RESET_B net36 VGND VGND VPWR VPWR sky130_fd_sc_hd__diode_2
XFILLER_58_251 VGND VGND VPWR VPWR sky130_fd_sc_hd__fill_1
XFILLER_74_722 VPWR VGND VPWR VGND sky130_ef_sc_hd__decap_12
XFILLER_59_785 VPWR VGND VPWR VGND sky130_ef_sc_hd__decap_12
XFILLER_58_273 VGND VGND VPWR VPWR sky130_fd_sc_hd__decap_3
XFILLER_46_413 VGND VGND VPWR VPWR sky130_fd_sc_hd__decap_6
XFILLER_74_766 VPWR VGND VPWR VGND sky130_ef_sc_hd__decap_12
XFILLER_73_221 VGND VGND VPWR VPWR sky130_fd_sc_hd__decap_3
XFILLER_27_671 VGND VGND VPWR VPWR sky130_fd_sc_hd__fill_1
XFILLER_92_77 VGND VGND VPWR VPWR sky130_fd_sc_hd__decap_6
XFILLER_61_449 VPWR VGND VPWR VGND sky130_ef_sc_hd__decap_12
XFILLER_61_438 VGND VGND VPWR VPWR sky130_fd_sc_hd__decap_8
XFILLER_14_321 VGND VGND VPWR VPWR sky130_fd_sc_hd__fill_1
XFILLER_15_833 VGND VGND VPWR VPWR sky130_fd_sc_hd__decap_6
XFILLER_14_365 VPWR VGND VPWR VGND sky130_ef_sc_hd__decap_12
XFILLER_15_877 VPWR VGND VPWR VGND sky130_ef_sc_hd__decap_12
XFILLER_25_93 VPWR VGND VPWR VGND sky130_ef_sc_hd__decap_12
XFILLER_30_847 VPWR VGND VPWR VGND sky130_ef_sc_hd__decap_12
XFILLER_128_713 VPWR VGND VPWR VGND sky130_ef_sc_hd__decap_12
XTAP_TAPCELL_ROW_12_522 VGND VPWR sky130_fd_sc_hd__tapvpwrvgnd_1
XFILLER_30_869 VGND VGND VPWR VPWR sky130_fd_sc_hd__decap_8
XFILLER_128_757 VPWR VGND VPWR VGND sky130_ef_sc_hd__decap_12
XFILLER_127_223 VGND VGND VPWR VPWR sky130_fd_sc_hd__fill_1
XFILLER_6_531 VGND VGND VPWR VPWR sky130_fd_sc_hd__fill_1
XFILLER_41_81 VPWR VGND VPWR VGND sky130_ef_sc_hd__decap_12
XFILLER_143_727 VGND VGND VPWR VPWR sky130_fd_sc_hd__fill_1
XFILLER_115_429 VPWR VGND VPWR VGND sky130_ef_sc_hd__decap_12
XTAP_TAPCELL_ROW_94_1841 VGND VPWR sky130_fd_sc_hd__tapvpwrvgnd_1
XTAP_TAPCELL_ROW_94_1830 VGND VPWR sky130_fd_sc_hd__tapvpwrvgnd_1
XANTENNA__1791__A1 A_reg\[6\] VGND VGND VPWR VPWR sky130_fd_sc_hd__diode_2
XFILLER_6_597 VGND VGND VPWR VPWR sky130_fd_sc_hd__fill_1
XFILLER_123_473 VPWR VGND VPWR VGND sky130_ef_sc_hd__decap_12
XFILLER_96_302 VGND VGND VPWR VPWR sky130_fd_sc_hd__decap_6
X_2360_ _0109_ _0111_ _0904_ VGND VGND VPWR VPWR _0114_ sky130_fd_sc_hd__a21oi_1
XFILLER_69_505 VPWR VGND VPWR VGND sky130_ef_sc_hd__decap_12
XFILLER_69_538 VGND VGND VPWR VPWR sky130_fd_sc_hd__fill_2
X_2291_ _1534_ _1545_ VGND VGND VPWR VPWR _1546_ sky130_fd_sc_hd__xor2_1
XFILLER_2_781 VPWR VGND VPWR VGND sky130_ef_sc_hd__decap_12
XPHY_EDGE_ROW_10_Right_10 VGND VGND VPWR VPWR sky130_fd_sc_hd__decap_3
XFILLER_2_53 VPWR VGND VPWR VGND sky130_ef_sc_hd__decap_12
XFILLER_110_189 VGND VGND VPWR VPWR sky130_fd_sc_hd__decap_6
XFILLER_49_273 VGND VGND VPWR VPWR sky130_fd_sc_hd__decap_6
XPHY_EDGE_ROW_139_Right_139 VGND VGND VPWR VPWR sky130_fd_sc_hd__decap_3
XTAP_TAPCELL_ROW_108_2059 VGND VPWR sky130_fd_sc_hd__tapvpwrvgnd_1
XFILLER_2_97 VPWR VGND VPWR VGND sky130_ef_sc_hd__decap_12
XFILLER_64_265 VPWR VGND VPWR VGND sky130_ef_sc_hd__decap_12
XFILLER_80_769 VPWR VGND VPWR VGND sky130_ef_sc_hd__decap_12
XFILLER_17_181 VPWR VGND VPWR VGND sky130_ef_sc_hd__decap_12
XFILLER_18_693 VGND VGND VPWR VPWR sky130_fd_sc_hd__decap_6
XFILLER_33_641 VPWR VGND VPWR VGND sky130_ef_sc_hd__decap_12
XTAP_TAPCELL_ROW_103_1981 VGND VPWR sky130_fd_sc_hd__tapvpwrvgnd_1
XTAP_TAPCELL_ROW_31_820 VGND VPWR sky130_fd_sc_hd__tapvpwrvgnd_1
XFILLER_33_685 VPWR VGND VPWR VGND sky130_ef_sc_hd__decap_12
XTAP_TAPCELL_ROW_31_831 VGND VPWR sky130_fd_sc_hd__tapvpwrvgnd_1
XFILLER_32_195 VGND VGND VPWR VPWR sky130_fd_sc_hd__fill_1
XFILLER_118_245 VGND VGND VPWR VPWR sky130_fd_sc_hd__decap_6
XFILLER_9_391 VGND VGND VPWR VPWR sky130_fd_sc_hd__fill_1
XFILLER_146_587 VGND VGND VPWR VPWR sky130_fd_sc_hd__fill_1
XFILLER_134_749 VGND VGND VPWR VPWR sky130_fd_sc_hd__decap_6
XFILLER_118_289 VPWR VGND VPWR VGND sky130_ef_sc_hd__decap_12
XFILLER_106_418 VGND VGND VPWR VPWR sky130_fd_sc_hd__fill_2
XANTENNA__1782__A1 A_reg\[7\] VGND VGND VPWR VPWR sky130_fd_sc_hd__diode_2
XFILLER_133_237 VPWR VGND VPWR VGND sky130_ef_sc_hd__decap_12
X_2627_ _0326_ _0353_ _0364_ _0358_ VGND VGND VPWR VPWR _0372_ sky130_fd_sc_hd__a31o_1
XFILLER_102_613 VPWR VGND VPWR VGND sky130_ef_sc_hd__decap_12
XFILLER_88_825 VPWR VGND VPWR VGND sky130_ef_sc_hd__decap_12
X_2558_ _0294_ _0298_ _0295_ VGND VGND VPWR VPWR _0304_ sky130_fd_sc_hd__a21o_1
XFILLER_0_729 VPWR VGND VPWR VGND sky130_ef_sc_hd__decap_12
XFILLER_142_793 VPWR VGND VPWR VGND sky130_ef_sc_hd__decap_12
XFILLER_141_281 VPWR VGND VPWR VGND sky130_ef_sc_hd__decap_12
XFILLER_88_869 VPWR VGND VPWR VGND sky130_ef_sc_hd__decap_12
X_2489_ _0235_ _0236_ VGND VGND VPWR VPWR _0237_ sky130_fd_sc_hd__and2_1
XFILLER_102_657 VPWR VGND VPWR VGND sky130_ef_sc_hd__decap_12
XFILLER_101_167 VGND VGND VPWR VPWR sky130_fd_sc_hd__fill_1
XPHY_EDGE_ROW_106_Right_106 VGND VGND VPWR VPWR sky130_fd_sc_hd__decap_3
XFILLER_83_541 VPWR VGND VPWR VGND sky130_ef_sc_hd__decap_12
XFILLER_56_755 VGND VGND VPWR VPWR sky130_fd_sc_hd__fill_1
XFILLER_28_457 VPWR VGND VPWR VGND sky130_ef_sc_hd__decap_12
XTAP_TAPCELL_ROW_39_953 VGND VPWR sky130_fd_sc_hd__tapvpwrvgnd_1
XFILLER_83_585 VPWR VGND VPWR VGND sky130_ef_sc_hd__decap_12
XTAP_TAPCELL_ROW_48_1106 VGND VPWR sky130_fd_sc_hd__tapvpwrvgnd_1
XFILLER_43_405 VPWR VGND VPWR VGND sky130_ef_sc_hd__decap_12
XFILLER_70_213 VPWR VGND VPWR VGND sky130_ef_sc_hd__decap_12
XFILLER_43_449 VPWR VGND VPWR VGND sky130_ef_sc_hd__decap_12
XFILLER_102_65 VPWR VGND VPWR VGND sky130_ef_sc_hd__decap_12
XTAP_TAPCELL_ROW_61_1306 VGND VPWR sky130_fd_sc_hd__tapvpwrvgnd_1
XFILLER_11_313 VPWR VGND VPWR VGND sky130_ef_sc_hd__decap_12
XFILLER_12_825 VPWR VGND VPWR VGND sky130_ef_sc_hd__decap_12
XFILLER_12_869 VPWR VGND VPWR VGND sky130_ef_sc_hd__decap_12
XFILLER_127_3 VPWR VGND VPWR VGND sky130_ef_sc_hd__decap_12
XFILLER_109_223 VGND VGND VPWR VPWR sky130_fd_sc_hd__fill_1
XFILLER_7_317 VPWR VGND VPWR VGND sky130_ef_sc_hd__decap_12
XFILLER_152_513 VPWR VGND VPWR VGND sky130_ef_sc_hd__decap_12
XFILLER_125_727 VGND VGND VPWR VPWR sky130_fd_sc_hd__fill_1
XFILLER_11_51 VGND VGND VPWR VPWR sky130_fd_sc_hd__decap_4
XFILLER_152_557 VPWR VGND VPWR VGND sky130_ef_sc_hd__decap_12
XFILLER_127_51 VGND VGND VPWR VPWR sky130_fd_sc_hd__decap_4
XANTENNA__3290__CLK clknet_3_2__leaf_clk VGND VGND VPWR VPWR sky130_fd_sc_hd__diode_2
XTAP_TAPCELL_ROW_59_1279 VGND VPWR sky130_fd_sc_hd__tapvpwrvgnd_1
XTAP_TAPCELL_ROW_59_1268 VGND VPWR sky130_fd_sc_hd__tapvpwrvgnd_1
XFILLER_120_421 VPWR VGND VPWR VGND sky130_ef_sc_hd__decap_12
XFILLER_105_473 VPWR VGND VPWR VGND sky130_ef_sc_hd__decap_12
XFILLER_87_77 VPWR VGND VPWR VGND sky130_ef_sc_hd__decap_12
XFILLER_78_357 VGND VGND VPWR VPWR sky130_fd_sc_hd__decap_6
XTAP_TAPCELL_ROW_72_1479 VGND VPWR sky130_fd_sc_hd__tapvpwrvgnd_1
XFILLER_93_305 VPWR VGND VPWR VGND sky130_ef_sc_hd__decap_12
XFILLER_47_722 VGND VGND VPWR VPWR sky130_fd_sc_hd__decap_6
XANTENNA__2509__A _0185_ VGND VGND VPWR VPWR sky130_fd_sc_hd__diode_2
XFILLER_62_725 VPWR VGND VPWR VGND sky130_ef_sc_hd__decap_12
XTAP_TAPCELL_ROW_17_603 VGND VPWR sky130_fd_sc_hd__tapvpwrvgnd_1
XFILLER_46_265 VGND VGND VPWR VPWR sky130_fd_sc_hd__decap_8
XFILLER_62_769 VPWR VGND VPWR VGND sky130_ef_sc_hd__decap_12
XFILLER_15_641 VPWR VGND VPWR VGND sky130_ef_sc_hd__decap_12
XFILLER_70_780 VPWR VGND VPWR VGND sky130_ef_sc_hd__decap_12
XFILLER_61_279 VGND VGND VPWR VPWR sky130_fd_sc_hd__fill_1
XFILLER_15_685 VPWR VGND VPWR VGND sky130_ef_sc_hd__decap_12
XFILLER_14_195 VGND VGND VPWR VPWR sky130_fd_sc_hd__fill_1
X_1860_ A_reg\[8\] _1127_ _1129_ VGND VGND VPWR VPWR _1130_ sky130_fd_sc_hd__o21a_1
XANTENNA__2244__A A_reg\[4\] VGND VGND VPWR VPWR sky130_fd_sc_hd__diode_2
XFILLER_147_329 VGND VGND VPWR VPWR sky130_fd_sc_hd__decap_6
Xinput12 A_in[5] VGND VGND VPWR VPWR net12 sky130_fd_sc_hd__buf_1
XFILLER_30_699 VGND VGND VPWR VPWR sky130_fd_sc_hd__fill_1
X_1791_ A_reg\[6\] _1061_ _1055_ VGND VGND VPWR VPWR _1064_ sky130_fd_sc_hd__o21ai_1
XANTENNA__3202__A1 _0912_ VGND VGND VPWR VPWR sky130_fd_sc_hd__diode_2
Xinput34 Op_Sel[1] VGND VGND VPWR VPWR net34 sky130_fd_sc_hd__dlymetal6s2s_1
Xinput23 B_in[15] VGND VGND VPWR VPWR net23 sky130_fd_sc_hd__clkbuf_1
XFILLER_128_587 VGND VGND VPWR VPWR sky130_fd_sc_hd__fill_1
XFILLER_7_895 VGND VGND VPWR VPWR sky130_fd_sc_hd__fill_1
XFILLER_116_749 VGND VGND VPWR VPWR sky130_fd_sc_hd__decap_6
XFILLER_115_237 VPWR VGND VPWR VGND sky130_ef_sc_hd__decap_12
X_2412_ _0155_ _0164_ _0909_ VGND VGND VPWR VPWR _0166_ sky130_fd_sc_hd__a21oi_1
XFILLER_42_3 VPWR VGND VPWR VGND sky130_ef_sc_hd__decap_12
XFILLER_124_793 VPWR VGND VPWR VGND sky130_ef_sc_hd__decap_12
XFILLER_123_281 VPWR VGND VPWR VGND sky130_ef_sc_hd__decap_12
XFILLER_96_121 VPWR VGND VPWR VGND sky130_ef_sc_hd__decap_12
X_2343_ _1587_ _1589_ _1583_ VGND VGND VPWR VPWR _1596_ sky130_fd_sc_hd__a21bo_1
XFILLER_96_165 VGND VGND VPWR VPWR sky130_fd_sc_hd__decap_6
XFILLER_85_839 VGND VGND VPWR VPWR sky130_fd_sc_hd__fill_1
X_2274_ A_reg\[1\] _1530_ VGND VGND VPWR VPWR _1531_ sky130_fd_sc_hd__xor2_2
XANTENNA_clkbuf_3_6__f_clk_A clknet_0_clk VGND VGND VPWR VPWR sky130_fd_sc_hd__diode_2
XFILLER_38_755 VGND VGND VPWR VPWR sky130_fd_sc_hd__fill_1
XTAP_TAPCELL_ROW_36_901 VGND VPWR sky130_fd_sc_hd__tapvpwrvgnd_1
XTAP_TAPCELL_ROW_36_912 VGND VPWR sky130_fd_sc_hd__tapvpwrvgnd_1
XANTENNA__2853__S _0383_ VGND VGND VPWR VPWR sky130_fd_sc_hd__diode_2
XFILLER_80_533 VGND VGND VPWR VPWR sky130_fd_sc_hd__decap_4
XFILLER_65_585 VGND VGND VPWR VPWR sky130_fd_sc_hd__decap_6
XFILLER_16_29 VPWR VGND VPWR VGND sky130_ef_sc_hd__decap_12
XFILLER_25_449 VPWR VGND VPWR VGND sky130_ef_sc_hd__decap_12
XFILLER_40_408 VPWR VGND VPWR VGND sky130_ef_sc_hd__decap_12
XFILLER_41_909 VGND VGND VPWR VPWR sky130_fd_sc_hd__fill_1
XFILLER_52_279 VPWR VGND VPWR VGND sky130_ef_sc_hd__decap_12
XTAP_TAPCELL_ROW_43_1014 VGND VPWR sky130_fd_sc_hd__tapvpwrvgnd_1
XTAP_TAPCELL_ROW_43_1025 VGND VPWR sky130_fd_sc_hd__tapvpwrvgnd_1
XTAP_TAPCELL_ROW_138_2542 VGND VPWR sky130_fd_sc_hd__tapvpwrvgnd_1
XFILLER_138_307 VGND VGND VPWR VPWR sky130_fd_sc_hd__fill_1
XFILLER_20_121 VPWR VGND VPWR VGND sky130_ef_sc_hd__decap_12
XFILLER_33_493 VGND VGND VPWR VPWR sky130_fd_sc_hd__fill_2
XFILLER_20_165 VPWR VGND VPWR VGND sky130_ef_sc_hd__decap_12
XFILLER_147_841 VPWR VGND VPWR VGND sky130_ef_sc_hd__decap_12
XANTENNA__2438__A_N OpSel_reg\[0\] VGND VGND VPWR VPWR sky130_fd_sc_hd__diode_2
X_1989_ b_r2\[1\] _1252_ Encode_EN VGND VGND VPWR VPWR _0012_ sky130_fd_sc_hd__mux2_1
XTAP_TAPCELL_ROW_151_2753 VGND VPWR sky130_fd_sc_hd__tapvpwrvgnd_1
XTAP_TAPCELL_ROW_151_2742 VGND VPWR sky130_fd_sc_hd__tapvpwrvgnd_1
XFILLER_134_513 VPWR VGND VPWR VGND sky130_ef_sc_hd__decap_12
XFILLER_107_727 VGND VGND VPWR VPWR sky130_fd_sc_hd__fill_1
XFILLER_4_309 VGND VGND VPWR VPWR sky130_fd_sc_hd__decap_3
XFILLER_134_557 VPWR VGND VPWR VGND sky130_ef_sc_hd__decap_12
XFILLER_106_8 VPWR VGND VPWR VGND sky130_ef_sc_hd__decap_12
XFILLER_102_432 VGND VGND VPWR VPWR sky130_fd_sc_hd__fill_1
XFILLER_88_666 VPWR VGND VPWR VGND sky130_ef_sc_hd__decap_12
XFILLER_0_559 VGND VGND VPWR VPWR sky130_fd_sc_hd__fill_1
XTAP_TAPCELL_ROW_54_1198 VGND VPWR sky130_fd_sc_hd__tapvpwrvgnd_1
XFILLER_91_809 VPWR VGND VPWR VGND sky130_ef_sc_hd__decap_12
XFILLER_75_349 VPWR VGND VPWR VGND sky130_ef_sc_hd__decap_12
XFILLER_84_861 VGND VGND VPWR VPWR sky130_fd_sc_hd__decap_6
XTAP_TAPCELL_ROW_3_386 VGND VPWR sky130_fd_sc_hd__tapvpwrvgnd_1
XTAP_TAPCELL_ROW_3_375 VGND VPWR sky130_fd_sc_hd__tapvpwrvgnd_1
XFILLER_28_265 VPWR VGND VPWR VGND sky130_ef_sc_hd__decap_12
XFILLER_29_777 VGND VGND VPWR VPWR sky130_fd_sc_hd__decap_6
XFILLER_83_393 VPWR VGND VPWR VGND sky130_ef_sc_hd__decap_12
XFILLER_43_202 VGND VGND VPWR VPWR sky130_fd_sc_hd__fill_2
XFILLER_73_57 VPWR VGND VPWR VGND sky130_ef_sc_hd__decap_12
XFILLER_71_588 VPWR VGND VPWR VGND sky130_ef_sc_hd__decap_12
XANTENNA__2064__A B_reg\[4\] VGND VGND VPWR VPWR sky130_fd_sc_hd__diode_2
XFILLER_129_329 VGND VGND VPWR VPWR sky130_fd_sc_hd__decap_6
XFILLER_8_637 VGND VGND VPWR VPWR sky130_fd_sc_hd__decap_6
XFILLER_7_125 VPWR VGND VPWR VGND sky130_ef_sc_hd__decap_12
XFILLER_12_699 VGND VGND VPWR VPWR sky130_fd_sc_hd__fill_1
XTAP_TAPCELL_ROW_22_683 VGND VPWR sky130_fd_sc_hd__tapvpwrvgnd_1
XFILLER_137_373 VPWR VGND VPWR VGND sky130_ef_sc_hd__decap_12
XFILLER_7_169 VPWR VGND VPWR VGND sky130_ef_sc_hd__decap_12
XFILLER_22_83 VGND VGND VPWR VPWR sky130_fd_sc_hd__fill_1
XFILLER_152_321 VPWR VGND VPWR VGND sky130_ef_sc_hd__decap_12
XFILLER_138_83 VGND VGND VPWR VPWR sky130_fd_sc_hd__fill_1
XFILLER_99_909 VGND VGND VPWR VPWR sky130_fd_sc_hd__fill_1
XTAP_TAPCELL_ROW_74_1519 VGND VPWR sky130_fd_sc_hd__tapvpwrvgnd_1
XTAP_TAPCELL_ROW_74_1508 VGND VPWR sky130_fd_sc_hd__tapvpwrvgnd_1
XFILLER_152_365 VPWR VGND VPWR VGND sky130_ef_sc_hd__decap_12
XFILLER_98_65 VPWR VGND VPWR VGND sky130_ef_sc_hd__decap_12
XFILLER_106_793 VPWR VGND VPWR VGND sky130_ef_sc_hd__decap_12
XFILLER_78_110 VPWR VGND VPWR VGND sky130_ef_sc_hd__decap_12
XFILLER_3_386 VGND VGND VPWR VPWR sky130_fd_sc_hd__decap_6
XFILLER_121_741 VPWR VGND VPWR VGND sky130_ef_sc_hd__decap_12
XFILLER_105_281 VPWR VGND VPWR VGND sky130_ef_sc_hd__decap_12
XFILLER_121_785 VPWR VGND VPWR VGND sky130_ef_sc_hd__decap_12
XFILLER_120_251 VGND VGND VPWR VPWR sky130_fd_sc_hd__fill_1
XFILLER_94_625 VPWR VGND VPWR VGND sky130_ef_sc_hd__decap_12
XFILLER_93_113 VPWR VGND VPWR VGND sky130_ef_sc_hd__decap_12
XFILLER_78_165 VPWR VGND VPWR VGND sky130_ef_sc_hd__decap_12
XFILLER_67_839 VGND VGND VPWR VPWR sky130_fd_sc_hd__fill_1
XFILLER_94_669 VPWR VGND VPWR VGND sky130_ef_sc_hd__decap_12
XTAP_TAPCELL_ROW_89_1751 VGND VPWR sky130_fd_sc_hd__tapvpwrvgnd_1
XFILLER_47_530 VPWR VGND VPWR VGND sky130_ef_sc_hd__decap_12
XTAP_TAPCELL_ROW_105_2018 VGND VPWR sky130_fd_sc_hd__tapvpwrvgnd_1
XTAP_TAPCELL_ROW_105_2007 VGND VPWR sky130_fd_sc_hd__tapvpwrvgnd_1
XTAP_TAPCELL_ROW_89_1762 VGND VPWR sky130_fd_sc_hd__tapvpwrvgnd_1
XFILLER_62_500 VPWR VGND VPWR VGND sky130_ef_sc_hd__decap_12
XFILLER_74_382 VPWR VGND VPWR VGND sky130_ef_sc_hd__decap_12
XFILLER_62_533 VPWR VGND VPWR VGND sky130_ef_sc_hd__decap_12
XFILLER_62_522 VGND VGND VPWR VPWR sky130_fd_sc_hd__decap_3
XFILLER_47_585 VPWR VGND VPWR VGND sky130_ef_sc_hd__decap_12
XFILLER_23_909 VGND VGND VPWR VPWR sky130_fd_sc_hd__fill_1
X_2961_ _0573_ _0648_ VGND VGND VPWR VPWR _0649_ sky130_fd_sc_hd__nand2_1
XFILLER_22_419 VGND VGND VPWR VPWR sky130_fd_sc_hd__fill_1
X_1912_ B_reg\[14\] B_reg\[15\] VGND VGND VPWR VPWR _1177_ sky130_fd_sc_hd__nand2b_1
X_2892_ u_crt.r3\[2\] _0565_ VGND VGND VPWR VPWR _0580_ sky130_fd_sc_hd__nand2_4
XFILLER_8_41 VPWR VGND VPWR VGND sky130_ef_sc_hd__decap_12
XFILLER_147_137 VPWR VGND VPWR VGND sky130_ef_sc_hd__decap_12
XFILLER_129_841 VPWR VGND VPWR VGND sky130_ef_sc_hd__decap_12
X_1843_ _1011_ _1112_ A_reg\[12\] VGND VGND VPWR VPWR _1113_ sky130_fd_sc_hd__o21ai_1
XFILLER_8_85 VPWR VGND VPWR VGND sky130_ef_sc_hd__decap_12
XTAP_TAPCELL_ROW_41_981 VGND VPWR sky130_fd_sc_hd__tapvpwrvgnd_1
XTAP_TAPCELL_ROW_41_992 VGND VPWR sky130_fd_sc_hd__tapvpwrvgnd_1
XANTENNA__3187__B1 _0912_ VGND VGND VPWR VPWR sky130_fd_sc_hd__diode_2
XFILLER_144_811 VGND VGND VPWR VPWR sky130_fd_sc_hd__fill_1
XFILLER_116_513 VPWR VGND VPWR VGND sky130_ef_sc_hd__decap_12
XANTENNA__1737__A1 A_reg\[13\] VGND VGND VPWR VPWR sky130_fd_sc_hd__diode_2
X_1774_ _1040_ _1042_ _1046_ VGND VGND VPWR VPWR _1047_ sky130_fd_sc_hd__a21o_1
XTAP_TAPCELL_ROW_133_2461 VGND VPWR sky130_fd_sc_hd__tapvpwrvgnd_1
XFILLER_131_505 VPWR VGND VPWR VGND sky130_ef_sc_hd__decap_12
XFILLER_116_557 VPWR VGND VPWR VGND sky130_ef_sc_hd__decap_12
XFILLER_89_419 VGND VGND VPWR VPWR sky130_fd_sc_hd__decap_6
XANTENNA__2848__S _0383_ VGND VGND VPWR VPWR sky130_fd_sc_hd__diode_2
XFILLER_111_273 VGND VGND VPWR VPWR sky130_fd_sc_hd__decap_6
XFILLER_97_485 VPWR VGND VPWR VGND sky130_ef_sc_hd__decap_12
XFILLER_69_165 VGND VGND VPWR VPWR sky130_fd_sc_hd__decap_3
X_2326_ _1574_ _1575_ _1578_ VGND VGND VPWR VPWR _1579_ sky130_fd_sc_hd__a21o_1
XFILLER_57_305 VPWR VGND VPWR VGND sky130_ef_sc_hd__decap_12
XFILLER_85_647 VGND VGND VPWR VPWR sky130_fd_sc_hd__fill_1
XFILLER_73_809 VPWR VGND VPWR VGND sky130_ef_sc_hd__decap_12
XFILLER_57_349 VPWR VGND VPWR VGND sky130_ef_sc_hd__decap_12
X_2257_ _1499_ _1506_ _1504_ VGND VGND VPWR VPWR _1514_ sky130_fd_sc_hd__o21ai_1
XFILLER_150_29 VPWR VGND VPWR VGND sky130_ef_sc_hd__decap_12
XFILLER_66_861 VGND VGND VPWR VPWR sky130_fd_sc_hd__decap_6
XFILLER_53_500 VGND VGND VPWR VPWR sky130_fd_sc_hd__fill_1
XTAP_TAPCELL_ROW_0_312 VGND VPWR sky130_fd_sc_hd__tapvpwrvgnd_1
XFILLER_27_39 VPWR VGND VPWR VGND sky130_ef_sc_hd__decap_12
XFILLER_65_393 VPWR VGND VPWR VGND sky130_ef_sc_hd__decap_12
XTAP_TAPCELL_ROW_0_323 VGND VPWR sky130_fd_sc_hd__tapvpwrvgnd_1
XTAP_TAPCELL_ROW_0_334 VGND VPWR sky130_fd_sc_hd__tapvpwrvgnd_1
X_2188_ _1443_ _1444_ VGND VGND VPWR VPWR _1445_ sky130_fd_sc_hd__nand2_1
XFILLER_26_725 VPWR VGND VPWR VGND sky130_ef_sc_hd__decap_12
XANTENNA__2436__X _0186_ VGND VGND VPWR VPWR sky130_fd_sc_hd__diode_2
XFILLER_81_853 VPWR VGND VPWR VGND sky130_ef_sc_hd__decap_12
XFILLER_14_909 VGND VGND VPWR VPWR sky130_fd_sc_hd__fill_1
XFILLER_26_769 VPWR VGND VPWR VGND sky130_ef_sc_hd__decap_12
XFILLER_81_897 VPWR VGND VPWR VGND sky130_ef_sc_hd__decap_12
XFILLER_80_374 VGND VGND VPWR VPWR sky130_fd_sc_hd__fill_1
XFILLER_80_363 VGND VGND VPWR VPWR sky130_fd_sc_hd__fill_1
XFILLER_53_577 VGND VGND VPWR VPWR sky130_fd_sc_hd__fill_1
XFILLER_25_279 VGND VGND VPWR VPWR sky130_fd_sc_hd__fill_1
XFILLER_43_27 VPWR VGND VPWR VGND sky130_ef_sc_hd__decap_12
XFILLER_21_485 VPWR VGND VPWR VGND sky130_ef_sc_hd__decap_12
XFILLER_147_671 VGND VGND VPWR VPWR sky130_fd_sc_hd__fill_1
XFILLER_119_373 VPWR VGND VPWR VGND sky130_ef_sc_hd__decap_12
XFILLER_107_502 VGND VGND VPWR VPWR sky130_fd_sc_hd__fill_2
XFILLER_135_833 VGND VGND VPWR VPWR sky130_fd_sc_hd__decap_6
XFILLER_134_321 VPWR VGND VPWR VGND sky130_ef_sc_hd__decap_12
XFILLER_107_546 VPWR VGND VPWR VGND sky130_ef_sc_hd__decap_12
XFILLER_107_535 VGND VGND VPWR VPWR sky130_fd_sc_hd__decap_4
XFILLER_4_139 VGND VGND VPWR VPWR sky130_fd_sc_hd__fill_1
XFILLER_135_877 VPWR VGND VPWR VGND sky130_ef_sc_hd__decap_12
XFILLER_134_365 VPWR VGND VPWR VGND sky130_ef_sc_hd__decap_12
XFILLER_108_53 VPWR VGND VPWR VGND sky130_ef_sc_hd__decap_12
XTAP_TAPCELL_ROW_56_1227 VGND VPWR sky130_fd_sc_hd__tapvpwrvgnd_1
XFILLER_150_825 VPWR VGND VPWR VGND sky130_ef_sc_hd__decap_12
XFILLER_68_35 VPWR VGND VPWR VGND sky130_ef_sc_hd__decap_12
XFILLER_150_869 VPWR VGND VPWR VGND sky130_ef_sc_hd__decap_12
XFILLER_108_97 VPWR VGND VPWR VGND sky130_ef_sc_hd__decap_12
XFILLER_103_741 VPWR VGND VPWR VGND sky130_ef_sc_hd__decap_12
XTAP_TAPCELL_ROW_8_467 VGND VPWR sky130_fd_sc_hd__tapvpwrvgnd_1
XTAP_TAPCELL_ROW_8_456 VGND VPWR sky130_fd_sc_hd__tapvpwrvgnd_1
XFILLER_103_785 VPWR VGND VPWR VGND sky130_ef_sc_hd__decap_12
XFILLER_102_251 VGND VGND VPWR VPWR sky130_fd_sc_hd__fill_1
XFILLER_49_839 VGND VGND VPWR VPWR sky130_fd_sc_hd__fill_1
XFILLER_0_389 VGND VGND VPWR VPWR sky130_fd_sc_hd__decap_3
XFILLER_124_41 VPWR VGND VPWR VGND sky130_ef_sc_hd__decap_12
XFILLER_75_135 VPWR VGND VPWR VGND sky130_ef_sc_hd__decap_12
XFILLER_75_113 VGND VGND VPWR VPWR sky130_fd_sc_hd__decap_4
XFILLER_124_85 VPWR VGND VPWR VGND sky130_ef_sc_hd__decap_12
XFILLER_91_617 VPWR VGND VPWR VGND sky130_ef_sc_hd__decap_12
XFILLER_63_319 VPWR VGND VPWR VGND sky130_ef_sc_hd__decap_12
XFILLER_84_67 VPWR VGND VPWR VGND sky130_ef_sc_hd__decap_12
XFILLER_44_533 VPWR VGND VPWR VGND sky130_ef_sc_hd__decap_12
XTAP_TAPCELL_ROW_84_1681 VGND VPWR sky130_fd_sc_hd__tapvpwrvgnd_1
XTAP_TAPCELL_ROW_84_1670 VGND VPWR sky130_fd_sc_hd__tapvpwrvgnd_1
XFILLER_71_385 VGND VGND VPWR VPWR sky130_fd_sc_hd__decap_6
XTAP_TAPCELL_ROW_27_764 VGND VPWR sky130_fd_sc_hd__tapvpwrvgnd_1
XFILLER_31_205 VPWR VGND VPWR VGND sky130_ef_sc_hd__decap_12
XFILLER_31_249 VPWR VGND VPWR VGND sky130_ef_sc_hd__decap_12
XFILLER_40_750 VGND VGND VPWR VPWR sky130_fd_sc_hd__decap_6
XFILLER_40_772 VGND VGND VPWR VPWR sky130_fd_sc_hd__fill_1
XFILLER_129_137 VPWR VGND VPWR VGND sky130_ef_sc_hd__decap_12
XFILLER_8_434 VPWR VGND VPWR VGND sky130_ef_sc_hd__decap_12
XFILLER_33_93 VPWR VGND VPWR VGND sky130_ef_sc_hd__decap_12
XFILLER_149_93 VPWR VGND VPWR VGND sky130_ef_sc_hd__decap_12
XFILLER_126_811 VGND VGND VPWR VPWR sky130_fd_sc_hd__fill_1
XFILLER_8_489 VPWR VGND VPWR VGND sky130_ef_sc_hd__decap_12
XFILLER_153_641 VGND VGND VPWR VPWR sky130_fd_sc_hd__decap_3
XFILLER_138_693 VGND VGND VPWR VPWR sky130_fd_sc_hd__decap_6
XFILLER_137_181 VPWR VGND VPWR VGND sky130_ef_sc_hd__decap_12
XFILLER_113_505 VPWR VGND VPWR VGND sky130_ef_sc_hd__decap_12
XFILLER_153_685 VPWR VGND VPWR VGND sky130_ef_sc_hd__decap_12
XFILLER_3_161 VGND VGND VPWR VPWR sky130_fd_sc_hd__decap_6
XFILLER_152_195 VGND VGND VPWR VPWR sky130_fd_sc_hd__fill_1
XFILLER_140_357 VGND VGND VPWR VPWR sky130_fd_sc_hd__decap_6
XANTENNA__2144__A1 B_reg\[1\] VGND VGND VPWR VPWR sky130_fd_sc_hd__diode_2
XFILLER_79_485 VPWR VGND VPWR VGND sky130_ef_sc_hd__decap_12
XFILLER_39_305 VPWR VGND VPWR VGND sky130_ef_sc_hd__decap_12
X_3160_ _0815_ _0827_ _0839_ _0813_ VGND VGND VPWR VPWR _0848_ sky130_fd_sc_hd__o2bb2a_1
X_2111_ B_reg\[10\] _1367_ _1368_ VGND VGND VPWR VPWR _1370_ sky130_fd_sc_hd__o21a_1
X_3091_ _0663_ _0679_ _0764_ VGND VGND VPWR VPWR _0779_ sky130_fd_sc_hd__or3_1
XFILLER_55_809 VGND VGND VPWR VPWR sky130_fd_sc_hd__decap_8
XFILLER_39_349 VPWR VGND VPWR VGND sky130_ef_sc_hd__decap_12
XFILLER_94_477 VPWR VGND VPWR VGND sky130_ef_sc_hd__decap_12
X_2042_ _1285_ _1294_ _1303_ VGND VGND VPWR VPWR _1304_ sky130_fd_sc_hd__o21a_1
XFILLER_81_105 VGND VGND VPWR VPWR sky130_fd_sc_hd__decap_6
XFILLER_63_853 VPWR VGND VPWR VGND sky130_ef_sc_hd__decap_12
XFILLER_47_393 VPWR VGND VPWR VGND sky130_ef_sc_hd__decap_12
XFILLER_63_897 VPWR VGND VPWR VGND sky130_ef_sc_hd__decap_12
XFILLER_62_363 VGND VGND VPWR VPWR sky130_fd_sc_hd__fill_1
XFILLER_50_525 VGND VGND VPWR VPWR sky130_fd_sc_hd__decap_6
XPHY_EDGE_ROW_8_Right_8 VGND VGND VPWR VPWR sky130_fd_sc_hd__decap_3
XFILLER_148_413 VGND VGND VPWR VPWR sky130_fd_sc_hd__decap_6
X_2944_ _0581_ _0630_ _0631_ VGND VGND VPWR VPWR _0632_ sky130_fd_sc_hd__or3_1
XANTENNA__1958__A1 B_reg\[5\] VGND VGND VPWR VPWR sky130_fd_sc_hd__diode_2
XFILLER_148_457 VPWR VGND VPWR VGND sky130_ef_sc_hd__decap_12
X_2875_ u_crt.r2\[1\] _0562_ VGND VGND VPWR VPWR _0563_ sky130_fd_sc_hd__nand2_2
XFILLER_31_783 VGND VGND VPWR VPWR sky130_fd_sc_hd__fill_1
XFILLER_129_671 VGND VGND VPWR VPWR sky130_fd_sc_hd__fill_1
X_1826_ _1093_ _1096_ _1098_ VGND VGND VPWR VPWR _1099_ sky130_fd_sc_hd__a21oi_1
XFILLER_117_833 VGND VGND VPWR VPWR sky130_fd_sc_hd__decap_6
XFILLER_116_321 VPWR VGND VPWR VGND sky130_ef_sc_hd__decap_12
XFILLER_117_877 VPWR VGND VPWR VGND sky130_ef_sc_hd__decap_12
XFILLER_116_365 VPWR VGND VPWR VGND sky130_ef_sc_hd__decap_12
X_1757_ _1028_ _1029_ VGND VGND VPWR VPWR _1030_ sky130_fd_sc_hd__nand2_1
XFILLER_132_825 VPWR VGND VPWR VGND sky130_ef_sc_hd__decap_12
XFILLER_89_205 VGND VGND VPWR VPWR sky130_fd_sc_hd__decap_8
X_1688_ _0953_ _0955_ VGND VGND VPWR VPWR _0964_ sky130_fd_sc_hd__xnor2_1
XFILLER_132_869 VPWR VGND VPWR VGND sky130_ef_sc_hd__decap_12
XFILLER_131_335 VGND VGND VPWR VPWR sky130_fd_sc_hd__fill_1
XTAP_TAPCELL_ROW_5_404 VGND VPWR sky130_fd_sc_hd__tapvpwrvgnd_1
XPHY_EDGE_ROW_39_Right_39 VGND VGND VPWR VPWR sky130_fd_sc_hd__decap_3
XFILLER_58_614 VPWR VGND VPWR VGND sky130_ef_sc_hd__decap_12
XTAP_TAPCELL_ROW_5_415 VGND VPWR sky130_fd_sc_hd__tapvpwrvgnd_1
XFILLER_38_27 VGND VGND VPWR VPWR sky130_fd_sc_hd__fill_1
XFILLER_58_658 VPWR VGND VPWR VGND sky130_ef_sc_hd__decap_12
XFILLER_57_113 VPWR VGND VPWR VGND sky130_ef_sc_hd__decap_12
X_2309_ _1560_ _1561_ VGND VGND VPWR VPWR _1562_ sky130_fd_sc_hd__nor2_1
XTAP_TAPCELL_ROW_51_1146 VGND VPWR sky130_fd_sc_hd__tapvpwrvgnd_1
XTAP_TAPCELL_ROW_146_2674 VGND VPWR sky130_fd_sc_hd__tapvpwrvgnd_1
XTAP_TAPCELL_ROW_146_2663 VGND VPWR sky130_fd_sc_hd__tapvpwrvgnd_1
XFILLER_100_755 VGND VGND VPWR VPWR sky130_fd_sc_hd__fill_1
XFILLER_73_617 VPWR VGND VPWR VGND sky130_ef_sc_hd__decap_12
X_3289_ clknet_3_5__leaf_clk _0072_ net36 VGND VGND VPWR VPWR A_reg\[15\] sky130_fd_sc_hd__dfrtp_4
XANTENNA__1894__B1 net37 VGND VGND VPWR VPWR sky130_fd_sc_hd__diode_2
XFILLER_39_894 VGND VGND VPWR VPWR sky130_fd_sc_hd__fill_2
XFILLER_72_149 VPWR VGND VPWR VGND sky130_ef_sc_hd__decap_12
XFILLER_26_533 VGND VGND VPWR VPWR sky130_fd_sc_hd__fill_2
XFILLER_13_205 VPWR VGND VPWR VGND sky130_ef_sc_hd__decap_12
XTAP_TAPCELL_ROW_24_712 VGND VPWR sky130_fd_sc_hd__tapvpwrvgnd_1
XFILLER_41_503 VGND VGND VPWR VPWR sky130_fd_sc_hd__fill_1
XFILLER_53_385 VGND VGND VPWR VPWR sky130_fd_sc_hd__decap_6
XPHY_EDGE_ROW_48_Right_48 VGND VGND VPWR VPWR sky130_fd_sc_hd__decap_3
XTAP_TAPCELL_ROW_24_723 VGND VPWR sky130_fd_sc_hd__tapvpwrvgnd_1
XFILLER_110_65 VPWR VGND VPWR VGND sky130_ef_sc_hd__decap_12
XANTENNA__3277__RESET_B net36 VGND VGND VPWR VPWR sky130_fd_sc_hd__diode_2
XFILLER_108_811 VGND VGND VPWR VPWR sky130_fd_sc_hd__fill_1
XFILLER_6_905 VGND VGND VPWR VPWR sky130_fd_sc_hd__decap_4
XFILLER_5_404 VGND VGND VPWR VPWR sky130_fd_sc_hd__fill_1
XFILLER_21_293 VPWR VGND VPWR VGND sky130_ef_sc_hd__decap_12
XFILLER_119_181 VPWR VGND VPWR VGND sky130_ef_sc_hd__decap_12
XFILLER_135_641 VPWR VGND VPWR VGND sky130_ef_sc_hd__decap_12
XFILLER_135_685 VPWR VGND VPWR VGND sky130_ef_sc_hd__decap_12
XPHY_EDGE_ROW_57_Right_57 VGND VGND VPWR VPWR sky130_fd_sc_hd__decap_3
XFILLER_134_195 VGND VGND VPWR VPWR sky130_fd_sc_hd__fill_1
XFILLER_122_357 VGND VGND VPWR VPWR sky130_fd_sc_hd__decap_6
XANTENNA__2126__A1 B_reg\[6\] VGND VGND VPWR VPWR sky130_fd_sc_hd__diode_2
XFILLER_150_699 VGND VGND VPWR VPWR sky130_fd_sc_hd__fill_1
XFILLER_135_51 VGND VGND VPWR VPWR sky130_fd_sc_hd__decap_4
XFILLER_89_783 VGND VGND VPWR VPWR sky130_fd_sc_hd__fill_1
XFILLER_0_153 VPWR VGND VPWR VGND sky130_ef_sc_hd__decap_12
XFILLER_1_665 VGND VGND VPWR VPWR sky130_fd_sc_hd__decap_6
XFILLER_95_55 VGND VGND VPWR VPWR sky130_fd_sc_hd__fill_1
XANTENNA__2677__A2 _0186_ VGND VGND VPWR VPWR sky130_fd_sc_hd__diode_2
XFILLER_76_433 VPWR VGND VPWR VGND sky130_ef_sc_hd__decap_12
XFILLER_49_658 VPWR VGND VPWR VGND sky130_ef_sc_hd__decap_12
XFILLER_0_197 VPWR VGND VPWR VGND sky130_ef_sc_hd__decap_12
XFILLER_95_99 VPWR VGND VPWR VGND sky130_ef_sc_hd__decap_12
XFILLER_76_477 VPWR VGND VPWR VGND sky130_ef_sc_hd__decap_12
XPHY_EDGE_ROW_48_Left_202 VGND VGND VPWR VPWR sky130_fd_sc_hd__decap_3
XFILLER_37_809 VPWR VGND VPWR VGND sky130_ef_sc_hd__decap_12
XTAP_TAPCELL_ROW_86_1710 VGND VPWR sky130_fd_sc_hd__tapvpwrvgnd_1
XTAP_TAPCELL_ROW_69_1429 VGND VPWR sky130_fd_sc_hd__tapvpwrvgnd_1
XFILLER_91_469 VGND VGND VPWR VPWR sky130_fd_sc_hd__fill_1
XFILLER_29_393 VPWR VGND VPWR VGND sky130_ef_sc_hd__decap_12
XFILLER_45_853 VGND VGND VPWR VPWR sky130_fd_sc_hd__fill_2
XPHY_EDGE_ROW_66_Right_66 VGND VGND VPWR VPWR sky130_fd_sc_hd__decap_3
XFILLER_44_363 VGND VGND VPWR VPWR sky130_fd_sc_hd__fill_1
XFILLER_45_897 VPWR VGND VPWR VGND sky130_ef_sc_hd__decap_12
XFILLER_71_193 VPWR VGND VPWR VGND sky130_ef_sc_hd__decap_12
XANTENNA__3224__CLK clknet_3_3__leaf_clk VGND VGND VPWR VPWR sky130_fd_sc_hd__diode_2
XFILLER_60_867 VGND VGND VPWR VPWR sky130_fd_sc_hd__fill_1
XPHY_EDGE_ROW_57_Left_211 VGND VGND VPWR VPWR sky130_fd_sc_hd__decap_3
XFILLER_9_721 VGND VGND VPWR VPWR sky130_fd_sc_hd__decap_6
XFILLER_13_783 VGND VGND VPWR VPWR sky130_fd_sc_hd__fill_1
XFILLER_145_405 VPWR VGND VPWR VGND sky130_ef_sc_hd__decap_12
X_2660_ b_r3\[2\] _0398_ VGND VGND VPWR VPWR _0400_ sky130_fd_sc_hd__xnor2_1
XANTENNA__2252__A A_reg\[2\] VGND VGND VPWR VPWR sky130_fd_sc_hd__diode_2
XFILLER_9_765 VPWR VGND VPWR VGND sky130_ef_sc_hd__decap_12
XFILLER_8_253 VPWR VGND VPWR VGND sky130_ef_sc_hd__decap_12
XFILLER_145_449 VPWR VGND VPWR VGND sky130_ef_sc_hd__decap_12
X_1611_ A_reg\[8\] VGND VGND VPWR VPWR _0891_ sky130_fd_sc_hd__inv_2
XTAP_TAPCELL_ROW_113_2139 VGND VPWR sky130_fd_sc_hd__tapvpwrvgnd_1
XTAP_TAPCELL_ROW_97_1883 VGND VPWR sky130_fd_sc_hd__tapvpwrvgnd_1
XPHY_EDGE_ROW_75_Right_75 VGND VGND VPWR VPWR sky130_fd_sc_hd__decap_3
X_2591_ b_r2\[2\] _0328_ _0329_ VGND VGND VPWR VPWR _0336_ sky130_fd_sc_hd__nand3_1
XTAP_TAPCELL_ROW_10_494 VGND VPWR sky130_fd_sc_hd__tapvpwrvgnd_1
XFILLER_114_825 VPWR VGND VPWR VGND sky130_ef_sc_hd__decap_12
XFILLER_140_121 VPWR VGND VPWR VGND sky130_ef_sc_hd__decap_12
XFILLER_114_869 VPWR VGND VPWR VGND sky130_ef_sc_hd__decap_12
XFILLER_113_335 VGND VGND VPWR VPWR sky130_fd_sc_hd__fill_1
XFILLER_4_481 VGND VGND VPWR VPWR sky130_fd_sc_hd__fill_1
XFILLER_140_165 VPWR VGND VPWR VGND sky130_ef_sc_hd__decap_12
X_3212_ clknet_3_1__leaf_clk _0000_ net36 VGND VGND VPWR VPWR a_r2\[0\] sky130_fd_sc_hd__dfrtp_4
XFILLER_79_293 VGND VGND VPWR VPWR sky130_fd_sc_hd__decap_8
XPHY_EDGE_ROW_66_Left_220 VGND VGND VPWR VPWR sky130_fd_sc_hd__decap_3
XFILLER_39_113 VPWR VGND VPWR VGND sky130_ef_sc_hd__decap_12
XFILLER_95_753 VPWR VGND VPWR VGND sky130_ef_sc_hd__decap_12
X_3143_ _0829_ _0830_ VGND VGND VPWR VPWR _0831_ sky130_fd_sc_hd__or2_1
XTAP_TAPCELL_ROW_128_2382 VGND VPWR sky130_fd_sc_hd__tapvpwrvgnd_1
XFILLER_95_797 VPWR VGND VPWR VGND sky130_ef_sc_hd__decap_12
XPHY_EDGE_ROW_84_Right_84 VGND VGND VPWR VPWR sky130_fd_sc_hd__decap_3
X_3074_ _0730_ _0761_ _0721_ VGND VGND VPWR VPWR _0762_ sky130_fd_sc_hd__o21a_1
X_2025_ _1275_ _1280_ _1283_ _1279_ VGND VGND VPWR VPWR _1287_ sky130_fd_sc_hd__a22o_1
XTAP_TAPCELL_ROW_141_2582 VGND VPWR sky130_fd_sc_hd__tapvpwrvgnd_1
XFILLER_51_823 VPWR VGND VPWR VGND sky130_ef_sc_hd__decap_12
XFILLER_23_503 VGND VGND VPWR VPWR sky130_fd_sc_hd__fill_1
XTAP_TAPCELL_ROW_141_2593 VGND VPWR sky130_fd_sc_hd__tapvpwrvgnd_1
XANTENNA__2861__S _0383_ VGND VGND VPWR VPWR sky130_fd_sc_hd__diode_2
XFILLER_50_333 VPWR VGND VPWR VGND sky130_ef_sc_hd__decap_12
XFILLER_24_29 VPWR VGND VPWR VGND sky130_ef_sc_hd__decap_12
XFILLER_51_889 VGND VGND VPWR VPWR sky130_fd_sc_hd__decap_6
XFILLER_11_709 VPWR VGND VPWR VGND sky130_ef_sc_hd__decap_12
XFILLER_148_221 VPWR VGND VPWR VGND sky130_ef_sc_hd__decap_12
X_2927_ _0593_ _0613_ VGND VGND VPWR VPWR _0615_ sky130_fd_sc_hd__or2_1
XFILLER_50_377 VPWR VGND VPWR VGND sky130_ef_sc_hd__decap_12
XFILLER_149_777 VGND VGND VPWR VPWR sky130_fd_sc_hd__decap_6
XFILLER_148_265 VPWR VGND VPWR VGND sky130_ef_sc_hd__decap_12
XPHY_EDGE_ROW_93_Right_93 VGND VGND VPWR VPWR sky130_fd_sc_hd__decap_3
X_2858_ net31 B_reg\[8\] _0383_ VGND VGND VPWR VPWR _0081_ sky130_fd_sc_hd__mux2_1
XFILLER_152_909 VGND VGND VPWR VPWR sky130_fd_sc_hd__fill_1
XFILLER_117_641 VPWR VGND VPWR VGND sky130_ef_sc_hd__decap_12
X_2789_ _0504_ _0513_ VGND VGND VPWR VPWR _0529_ sky130_fd_sc_hd__and2b_1
X_1809_ A_reg\[4\] _1071_ _1075_ _1081_ VGND VGND VPWR VPWR _1082_ sky130_fd_sc_hd__o31ai_1
XFILLER_117_685 VPWR VGND VPWR VGND sky130_ef_sc_hd__decap_12
XTAP_TAPCELL_ROW_148_2703 VGND VPWR sky130_fd_sc_hd__tapvpwrvgnd_1
XFILLER_116_195 VGND VGND VPWR VPWR sky130_fd_sc_hd__fill_1
XFILLER_132_699 VGND VGND VPWR VPWR sky130_fd_sc_hd__fill_1
XFILLER_104_357 VGND VGND VPWR VPWR sky130_fd_sc_hd__decap_4
XFILLER_105_32 VPWR VGND VPWR VGND sky130_ef_sc_hd__decap_12
XFILLER_19_809 VPWR VGND VPWR VGND sky130_ef_sc_hd__decap_12
XFILLER_85_285 VGND VGND VPWR VPWR sky130_fd_sc_hd__fill_1
XFILLER_58_477 VPWR VGND VPWR VGND sky130_ef_sc_hd__decap_12
XFILLER_46_639 VGND VGND VPWR VPWR sky130_fd_sc_hd__decap_4
XFILLER_45_105 VGND VGND VPWR VPWR sky130_fd_sc_hd__decap_6
XANTENNA__3247__CLK clknet_3_3__leaf_clk VGND VGND VPWR VPWR sky130_fd_sc_hd__diode_2
XFILLER_73_447 VGND VGND VPWR VPWR sky130_fd_sc_hd__fill_1
XFILLER_65_69 VPWR VGND VPWR VGND sky130_ef_sc_hd__decap_12
XFILLER_61_609 VGND VGND VPWR VPWR sky130_fd_sc_hd__decap_6
XFILLER_27_853 VPWR VGND VPWR VGND sky130_ef_sc_hd__decap_12
XFILLER_45_149 VPWR VGND VPWR VGND sky130_ef_sc_hd__decap_12
XFILLER_54_661 VGND VGND VPWR VPWR sky130_fd_sc_hd__fill_1
XFILLER_27_897 VPWR VGND VPWR VGND sky130_ef_sc_hd__decap_12
XFILLER_42_801 VGND VGND VPWR VPWR sky130_fd_sc_hd__decap_4
XTAP_TAPCELL_ROW_64_1348 VGND VPWR sky130_fd_sc_hd__tapvpwrvgnd_1
XFILLER_53_193 VPWR VGND VPWR VGND sky130_ef_sc_hd__decap_12
XFILLER_14_525 VGND VGND VPWR VPWR sky130_fd_sc_hd__decap_6
XFILLER_81_57 VPWR VGND VPWR VGND sky130_ef_sc_hd__decap_12
XTAP_TAPCELL_ROW_64_1359 VGND VPWR sky130_fd_sc_hd__tapvpwrvgnd_1
XFILLER_14_569 VPWR VGND VPWR VGND sky130_ef_sc_hd__decap_12
XFILLER_127_405 VPWR VGND VPWR VGND sky130_ef_sc_hd__decap_12
XFILLER_127_449 VPWR VGND VPWR VGND sky130_ef_sc_hd__decap_12
XFILLER_6_713 VPWR VGND VPWR VGND sky130_ef_sc_hd__decap_12
XFILLER_143_909 VGND VGND VPWR VPWR sky130_fd_sc_hd__fill_1
XFILLER_6_757 VPWR VGND VPWR VGND sky130_ef_sc_hd__decap_12
XFILLER_5_223 VGND VGND VPWR VPWR sky130_fd_sc_hd__fill_1
XFILLER_142_419 VGND VGND VPWR VPWR sky130_fd_sc_hd__fill_1
XTAP_TAPCELL_ROW_79_1591 VGND VPWR sky130_fd_sc_hd__tapvpwrvgnd_1
XFILLER_30_83 VGND VGND VPWR VPWR sky130_fd_sc_hd__fill_1
XFILLER_146_83 VGND VGND VPWR VPWR sky130_fd_sc_hd__fill_1
XFILLER_122_121 VPWR VGND VPWR VGND sky130_ef_sc_hd__decap_12
XFILLER_69_709 VPWR VGND VPWR VGND sky130_ef_sc_hd__decap_12
XFILLER_122_165 VPWR VGND VPWR VGND sky130_ef_sc_hd__decap_12
XFILLER_111_839 VGND VGND VPWR VPWR sky130_fd_sc_hd__fill_1
XFILLER_68_219 VPWR VGND VPWR VGND sky130_ef_sc_hd__decap_12
XFILLER_49_422 VPWR VGND VPWR VGND sky130_ef_sc_hd__decap_12
XFILLER_1_473 VPWR VGND VPWR VGND sky130_ef_sc_hd__decap_12
XFILLER_92_701 VPWR VGND VPWR VGND sky130_ef_sc_hd__decap_12
XFILLER_39_81 VPWR VGND VPWR VGND sky130_ef_sc_hd__decap_12
XFILLER_77_797 VPWR VGND VPWR VGND sky130_ef_sc_hd__decap_12
XFILLER_37_617 VPWR VGND VPWR VGND sky130_ef_sc_hd__decap_12
XFILLER_64_447 VGND VGND VPWR VPWR sky130_fd_sc_hd__fill_1
XFILLER_45_661 VGND VGND VPWR VPWR sky130_fd_sc_hd__decap_8
XFILLER_32_333 VPWR VGND VPWR VGND sky130_ef_sc_hd__decap_12
XTAP_TAPCELL_ROW_99_1912 VGND VPWR sky130_fd_sc_hd__tapvpwrvgnd_1
XTAP_TAPCELL_ROW_15_564 VGND VPWR sky130_fd_sc_hd__tapvpwrvgnd_1
XTAP_TAPCELL_ROW_15_575 VGND VPWR sky130_fd_sc_hd__tapvpwrvgnd_1
XFILLER_32_377 VPWR VGND VPWR VGND sky130_ef_sc_hd__decap_12
XTAP_TAPCELL_ROW_99_1923 VGND VPWR sky130_fd_sc_hd__tapvpwrvgnd_1
X_2712_ _0396_ _0399_ _0405_ VGND VGND VPWR VPWR _0452_ sky130_fd_sc_hd__and3_1
XFILLER_146_725 VPWR VGND VPWR VGND sky130_ef_sc_hd__decap_12
XFILLER_72_3 VPWR VGND VPWR VGND sky130_ef_sc_hd__decap_12
XFILLER_9_573 VPWR VGND VPWR VGND sky130_ef_sc_hd__decap_12
XFILLER_146_769 VPWR VGND VPWR VGND sky130_ef_sc_hd__decap_12
XFILLER_134_909 VGND VGND VPWR VPWR sky130_fd_sc_hd__fill_1
X_2643_ net34 OpSel_reg\[1\] _0383_ VGND VGND VPWR VPWR _0036_ sky130_fd_sc_hd__mux2_1
XFILLER_145_279 VGND VGND VPWR VPWR sky130_fd_sc_hd__fill_1
X_2574_ _0307_ _0318_ VGND VGND VPWR VPWR _0319_ sky130_fd_sc_hd__nor2_1
XFILLER_141_441 VGND VGND VPWR VPWR sky130_fd_sc_hd__decap_6
XFILLER_101_305 VPWR VGND VPWR VGND sky130_ef_sc_hd__decap_12
XFILLER_87_517 VPWR VGND VPWR VGND sky130_ef_sc_hd__decap_12
XFILLER_141_485 VPWR VGND VPWR VGND sky130_ef_sc_hd__decap_12
XFILLER_114_699 VGND VGND VPWR VPWR sky130_fd_sc_hd__fill_1
XFILLER_68_720 VPWR VGND VPWR VGND sky130_ef_sc_hd__decap_12
XFILLER_110_861 VGND VGND VPWR VPWR sky130_fd_sc_hd__decap_6
XFILLER_101_349 VPWR VGND VPWR VGND sky130_ef_sc_hd__decap_12
XFILLER_95_561 VGND VGND VPWR VPWR sky130_fd_sc_hd__fill_1
XANTENNA__2856__S _0383_ VGND VGND VPWR VPWR sky130_fd_sc_hd__diode_2
XTAP_TAPCELL_ROW_143_2622 VGND VPWR sky130_fd_sc_hd__tapvpwrvgnd_1
XFILLER_27_105 VGND VGND VPWR VPWR sky130_fd_sc_hd__decap_6
X_3126_ _0788_ _0811_ VGND VGND VPWR VPWR _0814_ sky130_fd_sc_hd__xnor2_1
XFILLER_82_233 VGND VGND VPWR VPWR sky130_fd_sc_hd__decap_8
XFILLER_55_447 VGND VGND VPWR VPWR sky130_fd_sc_hd__fill_1
XFILLER_27_149 VPWR VGND VPWR VGND sky130_ef_sc_hd__decap_12
XFILLER_82_277 VPWR VGND VPWR VGND sky130_ef_sc_hd__decap_12
X_3057_ _0673_ _0732_ VGND VGND VPWR VPWR _0745_ sky130_fd_sc_hd__and2_1
XFILLER_35_39 VPWR VGND VPWR VGND sky130_ef_sc_hd__decap_12
XFILLER_43_609 VGND VGND VPWR VPWR sky130_fd_sc_hd__decap_6
XANTENNA__2813__A2 _0910_ VGND VGND VPWR VPWR sky130_fd_sc_hd__diode_2
X_2008_ _1260_ _1267_ VGND VGND VPWR VPWR _1270_ sky130_fd_sc_hd__xor2_1
XFILLER_23_322 VGND VGND VPWR VPWR sky130_fd_sc_hd__decap_8
XFILLER_51_653 VPWR VGND VPWR VGND sky130_ef_sc_hd__decap_12
XFILLER_50_141 VPWR VGND VPWR VGND sky130_ef_sc_hd__decap_12
XFILLER_24_867 VGND VGND VPWR VPWR sky130_fd_sc_hd__fill_1
XFILLER_35_193 VPWR VGND VPWR VGND sky130_ef_sc_hd__decap_12
XTAP_TAPCELL_ROW_46_1067 VGND VPWR sky130_fd_sc_hd__tapvpwrvgnd_1
XFILLER_149_541 VPWR VGND VPWR VGND sky130_ef_sc_hd__decap_12
XFILLER_11_517 VPWR VGND VPWR VGND sky130_ef_sc_hd__decap_12
XTAP_TAPCELL_ROW_34_873 VGND VPWR sky130_fd_sc_hd__tapvpwrvgnd_1
XFILLER_109_405 VPWR VGND VPWR VGND sky130_ef_sc_hd__decap_12
XFILLER_149_585 VPWR VGND VPWR VGND sky130_ef_sc_hd__decap_12
XFILLER_125_909 VGND VGND VPWR VPWR sky130_fd_sc_hd__fill_1
XFILLER_109_449 VGND VGND VPWR VPWR sky130_fd_sc_hd__fill_2
XFILLER_151_205 VPWR VGND VPWR VGND sky130_ef_sc_hd__decap_12
XFILLER_124_419 VGND VGND VPWR VPWR sky130_fd_sc_hd__fill_1
XFILLER_3_727 VGND VGND VPWR VPWR sky130_fd_sc_hd__fill_1
XFILLER_151_249 VPWR VGND VPWR VGND sky130_ef_sc_hd__decap_12
XFILLER_104_121 VPWR VGND VPWR VGND sky130_ef_sc_hd__decap_12
XFILLER_104_165 VPWR VGND VPWR VGND sky130_ef_sc_hd__decap_12
XFILLER_120_625 VPWR VGND VPWR VGND sky130_ef_sc_hd__decap_12
XFILLER_116_53 VPWR VGND VPWR VGND sky130_ef_sc_hd__decap_12
XFILLER_120_669 VPWR VGND VPWR VGND sky130_ef_sc_hd__decap_12
XFILLER_116_97 VPWR VGND VPWR VGND sky130_ef_sc_hd__decap_12
XFILLER_74_734 VPWR VGND VPWR VGND sky130_ef_sc_hd__decap_12
XFILLER_74_701 VGND VGND VPWR VPWR sky130_fd_sc_hd__fill_2
XFILLER_59_797 VPWR VGND VPWR VGND sky130_ef_sc_hd__decap_12
XFILLER_19_617 VPWR VGND VPWR VGND sky130_ef_sc_hd__decap_12
XFILLER_132_41 VPWR VGND VPWR VGND sky130_ef_sc_hd__decap_12
XFILLER_132_85 VPWR VGND VPWR VGND sky130_ef_sc_hd__decap_12
XANTENNA__3292__RESET_B net36 VGND VGND VPWR VPWR sky130_fd_sc_hd__diode_2
XFILLER_74_778 VPWR VGND VPWR VGND sky130_ef_sc_hd__decap_12
XANTENNA__3221__RESET_B net36 VGND VGND VPWR VPWR sky130_fd_sc_hd__diode_2
XFILLER_15_889 VGND VGND VPWR VPWR sky130_fd_sc_hd__decap_6
XFILLER_14_377 VGND VGND VPWR VPWR sky130_fd_sc_hd__decap_8
XTAP_TAPCELL_ROW_12_523 VGND VPWR sky130_fd_sc_hd__tapvpwrvgnd_1
XFILLER_30_859 VGND VGND VPWR VPWR sky130_fd_sc_hd__decap_8
XFILLER_128_725 VPWR VGND VPWR VGND sky130_ef_sc_hd__decap_12
XFILLER_128_769 VPWR VGND VPWR VGND sky130_ef_sc_hd__decap_12
XFILLER_116_909 VGND VGND VPWR VPWR sky130_fd_sc_hd__fill_1
XFILLER_41_93 VPWR VGND VPWR VGND sky130_ef_sc_hd__decap_12
XFILLER_127_279 VGND VGND VPWR VPWR sky130_fd_sc_hd__fill_1
XTAP_TAPCELL_ROW_94_1842 VGND VPWR sky130_fd_sc_hd__tapvpwrvgnd_1
XTAP_TAPCELL_ROW_94_1831 VGND VPWR sky130_fd_sc_hd__tapvpwrvgnd_1
XFILLER_6_587 VGND VGND VPWR VPWR sky130_fd_sc_hd__fill_1
XFILLER_123_441 VGND VGND VPWR VPWR sky130_fd_sc_hd__decap_6
XFILLER_69_517 VPWR VGND VPWR VGND sky130_ef_sc_hd__decap_12
XFILLER_151_783 VGND VGND VPWR VPWR sky130_fd_sc_hd__fill_1
XFILLER_123_485 VPWR VGND VPWR VGND sky130_ef_sc_hd__decap_12
X_2290_ A_reg\[0\] _1531_ _1540_ VGND VGND VPWR VPWR _1545_ sky130_fd_sc_hd__a21bo_1
XFILLER_2_793 VPWR VGND VPWR VGND sky130_ef_sc_hd__decap_12
XFILLER_84_509 VGND VGND VPWR VPWR sky130_fd_sc_hd__fill_2
XFILLER_1_281 VPWR VGND VPWR VGND sky130_ef_sc_hd__decap_12
XFILLER_38_904 VGND VGND VPWR VPWR sky130_fd_sc_hd__decap_6
XFILLER_77_561 VPWR VGND VPWR VGND sky130_ef_sc_hd__decap_12
XFILLER_2_65 VPWR VGND VPWR VGND sky130_ef_sc_hd__decap_12
XTAP_TAPCELL_ROW_125_2330 VGND VPWR sky130_fd_sc_hd__tapvpwrvgnd_1
XFILLER_49_285 VGND VGND VPWR VPWR sky130_fd_sc_hd__fill_1
XANTENNA__3309__RESET_B net36 VGND VGND VPWR VPWR sky130_fd_sc_hd__diode_2
XFILLER_92_575 VGND VGND VPWR VPWR sky130_fd_sc_hd__decap_4
XFILLER_64_277 VPWR VGND VPWR VGND sky130_ef_sc_hd__decap_12
XFILLER_25_609 VGND VGND VPWR VPWR sky130_fd_sc_hd__decap_6
XFILLER_17_193 VPWR VGND VPWR VGND sky130_ef_sc_hd__decap_12
XFILLER_32_141 VPWR VGND VPWR VGND sky130_ef_sc_hd__decap_12
XFILLER_33_653 VPWR VGND VPWR VGND sky130_ef_sc_hd__decap_12
XTAP_TAPCELL_ROW_103_1982 VGND VPWR sky130_fd_sc_hd__tapvpwrvgnd_1
XFILLER_20_303 VGND VGND VPWR VPWR sky130_fd_sc_hd__decap_4
XFILLER_33_697 VPWR VGND VPWR VGND sky130_ef_sc_hd__decap_12
XANTENNA__2424__B _0911_ VGND VGND VPWR VPWR sky130_fd_sc_hd__diode_2
XTAP_TAPCELL_ROW_31_821 VGND VPWR sky130_fd_sc_hd__tapvpwrvgnd_1
XTAP_TAPCELL_ROW_31_832 VGND VPWR sky130_fd_sc_hd__tapvpwrvgnd_1
XFILLER_146_533 VPWR VGND VPWR VGND sky130_ef_sc_hd__decap_12
XFILLER_107_909 VGND VGND VPWR VPWR sky130_fd_sc_hd__fill_1
XFILLER_133_205 VPWR VGND VPWR VGND sky130_ef_sc_hd__decap_12
X_2626_ _0185_ _0370_ VGND VGND VPWR VPWR _0371_ sky130_fd_sc_hd__xnor2_1
XFILLER_133_249 VPWR VGND VPWR VGND sky130_ef_sc_hd__decap_12
X_2557_ u_crt.r1\[1\] _0910_ _0184_ _0303_ VGND VGND VPWR VPWR _0030_ sky130_fd_sc_hd__a22o_1
XFILLER_153_29 VPWR VGND VPWR VGND sky130_ef_sc_hd__decap_12
XFILLER_102_625 VPWR VGND VPWR VGND sky130_ef_sc_hd__decap_12
XFILLER_101_113 VPWR VGND VPWR VGND sky130_ef_sc_hd__decap_12
XFILLER_88_837 VPWR VGND VPWR VGND sky130_ef_sc_hd__decap_12
X_2488_ _0221_ _0231_ VGND VGND VPWR VPWR _0236_ sky130_fd_sc_hd__xor2_1
XFILLER_141_293 VPWR VGND VPWR VGND sky130_ef_sc_hd__decap_12
XFILLER_102_669 VPWR VGND VPWR VGND sky130_ef_sc_hd__decap_12
XFILLER_96_881 VPWR VGND VPWR VGND sky130_ef_sc_hd__decap_12
XFILLER_56_701 VPWR VGND VPWR VGND sky130_ef_sc_hd__decap_12
XFILLER_95_391 VGND VGND VPWR VPWR sky130_fd_sc_hd__fill_1
XANTENNA__2495__B1 _0185_ VGND VGND VPWR VPWR sky130_fd_sc_hd__diode_2
XTAP_TAPCELL_ROW_39_954 VGND VPWR sky130_fd_sc_hd__tapvpwrvgnd_1
XFILLER_83_553 VGND VGND VPWR VPWR sky130_fd_sc_hd__decap_6
X_3109_ _0782_ _0796_ VGND VGND VPWR VPWR _0797_ sky130_fd_sc_hd__nor2_1
XTAP_TAPCELL_ROW_48_1107 VGND VPWR sky130_fd_sc_hd__tapvpwrvgnd_1
XFILLER_28_469 VGND VGND VPWR VPWR sky130_fd_sc_hd__decap_6
XFILLER_43_417 VPWR VGND VPWR VGND sky130_ef_sc_hd__decap_12
XFILLER_83_597 VPWR VGND VPWR VGND sky130_ef_sc_hd__decap_12
XFILLER_70_225 VGND VGND VPWR VPWR sky130_fd_sc_hd__decap_6
XFILLER_102_77 VGND VGND VPWR VPWR sky130_fd_sc_hd__decap_6
XFILLER_70_247 VGND VGND VPWR VPWR sky130_fd_sc_hd__decap_4
XFILLER_62_15 VPWR VGND VPWR VGND sky130_ef_sc_hd__decap_12
XTAP_TAPCELL_ROW_61_1307 VGND VPWR sky130_fd_sc_hd__tapvpwrvgnd_1
XFILLER_51_461 VGND VGND VPWR VPWR sky130_fd_sc_hd__decap_4
XFILLER_12_837 VPWR VGND VPWR VGND sky130_ef_sc_hd__decap_12
XFILLER_11_325 VGND VGND VPWR VPWR sky130_fd_sc_hd__decap_8
XFILLER_7_329 VGND VGND VPWR VPWR sky130_fd_sc_hd__decap_6
XFILLER_149_393 VPWR VGND VPWR VGND sky130_ef_sc_hd__decap_12
XPHY_EDGE_ROW_12_Left_166 VGND VGND VPWR VPWR sky130_fd_sc_hd__decap_3
XFILLER_20_881 VPWR VGND VPWR VGND sky130_ef_sc_hd__decap_12
XFILLER_152_525 VGND VGND VPWR VPWR sky130_fd_sc_hd__decap_6
XFILLER_109_279 VGND VGND VPWR VPWR sky130_fd_sc_hd__fill_1
XFILLER_3_502 VGND VGND VPWR VPWR sky130_fd_sc_hd__fill_2
XTAP_TAPCELL_ROW_76_1550 VGND VPWR sky130_fd_sc_hd__tapvpwrvgnd_1
XTAP_TAPCELL_ROW_59_1269 VGND VPWR sky130_fd_sc_hd__tapvpwrvgnd_1
XFILLER_3_513 VGND VGND VPWR VPWR sky130_fd_sc_hd__fill_2
XFILLER_105_441 VGND VGND VPWR VPWR sky130_fd_sc_hd__decap_6
XFILLER_2_3 VPWR VGND VPWR VGND sky130_ef_sc_hd__decap_12
XFILLER_133_783 VGND VGND VPWR VPWR sky130_fd_sc_hd__fill_1
XFILLER_105_485 VPWR VGND VPWR VGND sky130_ef_sc_hd__decap_12
XFILLER_120_433 VPWR VGND VPWR VGND sky130_ef_sc_hd__decap_12
XFILLER_87_89 VGND VGND VPWR VPWR sky130_fd_sc_hd__decap_6
XFILLER_143_51 VGND VGND VPWR VPWR sky130_fd_sc_hd__decap_4
XFILLER_120_477 VPWR VGND VPWR VGND sky130_ef_sc_hd__decap_12
XFILLER_93_317 VPWR VGND VPWR VGND sky130_ef_sc_hd__decap_12
XFILLER_74_531 VGND VGND VPWR VPWR sky130_fd_sc_hd__fill_1
XFILLER_19_447 VGND VGND VPWR VPWR sky130_fd_sc_hd__fill_1
XPHY_EDGE_ROW_21_Left_175 VGND VGND VPWR VPWR sky130_fd_sc_hd__decap_3
XFILLER_46_222 VGND VGND VPWR VPWR sky130_fd_sc_hd__decap_6
XTAP_TAPCELL_ROW_17_604 VGND VPWR sky130_fd_sc_hd__tapvpwrvgnd_1
XFILLER_62_737 VPWR VGND VPWR VGND sky130_ef_sc_hd__decap_12
XFILLER_61_225 VPWR VGND VPWR VGND sky130_ef_sc_hd__decap_12
XFILLER_15_653 VPWR VGND VPWR VGND sky130_ef_sc_hd__decap_12
XFILLER_14_141 VPWR VGND VPWR VGND sky130_ef_sc_hd__decap_12
XFILLER_15_697 VPWR VGND VPWR VGND sky130_ef_sc_hd__decap_12
XFILLER_30_601 VPWR VGND VPWR VGND sky130_ef_sc_hd__decap_12
XFILLER_70_792 VPWR VGND VPWR VGND sky130_ef_sc_hd__decap_12
XFILLER_30_645 VPWR VGND VPWR VGND sky130_ef_sc_hd__decap_12
XPHY_EDGE_ROW_30_Left_184 VGND VGND VPWR VPWR sky130_fd_sc_hd__decap_3
X_1790_ _1062_ _1056_ _1058_ VGND VGND VPWR VPWR _1063_ sky130_fd_sc_hd__mux2_1
Xinput13 A_in[6] VGND VGND VPWR VPWR net13 sky130_fd_sc_hd__buf_1
XFILLER_128_533 VPWR VGND VPWR VGND sky130_ef_sc_hd__decap_12
Xinput24 B_in[1] VGND VGND VPWR VPWR net24 sky130_fd_sc_hd__clkbuf_1
XFILLER_7_841 VPWR VGND VPWR VGND sky130_ef_sc_hd__decap_12
Xinput35 Start VGND VGND VPWR VPWR net35 sky130_fd_sc_hd__buf_1
XFILLER_143_503 VGND VGND VPWR VPWR sky130_fd_sc_hd__fill_1
XFILLER_115_205 VPWR VGND VPWR VGND sky130_ef_sc_hd__decap_12
XFILLER_115_249 VPWR VGND VPWR VGND sky130_ef_sc_hd__decap_12
XFILLER_131_709 VPWR VGND VPWR VGND sky130_ef_sc_hd__decap_12
X_2411_ _0155_ _0164_ VGND VGND VPWR VPWR _0165_ sky130_fd_sc_hd__and2_1
X_2342_ _1586_ _1594_ _1587_ VGND VGND VPWR VPWR _1595_ sky130_fd_sc_hd__a21bo_1
XFILLER_35_3 VPWR VGND VPWR VGND sky130_ef_sc_hd__decap_12
XFILLER_123_293 VPWR VGND VPWR VGND sky130_ef_sc_hd__decap_12
XFILLER_96_133 VGND VGND VPWR VPWR sky130_fd_sc_hd__decap_6
XFILLER_84_306 VGND VGND VPWR VPWR sky130_fd_sc_hd__fill_2
XFILLER_78_881 VPWR VGND VPWR VGND sky130_ef_sc_hd__decap_12
X_2273_ _1523_ _1529_ _1521_ VGND VGND VPWR VPWR _1530_ sky130_fd_sc_hd__a21o_1
XFILLER_38_701 VPWR VGND VPWR VGND sky130_ef_sc_hd__decap_12
XTAP_TAPCELL_ROW_36_902 VGND VPWR sky130_fd_sc_hd__tapvpwrvgnd_1
XFILLER_93_895 VGND VGND VPWR VPWR sky130_fd_sc_hd__fill_1
XTAP_TAPCELL_ROW_36_913 VGND VPWR sky130_fd_sc_hd__tapvpwrvgnd_1
XANTENNA__3308__CLK clknet_3_7__leaf_clk VGND VGND VPWR VPWR sky130_fd_sc_hd__diode_2
XANTENNA__2435__A OpSel_reg\[0\] VGND VGND VPWR VPWR sky130_fd_sc_hd__diode_2
XFILLER_80_589 VPWR VGND VPWR VGND sky130_ef_sc_hd__decap_12
XFILLER_33_461 VPWR VGND VPWR VGND sky130_ef_sc_hd__decap_12
XTAP_TAPCELL_ROW_43_1015 VGND VPWR sky130_fd_sc_hd__tapvpwrvgnd_1
XFILLER_139_809 VPWR VGND VPWR VGND sky130_ef_sc_hd__decap_12
XTAP_TAPCELL_ROW_138_2532 VGND VPWR sky130_fd_sc_hd__tapvpwrvgnd_1
XFILLER_32_29 VPWR VGND VPWR VGND sky130_ef_sc_hd__decap_12
XTAP_TAPCELL_ROW_43_1026 VGND VPWR sky130_fd_sc_hd__tapvpwrvgnd_1
XFILLER_148_29 VPWR VGND VPWR VGND sky130_ef_sc_hd__decap_12
XTAP_TAPCELL_ROW_138_2543 VGND VPWR sky130_fd_sc_hd__tapvpwrvgnd_1
XFILLER_20_133 VGND VGND VPWR VPWR sky130_fd_sc_hd__decap_6
XFILLER_147_853 VPWR VGND VPWR VGND sky130_ef_sc_hd__decap_12
X_1988_ _1247_ _1250_ VGND VGND VPWR VPWR _1252_ sky130_fd_sc_hd__xnor2_1
XFILLER_20_177 VPWR VGND VPWR VGND sky130_ef_sc_hd__decap_12
XTAP_TAPCELL_ROW_151_2754 VGND VPWR sky130_fd_sc_hd__tapvpwrvgnd_1
XTAP_TAPCELL_ROW_151_2743 VGND VPWR sky130_fd_sc_hd__tapvpwrvgnd_1
XFILLER_147_897 VPWR VGND VPWR VGND sky130_ef_sc_hd__decap_12
XFILLER_146_363 VGND VGND VPWR VPWR sky130_fd_sc_hd__fill_1
XFILLER_134_525 VGND VGND VPWR VPWR sky130_fd_sc_hd__decap_6
XFILLER_134_569 VPWR VGND VPWR VGND sky130_ef_sc_hd__decap_12
X_2609_ _0314_ _0325_ _0187_ VGND VGND VPWR VPWR _0354_ sky130_fd_sc_hd__o21ai_1
XFILLER_115_783 VGND VGND VPWR VPWR sky130_fd_sc_hd__fill_1
XFILLER_88_678 VPWR VGND VPWR VGND sky130_ef_sc_hd__decap_12
XFILLER_88_645 VGND VGND VPWR VPWR sky130_fd_sc_hd__decap_4
XTAP_TAPCELL_ROW_54_1188 VGND VPWR sky130_fd_sc_hd__tapvpwrvgnd_1
XFILLER_75_328 VGND VGND VPWR VPWR sky130_fd_sc_hd__fill_1
XFILLER_75_306 VGND VGND VPWR VPWR sky130_fd_sc_hd__decap_8
XTAP_TAPCELL_ROW_54_1199 VGND VPWR sky130_fd_sc_hd__tapvpwrvgnd_1
XFILLER_90_309 VPWR VGND VPWR VGND sky130_ef_sc_hd__decap_12
XFILLER_56_553 VGND VGND VPWR VPWR sky130_fd_sc_hd__decap_3
XTAP_TAPCELL_ROW_3_387 VGND VPWR sky130_fd_sc_hd__tapvpwrvgnd_1
XTAP_TAPCELL_ROW_3_376 VGND VPWR sky130_fd_sc_hd__tapvpwrvgnd_1
XFILLER_83_361 VPWR VGND VPWR VGND sky130_ef_sc_hd__decap_12
XFILLER_16_439 VGND VGND VPWR VPWR sky130_fd_sc_hd__fill_1
XFILLER_28_277 VPWR VGND VPWR VGND sky130_ef_sc_hd__decap_12
XFILLER_43_225 VPWR VGND VPWR VGND sky130_ef_sc_hd__decap_12
XFILLER_73_69 VPWR VGND VPWR VGND sky130_ef_sc_hd__decap_12
XANTENNA__2640__B1 _0184_ VGND VGND VPWR VPWR sky130_fd_sc_hd__diode_2
XFILLER_11_111 VGND VGND VPWR VPWR sky130_fd_sc_hd__fill_1
XFILLER_12_645 VPWR VGND VPWR VGND sky130_ef_sc_hd__decap_12
XFILLER_7_137 VPWR VGND VPWR VGND sky130_ef_sc_hd__decap_12
XTAP_TAPCELL_ROW_22_684 VGND VPWR sky130_fd_sc_hd__tapvpwrvgnd_1
XFILLER_125_503 VGND VGND VPWR VPWR sky130_fd_sc_hd__fill_1
XFILLER_4_811 VGND VGND VPWR VPWR sky130_fd_sc_hd__fill_1
XFILLER_152_333 VPWR VGND VPWR VGND sky130_ef_sc_hd__decap_12
XFILLER_137_385 VGND VGND VPWR VPWR sky130_fd_sc_hd__decap_6
XTAP_TAPCELL_ROW_74_1509 VGND VPWR sky130_fd_sc_hd__tapvpwrvgnd_1
XFILLER_3_321 VGND VGND VPWR VPWR sky130_fd_sc_hd__decap_3
XFILLER_113_709 VPWR VGND VPWR VGND sky130_ef_sc_hd__decap_12
XFILLER_98_409 VGND VGND VPWR VPWR sky130_fd_sc_hd__decap_8
XFILLER_98_77 VGND VGND VPWR VPWR sky130_fd_sc_hd__decap_6
XFILLER_152_377 VPWR VGND VPWR VGND sky130_ef_sc_hd__decap_12
XFILLER_121_753 VPWR VGND VPWR VGND sky130_ef_sc_hd__decap_12
XFILLER_105_293 VPWR VGND VPWR VGND sky130_ef_sc_hd__decap_12
XFILLER_78_122 VGND VGND VPWR VPWR sky130_fd_sc_hd__decap_8
XFILLER_121_797 VPWR VGND VPWR VGND sky130_ef_sc_hd__decap_12
XFILLER_78_177 VGND VGND VPWR VPWR sky130_fd_sc_hd__decap_3
XFILLER_94_637 VGND VGND VPWR VPWR sky130_fd_sc_hd__decap_6
XFILLER_93_125 VPWR VGND VPWR VGND sky130_ef_sc_hd__decap_12
XFILLER_59_391 VGND VGND VPWR VPWR sky130_fd_sc_hd__fill_1
XTAP_TAPCELL_ROW_105_2019 VGND VPWR sky130_fd_sc_hd__tapvpwrvgnd_1
XTAP_TAPCELL_ROW_105_2008 VGND VPWR sky130_fd_sc_hd__tapvpwrvgnd_1
XFILLER_93_169 VPWR VGND VPWR VGND sky130_ef_sc_hd__decap_12
XTAP_TAPCELL_ROW_89_1763 VGND VPWR sky130_fd_sc_hd__tapvpwrvgnd_1
XTAP_TAPCELL_ROW_89_1752 VGND VPWR sky130_fd_sc_hd__tapvpwrvgnd_1
XFILLER_47_542 VPWR VGND VPWR VGND sky130_ef_sc_hd__decap_12
XFILLER_19_255 VPWR VGND VPWR VGND sky130_ef_sc_hd__decap_12
XFILLER_47_81 VPWR VGND VPWR VGND sky130_ef_sc_hd__decap_12
XFILLER_75_895 VGND VGND VPWR VPWR sky130_fd_sc_hd__fill_1
XFILLER_62_512 VGND VGND VPWR VPWR sky130_fd_sc_hd__decap_4
XFILLER_47_597 VPWR VGND VPWR VGND sky130_ef_sc_hd__decap_12
XANTENNA_clkload5_A clknet_3_5__leaf_clk VGND VGND VPWR VPWR sky130_fd_sc_hd__diode_2
XFILLER_19_288 VGND VGND VPWR VPWR sky130_fd_sc_hd__decap_4
XFILLER_74_394 VPWR VGND VPWR VGND sky130_ef_sc_hd__decap_12
XFILLER_62_545 VPWR VGND VPWR VGND sky130_ef_sc_hd__decap_12
XFILLER_50_707 VGND VGND VPWR VPWR sky130_fd_sc_hd__fill_1
X_2960_ _0566_ _0574_ _0647_ VGND VGND VPWR VPWR _0648_ sky130_fd_sc_hd__a21oi_1
XFILLER_62_589 VPWR VGND VPWR VGND sky130_ef_sc_hd__decap_12
XFILLER_15_461 VPWR VGND VPWR VGND sky130_ef_sc_hd__decap_12
XTAP_TAPCELL_ROW_100_1930 VGND VPWR sky130_fd_sc_hd__tapvpwrvgnd_1
X_2891_ u_crt.r2\[2\] u_crt.r2\[1\] u_crt.r2\[0\] VGND VGND VPWR VPWR _0579_ sky130_fd_sc_hd__a21bo_1
X_1911_ B_reg\[15\] B_reg\[13\] VGND VGND VPWR VPWR _1176_ sky130_fd_sc_hd__nand2_1
XFILLER_147_105 VGND VGND VPWR VPWR sky130_fd_sc_hd__decap_6
X_1842_ _0917_ _0924_ VGND VGND VPWR VPWR _1112_ sky130_fd_sc_hd__nor2_1
XFILLER_147_149 VPWR VGND VPWR VGND sky130_ef_sc_hd__decap_12
XFILLER_129_853 VPWR VGND VPWR VGND sky130_ef_sc_hd__decap_12
XFILLER_8_53 VPWR VGND VPWR VGND sky130_ef_sc_hd__decap_12
XFILLER_30_475 VGND VGND VPWR VPWR sky130_fd_sc_hd__fill_1
XTAP_TAPCELL_ROW_41_982 VGND VPWR sky130_fd_sc_hd__tapvpwrvgnd_1
XTAP_TAPCELL_ROW_41_993 VGND VPWR sky130_fd_sc_hd__tapvpwrvgnd_1
XFILLER_129_897 VPWR VGND VPWR VGND sky130_ef_sc_hd__decap_12
XFILLER_128_363 VGND VGND VPWR VPWR sky130_fd_sc_hd__fill_1
XFILLER_8_97 VPWR VGND VPWR VGND sky130_ef_sc_hd__decap_12
X_1773_ _1042_ _1044_ _1040_ VGND VGND VPWR VPWR _1046_ sky130_fd_sc_hd__a21oi_1
XTAP_TAPCELL_ROW_133_2462 VGND VPWR sky130_fd_sc_hd__tapvpwrvgnd_1
XFILLER_116_525 VGND VGND VPWR VPWR sky130_fd_sc_hd__decap_6
XFILLER_7_671 VGND VGND VPWR VPWR sky130_fd_sc_hd__fill_1
XFILLER_144_867 VGND VGND VPWR VPWR sky130_fd_sc_hd__fill_1
XFILLER_116_569 VPWR VGND VPWR VGND sky130_ef_sc_hd__decap_12
XFILLER_131_517 VPWR VGND VPWR VGND sky130_ef_sc_hd__decap_12
XFILLER_97_431 VGND VGND VPWR VPWR sky130_fd_sc_hd__fill_1
XFILLER_69_133 VGND VGND VPWR VPWR sky130_fd_sc_hd__decap_3
XFILLER_57_317 VPWR VGND VPWR VGND sky130_ef_sc_hd__decap_12
X_2325_ _1564_ _1577_ VGND VGND VPWR VPWR _1578_ sky130_fd_sc_hd__xor2_1
XFILLER_97_497 VGND VGND VPWR VPWR sky130_fd_sc_hd__decap_6
X_2256_ A_reg\[2\] _1508_ _1510_ _1511_ VGND VGND VPWR VPWR _1513_ sky130_fd_sc_hd__a22o_1
XFILLER_72_309 VPWR VGND VPWR VGND sky130_ef_sc_hd__decap_12
XANTENNA__2864__S _0383_ VGND VGND VPWR VPWR sky130_fd_sc_hd__diode_2
XFILLER_81_821 VPWR VGND VPWR VGND sky130_ef_sc_hd__decap_12
XFILLER_53_512 VPWR VGND VPWR VGND sky130_ef_sc_hd__decap_12
XTAP_TAPCELL_ROW_0_313 VGND VPWR sky130_fd_sc_hd__tapvpwrvgnd_1
XTAP_TAPCELL_ROW_0_324 VGND VPWR sky130_fd_sc_hd__tapvpwrvgnd_1
XTAP_TAPCELL_ROW_0_335 VGND VPWR sky130_fd_sc_hd__tapvpwrvgnd_1
X_2187_ A_reg\[9\] _1440_ _1431_ VGND VGND VPWR VPWR _1444_ sky130_fd_sc_hd__a21o_1
XFILLER_26_737 VPWR VGND VPWR VGND sky130_ef_sc_hd__decap_12
XFILLER_81_865 VPWR VGND VPWR VGND sky130_ef_sc_hd__decap_12
XFILLER_25_225 VGND VGND VPWR VPWR sky130_fd_sc_hd__fill_2
XANTENNA__3280__CLK clknet_3_0__leaf_clk VGND VGND VPWR VPWR sky130_fd_sc_hd__diode_2
XFILLER_34_781 VPWR VGND VPWR VGND sky130_ef_sc_hd__decap_12
XFILLER_43_39 VPWR VGND VPWR VGND sky130_ef_sc_hd__decap_12
XFILLER_139_617 VPWR VGND VPWR VGND sky130_ef_sc_hd__decap_12
XFILLER_21_497 VGND VGND VPWR VPWR sky130_fd_sc_hd__decap_6
XFILLER_119_385 VGND VGND VPWR VPWR sky130_fd_sc_hd__decap_6
XFILLER_135_889 VGND VGND VPWR VPWR sky130_fd_sc_hd__decap_6
XFILLER_134_333 VPWR VGND VPWR VGND sky130_ef_sc_hd__decap_12
XFILLER_107_558 VGND VGND VPWR VPWR sky130_fd_sc_hd__fill_2
XTAP_TAPCELL_ROW_56_1228 VGND VPWR sky130_fd_sc_hd__tapvpwrvgnd_1
XFILLER_150_837 VPWR VGND VPWR VGND sky130_ef_sc_hd__decap_12
XFILLER_134_377 VPWR VGND VPWR VGND sky130_ef_sc_hd__decap_12
XFILLER_108_65 VPWR VGND VPWR VGND sky130_ef_sc_hd__decap_12
XFILLER_103_753 VPWR VGND VPWR VGND sky130_ef_sc_hd__decap_12
XFILLER_68_47 VPWR VGND VPWR VGND sky130_ef_sc_hd__decap_12
XFILLER_49_807 VPWR VGND VPWR VGND sky130_ef_sc_hd__decap_12
XTAP_TAPCELL_ROW_8_457 VGND VPWR sky130_fd_sc_hd__tapvpwrvgnd_1
XFILLER_88_475 VGND VGND VPWR VPWR sky130_fd_sc_hd__fill_1
XFILLER_124_53 VPWR VGND VPWR VGND sky130_ef_sc_hd__decap_12
XFILLER_103_797 VPWR VGND VPWR VGND sky130_ef_sc_hd__decap_12
XFILLER_76_648 VPWR VGND VPWR VGND sky130_ef_sc_hd__decap_12
XFILLER_124_97 VPWR VGND VPWR VGND sky130_ef_sc_hd__decap_12
XFILLER_75_169 VPWR VGND VPWR VGND sky130_ef_sc_hd__decap_12
XFILLER_75_147 VPWR VGND VPWR VGND sky130_ef_sc_hd__decap_12
XANTENNA__3232__Q a_r3\[0\] VGND VGND VPWR VPWR sky130_fd_sc_hd__diode_2
XFILLER_91_629 VPWR VGND VPWR VGND sky130_ef_sc_hd__decap_12
XFILLER_84_681 VPWR VGND VPWR VGND sky130_ef_sc_hd__decap_12
XFILLER_84_79 VGND VGND VPWR VPWR sky130_fd_sc_hd__decap_4
XFILLER_57_895 VGND VGND VPWR VPWR sky130_fd_sc_hd__fill_1
XFILLER_140_41 VPWR VGND VPWR VGND sky130_ef_sc_hd__decap_12
XFILLER_90_139 VGND VGND VPWR VPWR sky130_fd_sc_hd__fill_1
XFILLER_17_51 VGND VGND VPWR VPWR sky130_fd_sc_hd__decap_4
XFILLER_44_545 VGND VGND VPWR VPWR sky130_fd_sc_hd__fill_1
XFILLER_140_85 VPWR VGND VPWR VGND sky130_ef_sc_hd__decap_12
XTAP_TAPCELL_ROW_84_1671 VGND VPWR sky130_fd_sc_hd__tapvpwrvgnd_1
XANTENNA__2075__A B_reg\[2\] VGND VGND VPWR VPWR sky130_fd_sc_hd__diode_2
XTAP_TAPCELL_ROW_27_765 VGND VPWR sky130_fd_sc_hd__tapvpwrvgnd_1
XFILLER_31_217 VGND VGND VPWR VPWR sky130_fd_sc_hd__decap_6
XFILLER_44_589 VPWR VGND VPWR VGND sky130_ef_sc_hd__decap_12
XTAP_TAPCELL_ROW_84_1682 VGND VPWR sky130_fd_sc_hd__tapvpwrvgnd_1
XFILLER_129_105 VGND VGND VPWR VPWR sky130_fd_sc_hd__decap_6
XFILLER_129_149 VPWR VGND VPWR VGND sky130_ef_sc_hd__decap_12
XFILLER_8_446 VGND VGND VPWR VPWR sky130_fd_sc_hd__fill_2
XFILLER_145_609 VGND VGND VPWR VPWR sky130_fd_sc_hd__decap_6
XFILLER_152_141 VPWR VGND VPWR VGND sky130_ef_sc_hd__decap_12
XFILLER_137_193 VPWR VGND VPWR VGND sky130_ef_sc_hd__decap_12
XFILLER_126_867 VGND VGND VPWR VPWR sky130_fd_sc_hd__fill_1
XTAP_TAPCELL_ROW_115_2170 VGND VPWR sky130_fd_sc_hd__tapvpwrvgnd_1
XFILLER_153_697 VGND VGND VPWR VPWR sky130_fd_sc_hd__decap_3
XFILLER_113_517 VPWR VGND VPWR VGND sky130_ef_sc_hd__decap_12
XFILLER_99_729 VPWR VGND VPWR VGND sky130_ef_sc_hd__decap_12
XFILLER_98_206 VGND VGND VPWR VPWR sky130_fd_sc_hd__decap_3
XFILLER_121_561 VPWR VGND VPWR VGND sky130_ef_sc_hd__decap_12
XFILLER_39_317 VPWR VGND VPWR VGND sky130_ef_sc_hd__decap_12
XFILLER_79_497 VGND VGND VPWR VPWR sky130_fd_sc_hd__decap_6
X_3090_ _0768_ _0771_ VGND VGND VPWR VPWR _0778_ sky130_fd_sc_hd__or2_2
XFILLER_67_637 VGND VGND VPWR VPWR sky130_fd_sc_hd__fill_1
X_2110_ _1366_ _1367_ B_reg\[10\] VGND VGND VPWR VPWR _1369_ sky130_fd_sc_hd__mux2_1
X_2041_ _1294_ _1297_ _1292_ VGND VGND VPWR VPWR _1303_ sky130_fd_sc_hd__o21ai_1
XFILLER_94_489 VPWR VGND VPWR VGND sky130_ef_sc_hd__decap_12
XFILLER_75_670 VGND VGND VPWR VPWR sky130_fd_sc_hd__fill_2
XFILLER_63_821 VPWR VGND VPWR VGND sky130_ef_sc_hd__decap_12
XFILLER_63_865 VPWR VGND VPWR VGND sky130_ef_sc_hd__decap_12
XFILLER_23_729 VPWR VGND VPWR VGND sky130_ef_sc_hd__decap_12
X_2943_ _0566_ _0608_ VGND VGND VPWR VPWR _0631_ sky130_fd_sc_hd__nor2_1
XFILLER_16_781 VPWR VGND VPWR VGND sky130_ef_sc_hd__decap_12
XFILLER_22_228 VGND VGND VPWR VPWR sky130_fd_sc_hd__decap_4
XANTENNA__2713__A a_r3\[3\] VGND VGND VPWR VPWR sky130_fd_sc_hd__diode_2
X_2874_ u_crt.r2\[2\] u_crt.r2\[0\] VGND VGND VPWR VPWR _0562_ sky130_fd_sc_hd__nand2_2
XFILLER_148_469 VGND VGND VPWR VPWR sky130_fd_sc_hd__decap_6
X_1825_ _1097_ _1087_ _1090_ VGND VGND VPWR VPWR _1098_ sky130_fd_sc_hd__mux2_1
X_1756_ _0889_ _1021_ _1026_ VGND VGND VPWR VPWR _1029_ sky130_fd_sc_hd__or3_1
XFILLER_116_333 VPWR VGND VPWR VGND sky130_ef_sc_hd__decap_12
XANTENNA__2859__S _0383_ VGND VGND VPWR VPWR sky130_fd_sc_hd__diode_2
XFILLER_7_490 VPWR VGND VPWR VGND sky130_ef_sc_hd__decap_12
XFILLER_132_837 VPWR VGND VPWR VGND sky130_ef_sc_hd__decap_12
XFILLER_117_889 VGND VGND VPWR VPWR sky130_fd_sc_hd__decap_6
XFILLER_116_377 VPWR VGND VPWR VGND sky130_ef_sc_hd__decap_12
X_1687_ _0961_ _0962_ VGND VGND VPWR VPWR _0963_ sky130_fd_sc_hd__or2_1
XFILLER_100_701 VPWR VGND VPWR VGND sky130_ef_sc_hd__decap_12
XFILLER_97_261 VGND VGND VPWR VPWR sky130_fd_sc_hd__decap_8
XTAP_TAPCELL_ROW_5_416 VGND VPWR sky130_fd_sc_hd__tapvpwrvgnd_1
XTAP_TAPCELL_ROW_5_405 VGND VPWR sky130_fd_sc_hd__tapvpwrvgnd_1
XFILLER_140_881 VPWR VGND VPWR VGND sky130_ef_sc_hd__decap_12
XFILLER_58_626 VPWR VGND VPWR VGND sky130_ef_sc_hd__decap_12
XFILLER_57_125 VPWR VGND VPWR VGND sky130_ef_sc_hd__decap_12
X_2308_ _0899_ _1555_ _1557_ VGND VGND VPWR VPWR _1561_ sky130_fd_sc_hd__and3_1
XTAP_TAPCELL_ROW_51_1147 VGND VPWR sky130_fd_sc_hd__tapvpwrvgnd_1
XTAP_TAPCELL_ROW_146_2675 VGND VPWR sky130_fd_sc_hd__tapvpwrvgnd_1
XTAP_TAPCELL_ROW_146_2664 VGND VPWR sky130_fd_sc_hd__tapvpwrvgnd_1
XFILLER_57_169 VPWR VGND VPWR VGND sky130_ef_sc_hd__decap_12
X_3288_ clknet_3_5__leaf_clk _0071_ net36 VGND VGND VPWR VPWR A_reg\[14\] sky130_fd_sc_hd__dfrtp_4
XANTENNA__1894__B2 net35 VGND VGND VPWR VPWR sky130_fd_sc_hd__diode_2
XFILLER_73_629 VPWR VGND VPWR VGND sky130_ef_sc_hd__decap_12
XFILLER_72_128 VGND VGND VPWR VPWR sky130_fd_sc_hd__fill_2
XFILLER_66_681 VGND VGND VPWR VPWR sky130_fd_sc_hd__decap_3
XFILLER_26_501 VPWR VGND VPWR VGND sky130_ef_sc_hd__decap_12
XFILLER_38_361 VGND VGND VPWR VPWR sky130_fd_sc_hd__decap_3
X_2239_ _1491_ _1493_ _1495_ VGND VGND VPWR VPWR _1496_ sky130_fd_sc_hd__a21o_1
XFILLER_81_673 VPWR VGND VPWR VGND sky130_ef_sc_hd__decap_12
XFILLER_26_589 VPWR VGND VPWR VGND sky130_ef_sc_hd__decap_12
XTAP_TAPCELL_ROW_66_1390 VGND VPWR sky130_fd_sc_hd__tapvpwrvgnd_1
XFILLER_13_217 VGND VGND VPWR VPWR sky130_fd_sc_hd__decap_6
XTAP_TAPCELL_ROW_24_713 VGND VPWR sky130_fd_sc_hd__tapvpwrvgnd_1
XFILLER_110_77 VGND VGND VPWR VPWR sky130_fd_sc_hd__decap_6
XFILLER_70_15 VGND VGND VPWR VPWR sky130_fd_sc_hd__fill_1
XFILLER_41_559 VGND VGND VPWR VPWR sky130_fd_sc_hd__fill_1
XFILLER_139_447 VGND VGND VPWR VPWR sky130_fd_sc_hd__fill_1
XFILLER_127_609 VGND VGND VPWR VPWR sky130_fd_sc_hd__decap_6
XFILLER_135_653 VPWR VGND VPWR VGND sky130_ef_sc_hd__decap_12
XFILLER_134_141 VPWR VGND VPWR VGND sky130_ef_sc_hd__decap_12
XFILLER_119_193 VPWR VGND VPWR VGND sky130_ef_sc_hd__decap_12
XFILLER_108_867 VGND VGND VPWR VPWR sky130_fd_sc_hd__fill_1
XANTENNA__3227__Q b_r1\[0\] VGND VGND VPWR VPWR sky130_fd_sc_hd__diode_2
XANTENNA__3246__RESET_B net36 VGND VGND VPWR VPWR sky130_fd_sc_hd__diode_2
XFILLER_5_449 VPWR VGND VPWR VGND sky130_ef_sc_hd__decap_12
XFILLER_150_601 VPWR VGND VPWR VGND sky130_ef_sc_hd__decap_12
XFILLER_135_697 VPWR VGND VPWR VGND sky130_ef_sc_hd__decap_12
XFILLER_102_3 VPWR VGND VPWR VGND sky130_ef_sc_hd__decap_12
XFILLER_79_57 VPWR VGND VPWR VGND sky130_ef_sc_hd__decap_12
XFILLER_150_645 VPWR VGND VPWR VGND sky130_ef_sc_hd__decap_12
XFILLER_95_209 VPWR VGND VPWR VGND sky130_ef_sc_hd__decap_12
XFILLER_76_401 VPWR VGND VPWR VGND sky130_ef_sc_hd__decap_12
XANTENNA__3173__B _0912_ VGND VGND VPWR VPWR sky130_fd_sc_hd__diode_2
XFILLER_88_294 VPWR VGND VPWR VGND sky130_ef_sc_hd__decap_12
XANTENNA__1885__A1 A_reg\[1\] VGND VGND VPWR VPWR sky130_fd_sc_hd__diode_2
XFILLER_0_165 VGND VGND VPWR VPWR sky130_fd_sc_hd__decap_3
XFILLER_92_905 VGND VGND VPWR VPWR sky130_fd_sc_hd__decap_4
XFILLER_76_445 VPWR VGND VPWR VGND sky130_ef_sc_hd__decap_12
XANTENNA_input22_A B_in[14] VGND VGND VPWR VPWR sky130_fd_sc_hd__diode_2
XFILLER_36_309 VPWR VGND VPWR VGND sky130_ef_sc_hd__decap_12
XFILLER_151_51 VGND VGND VPWR VPWR sky130_fd_sc_hd__decap_4
XFILLER_91_426 VPWR VGND VPWR VGND sky130_ef_sc_hd__decap_12
XTAP_TAPCELL_ROW_86_1711 VGND VPWR sky130_fd_sc_hd__tapvpwrvgnd_1
XTAP_TAPCELL_ROW_86_1700 VGND VPWR sky130_fd_sc_hd__tapvpwrvgnd_1
XFILLER_76_489 VPWR VGND VPWR VGND sky130_ef_sc_hd__decap_12
XFILLER_28_83 VGND VGND VPWR VPWR sky130_fd_sc_hd__fill_1
XFILLER_29_361 VPWR VGND VPWR VGND sky130_ef_sc_hd__decap_12
XANTENNA__1702__A A_reg\[4\] VGND VGND VPWR VPWR sky130_fd_sc_hd__diode_2
XFILLER_45_821 VPWR VGND VPWR VGND sky130_ef_sc_hd__decap_12
XFILLER_63_139 VPWR VGND VPWR VGND sky130_ef_sc_hd__decap_12
XFILLER_44_375 VPWR VGND VPWR VGND sky130_ef_sc_hd__decap_12
XFILLER_60_835 VPWR VGND VPWR VGND sky130_ef_sc_hd__decap_12
XFILLER_32_537 VGND VGND VPWR VPWR sky130_fd_sc_hd__fill_1
XFILLER_8_221 VPWR VGND VPWR VGND sky130_ef_sc_hd__decap_12
XPHY_EDGE_ROW_4_Left_158 VGND VGND VPWR VPWR sky130_fd_sc_hd__decap_3
XFILLER_12_261 VGND VGND VPWR VPWR sky130_fd_sc_hd__fill_2
XFILLER_40_581 VGND VGND VPWR VPWR sky130_fd_sc_hd__decap_6
XFILLER_145_417 VPWR VGND VPWR VGND sky130_ef_sc_hd__decap_12
XTAP_TAPCELL_ROW_117_2210 VGND VPWR sky130_fd_sc_hd__tapvpwrvgnd_1
XFILLER_9_777 VGND VGND VPWR VPWR sky130_fd_sc_hd__decap_6
XFILLER_8_265 VPWR VGND VPWR VGND sky130_ef_sc_hd__decap_12
X_1610_ A_reg\[9\] VGND VGND VPWR VPWR _0890_ sky130_fd_sc_hd__inv_2
XTAP_TAPCELL_ROW_130_2410 VGND VPWR sky130_fd_sc_hd__tapvpwrvgnd_1
XTAP_TAPCELL_ROW_97_1884 VGND VPWR sky130_fd_sc_hd__tapvpwrvgnd_1
X_2590_ _0318_ _0334_ _0332_ VGND VGND VPWR VPWR _0335_ sky130_fd_sc_hd__a21o_1
XTAP_TAPCELL_ROW_10_495 VGND VPWR sky130_fd_sc_hd__tapvpwrvgnd_1
XTAP_TAPCELL_ROW_10_484 VGND VPWR sky130_fd_sc_hd__tapvpwrvgnd_1
XFILLER_153_461 VPWR VGND VPWR VGND sky130_ef_sc_hd__decap_12
XFILLER_114_837 VPWR VGND VPWR VGND sky130_ef_sc_hd__decap_12
XFILLER_140_133 VGND VGND VPWR VPWR sky130_fd_sc_hd__decap_6
XFILLER_99_559 VGND VGND VPWR VPWR sky130_fd_sc_hd__fill_1
XFILLER_86_209 VPWR VGND VPWR VGND sky130_ef_sc_hd__decap_12
X_3211_ X_crt\[15\] _0912_ VGND VGND VPWR VPWR _0104_ sky130_fd_sc_hd__and2_1
XFILLER_140_177 VPWR VGND VPWR VGND sky130_ef_sc_hd__decap_12
XFILLER_122_881 VPWR VGND VPWR VGND sky130_ef_sc_hd__decap_12
XFILLER_95_721 VGND VGND VPWR VPWR sky130_fd_sc_hd__decap_6
X_3142_ _0803_ _0826_ VGND VGND VPWR VPWR _0830_ sky130_fd_sc_hd__and2_1
XFILLER_39_125 VPWR VGND VPWR VGND sky130_ef_sc_hd__decap_12
XTAP_TAPCELL_ROW_128_2372 VGND VPWR sky130_fd_sc_hd__tapvpwrvgnd_1
XFILLER_121_391 VGND VGND VPWR VPWR sky130_fd_sc_hd__fill_1
XFILLER_95_765 VPWR VGND VPWR VGND sky130_ef_sc_hd__decap_12
XFILLER_94_253 VPWR VGND VPWR VGND sky130_ef_sc_hd__decap_12
XTAP_TAPCELL_ROW_128_2383 VGND VPWR sky130_fd_sc_hd__tapvpwrvgnd_1
XFILLER_48_670 VPWR VGND VPWR VGND sky130_ef_sc_hd__decap_12
XANTENNA__1612__A A_reg\[7\] VGND VGND VPWR VPWR sky130_fd_sc_hd__diode_2
XFILLER_39_169 VPWR VGND VPWR VGND sky130_ef_sc_hd__decap_12
X_3073_ _0741_ _0760_ _0731_ VGND VGND VPWR VPWR _0761_ sky130_fd_sc_hd__a21oi_1
X_2024_ B_reg\[8\] _1282_ _1284_ VGND VGND VPWR VPWR _1286_ sky130_fd_sc_hd__or3b_1
XFILLER_35_320 VPWR VGND VPWR VGND sky130_ef_sc_hd__decap_12
XTAP_TAPCELL_ROW_141_2583 VGND VPWR sky130_fd_sc_hd__tapvpwrvgnd_1
XFILLER_63_673 VPWR VGND VPWR VGND sky130_ef_sc_hd__decap_12
XFILLER_51_802 VGND VGND VPWR VPWR sky130_fd_sc_hd__decap_4
XTAP_TAPCELL_ROW_141_2594 VGND VPWR sky130_fd_sc_hd__tapvpwrvgnd_1
XFILLER_51_835 VGND VGND VPWR VPWR sky130_fd_sc_hd__decap_4
XFILLER_50_301 VGND VGND VPWR VPWR sky130_fd_sc_hd__decap_6
XFILLER_50_345 VPWR VGND VPWR VGND sky130_ef_sc_hd__decap_12
XFILLER_23_559 VGND VGND VPWR VPWR sky130_fd_sc_hd__fill_1
XFILLER_148_233 VPWR VGND VPWR VGND sky130_ef_sc_hd__decap_12
XANTENNA__2053__A1 B_reg\[5\] VGND VGND VPWR VPWR sky130_fd_sc_hd__diode_2
X_2926_ _0593_ _0599_ VGND VGND VPWR VPWR _0614_ sky130_fd_sc_hd__nand2_1
XFILLER_50_389 VGND VGND VPWR VPWR sky130_fd_sc_hd__decap_4
XFILLER_10_209 VPWR VGND VPWR VGND sky130_ef_sc_hd__decap_12
XFILLER_109_609 VGND VGND VPWR VPWR sky130_fd_sc_hd__decap_6
X_2857_ net30 B_reg\[7\] _0383_ VGND VGND VPWR VPWR _0080_ sky130_fd_sc_hd__mux2_1
XANTENNA__1800__A1 A_reg\[4\] VGND VGND VPWR VPWR sky130_fd_sc_hd__diode_2
XFILLER_148_277 VPWR VGND VPWR VGND sky130_ef_sc_hd__decap_12
XFILLER_40_29 VPWR VGND VPWR VGND sky130_ef_sc_hd__decap_12
X_1808_ A_reg\[4\] _1076_ _1071_ VGND VGND VPWR VPWR _1081_ sky130_fd_sc_hd__o21ai_1
XFILLER_117_653 VPWR VGND VPWR VGND sky130_ef_sc_hd__decap_12
X_2788_ _0526_ _0527_ VGND VGND VPWR VPWR _0528_ sky130_fd_sc_hd__nand2_1
XFILLER_3_909 VGND VGND VPWR VPWR sky130_fd_sc_hd__fill_1
XFILLER_132_601 VPWR VGND VPWR VGND sky130_ef_sc_hd__decap_12
XFILLER_117_697 VPWR VGND VPWR VGND sky130_ef_sc_hd__decap_12
XFILLER_116_141 VPWR VGND VPWR VGND sky130_ef_sc_hd__decap_12
X_1739_ A_reg\[13\] _0923_ VGND VGND VPWR VPWR _1012_ sky130_fd_sc_hd__or2_1
XFILLER_2_419 VGND VGND VPWR VPWR sky130_fd_sc_hd__fill_1
XTAP_TAPCELL_ROW_148_2704 VGND VPWR sky130_fd_sc_hd__tapvpwrvgnd_1
XFILLER_132_645 VPWR VGND VPWR VGND sky130_ef_sc_hd__decap_12
XFILLER_131_111 VGND VGND VPWR VPWR sky130_fd_sc_hd__fill_1
XFILLER_58_401 VGND VGND VPWR VPWR sky130_fd_sc_hd__decap_6
XFILLER_105_44 VPWR VGND VPWR VGND sky130_ef_sc_hd__decap_12
XFILLER_100_553 VGND VGND VPWR VPWR sky130_fd_sc_hd__fill_2
XFILLER_100_531 VGND VGND VPWR VPWR sky130_fd_sc_hd__fill_1
XFILLER_86_754 VGND VGND VPWR VPWR sky130_fd_sc_hd__fill_2
XFILLER_74_905 VGND VGND VPWR VPWR sky130_fd_sc_hd__decap_4
XFILLER_65_15 VGND VGND VPWR VPWR sky130_fd_sc_hd__fill_2
XANTENNA__1867__A1 A_reg\[6\] VGND VGND VPWR VPWR sky130_fd_sc_hd__diode_2
XFILLER_58_489 VPWR VGND VPWR VGND sky130_ef_sc_hd__decap_12
XFILLER_18_309 VPWR VGND VPWR VGND sky130_ef_sc_hd__decap_12
XFILLER_27_821 VPWR VGND VPWR VGND sky130_ef_sc_hd__decap_12
XFILLER_39_681 VGND VGND VPWR VPWR sky130_fd_sc_hd__fill_2
XANTENNA__2816__B1 _0184_ VGND VGND VPWR VPWR sky130_fd_sc_hd__diode_2
XFILLER_26_320 VPWR VGND VPWR VGND sky130_ef_sc_hd__decap_12
XFILLER_60_109 VPWR VGND VPWR VGND sky130_ef_sc_hd__decap_12
XFILLER_53_150 VGND VGND VPWR VPWR sky130_fd_sc_hd__fill_1
XFILLER_27_865 VPWR VGND VPWR VGND sky130_ef_sc_hd__decap_12
XFILLER_42_813 VGND VGND VPWR VPWR sky130_fd_sc_hd__fill_1
XTAP_TAPCELL_ROW_64_1349 VGND VPWR sky130_fd_sc_hd__tapvpwrvgnd_1
XTAP_TAPCELL_ROW_81_1630 VGND VPWR sky130_fd_sc_hd__tapvpwrvgnd_1
XFILLER_81_69 VPWR VGND VPWR VGND sky130_ef_sc_hd__decap_12
XFILLER_41_334 VGND VGND VPWR VPWR sky130_fd_sc_hd__fill_2
XFILLER_14_41 VPWR VGND VPWR VGND sky130_ef_sc_hd__decap_12
XFILLER_14_85 VPWR VGND VPWR VGND sky130_ef_sc_hd__decap_12
XFILLER_22_581 VGND VGND VPWR VPWR sky130_fd_sc_hd__decap_6
XFILLER_127_417 VPWR VGND VPWR VGND sky130_ef_sc_hd__decap_12
XFILLER_6_725 VPWR VGND VPWR VGND sky130_ef_sc_hd__decap_12
XFILLER_6_769 VPWR VGND VPWR VGND sky130_ef_sc_hd__decap_12
XFILLER_135_461 VPWR VGND VPWR VGND sky130_ef_sc_hd__decap_12
XTAP_TAPCELL_ROW_79_1592 VGND VPWR sky130_fd_sc_hd__tapvpwrvgnd_1
XFILLER_150_475 VGND VGND VPWR VPWR sky130_fd_sc_hd__fill_1
XFILLER_122_133 VGND VGND VPWR VPWR sky130_fd_sc_hd__decap_6
XFILLER_1_441 VGND VGND VPWR VPWR sky130_fd_sc_hd__decap_6
XFILLER_122_177 VPWR VGND VPWR VGND sky130_ef_sc_hd__decap_12
XFILLER_104_881 VPWR VGND VPWR VGND sky130_ef_sc_hd__decap_12
XFILLER_77_710 VPWR VGND VPWR VGND sky130_ef_sc_hd__decap_12
XFILLER_1_485 VPWR VGND VPWR VGND sky130_ef_sc_hd__decap_12
XFILLER_77_743 VGND VGND VPWR VPWR sky130_fd_sc_hd__decap_4
XFILLER_49_434 VPWR VGND VPWR VGND sky130_ef_sc_hd__decap_12
XANTENNA__1858__A1 A_reg\[9\] VGND VGND VPWR VPWR sky130_fd_sc_hd__diode_2
XFILLER_39_93 VPWR VGND VPWR VGND sky130_ef_sc_hd__decap_12
XFILLER_92_713 VPWR VGND VPWR VGND sky130_ef_sc_hd__decap_12
XFILLER_76_253 VPWR VGND VPWR VGND sky130_ef_sc_hd__decap_12
XFILLER_37_629 VPWR VGND VPWR VGND sky130_ef_sc_hd__decap_12
XFILLER_92_757 VPWR VGND VPWR VGND sky130_ef_sc_hd__decap_12
XFILLER_36_139 VGND VGND VPWR VPWR sky130_fd_sc_hd__fill_1
XFILLER_45_673 VPWR VGND VPWR VGND sky130_ef_sc_hd__decap_12
XFILLER_72_492 VGND VGND VPWR VPWR sky130_fd_sc_hd__fill_2
XFILLER_17_386 VGND VGND VPWR VPWR sky130_fd_sc_hd__decap_6
XFILLER_44_161 VGND VGND VPWR VPWR sky130_fd_sc_hd__fill_2
XFILLER_60_643 VGND VGND VPWR VPWR sky130_fd_sc_hd__fill_1
XFILLER_32_345 VPWR VGND VPWR VGND sky130_ef_sc_hd__decap_12
XTAP_TAPCELL_ROW_15_565 VGND VPWR sky130_fd_sc_hd__tapvpwrvgnd_1
XTAP_TAPCELL_ROW_15_576 VGND VPWR sky130_fd_sc_hd__tapvpwrvgnd_1
XFILLER_32_389 VPWR VGND VPWR VGND sky130_ef_sc_hd__decap_12
X_2711_ _0411_ _0448_ _0449_ VGND VGND VPWR VPWR _0451_ sky130_fd_sc_hd__and3_1
XTAP_TAPCELL_ROW_99_1913 VGND VPWR sky130_fd_sc_hd__tapvpwrvgnd_1
XFILLER_9_541 VPWR VGND VPWR VGND sky130_ef_sc_hd__decap_12
XFILLER_146_737 VPWR VGND VPWR VGND sky130_ef_sc_hd__decap_12
XFILLER_145_225 VPWR VGND VPWR VGND sky130_ef_sc_hd__decap_12
XFILLER_9_585 VPWR VGND VPWR VGND sky130_ef_sc_hd__decap_12
X_2642_ net33 OpSel_reg\[0\] _0383_ VGND VGND VPWR VPWR _0035_ sky130_fd_sc_hd__mux2_1
XFILLER_65_3 VPWR VGND VPWR VGND sky130_ef_sc_hd__decap_12
XFILLER_114_601 VPWR VGND VPWR VGND sky130_ef_sc_hd__decap_12
X_2573_ a_r2\[0\] b_r2\[0\] VGND VGND VPWR VPWR _0318_ sky130_fd_sc_hd__nand2_1
XFILLER_114_645 VPWR VGND VPWR VGND sky130_ef_sc_hd__decap_12
XFILLER_113_111 VGND VGND VPWR VPWR sky130_fd_sc_hd__fill_1
XANTENNA__1607__A A_reg\[15\] VGND VGND VPWR VPWR sky130_fd_sc_hd__diode_2
XFILLER_141_497 VGND VGND VPWR VPWR sky130_fd_sc_hd__decap_6
XFILLER_101_317 VPWR VGND VPWR VGND sky130_ef_sc_hd__decap_12
XFILLER_87_529 VPWR VGND VPWR VGND sky130_ef_sc_hd__decap_12
XFILLER_68_732 VPWR VGND VPWR VGND sky130_ef_sc_hd__decap_12
XFILLER_56_905 VGND VGND VPWR VPWR sky130_fd_sc_hd__fill_2
XTAP_TAPCELL_ROW_143_2623 VGND VPWR sky130_fd_sc_hd__tapvpwrvgnd_1
XTAP_TAPCELL_ROW_143_2612 VGND VPWR sky130_fd_sc_hd__tapvpwrvgnd_1
X_3125_ _0786_ _0812_ _0799_ _0795_ VGND VGND VPWR VPWR _0813_ sky130_fd_sc_hd__o2bb2a_1
X_3056_ _0688_ _0743_ VGND VGND VPWR VPWR _0744_ sky130_fd_sc_hd__nand2b_1
X_2007_ _0900_ _1267_ _1268_ VGND VGND VPWR VPWR _1269_ sky130_fd_sc_hd__and3_1
XFILLER_24_813 VPWR VGND VPWR VGND sky130_ef_sc_hd__decap_12
XFILLER_42_109 VPWR VGND VPWR VGND sky130_ef_sc_hd__decap_12
XFILLER_82_289 VPWR VGND VPWR VGND sky130_ef_sc_hd__decap_12
XFILLER_35_161 VGND VGND VPWR VPWR sky130_fd_sc_hd__decap_6
XFILLER_51_665 VGND VGND VPWR VPWR sky130_fd_sc_hd__decap_3
XTAP_TAPCELL_ROW_46_1068 VGND VPWR sky130_fd_sc_hd__tapvpwrvgnd_1
XFILLER_50_153 VPWR VGND VPWR VGND sky130_ef_sc_hd__decap_12
XFILLER_11_529 VPWR VGND VPWR VGND sky130_ef_sc_hd__decap_12
XTAP_TAPCELL_ROW_34_874 VGND VPWR sky130_fd_sc_hd__tapvpwrvgnd_1
XFILLER_149_553 VGND VGND VPWR VPWR sky130_fd_sc_hd__decap_6
XFILLER_51_39 VGND VGND VPWR VPWR sky130_fd_sc_hd__decap_8
XFILLER_149_597 VPWR VGND VPWR VGND sky130_ef_sc_hd__decap_12
XFILLER_109_417 VGND VGND VPWR VPWR sky130_fd_sc_hd__decap_8
X_2909_ _0583_ _0594_ VGND VGND VPWR VPWR _0597_ sky130_fd_sc_hd__or2_1
XFILLER_151_217 VGND VGND VPWR VPWR sky130_fd_sc_hd__decap_6
XFILLER_117_461 VPWR VGND VPWR VGND sky130_ef_sc_hd__decap_12
XFILLER_104_133 VGND VGND VPWR VPWR sky130_fd_sc_hd__decap_6
XFILLER_2_249 VGND VGND VPWR VPWR sky130_fd_sc_hd__decap_3
XFILLER_132_475 VGND VGND VPWR VPWR sky130_fd_sc_hd__fill_1
XFILLER_120_637 VGND VGND VPWR VPWR sky130_fd_sc_hd__decap_6
XFILLER_116_65 VPWR VGND VPWR VGND sky130_ef_sc_hd__decap_12
XFILLER_104_177 VPWR VGND VPWR VGND sky130_ef_sc_hd__decap_12
XANTENNA__3214__CLK clknet_3_3__leaf_clk VGND VGND VPWR VPWR sky130_fd_sc_hd__diode_2
XFILLER_101_895 VGND VGND VPWR VPWR sky130_fd_sc_hd__fill_1
XFILLER_58_253 VGND VGND VPWR VPWR sky130_fd_sc_hd__decap_8
XFILLER_19_629 VPWR VGND VPWR VGND sky130_ef_sc_hd__decap_12
XFILLER_132_53 VPWR VGND VPWR VGND sky130_ef_sc_hd__decap_12
XFILLER_74_746 VGND VGND VPWR VPWR sky130_fd_sc_hd__decap_8
XFILLER_18_139 VGND VGND VPWR VPWR sky130_fd_sc_hd__fill_1
XFILLER_46_459 VGND VGND VPWR VPWR sky130_fd_sc_hd__fill_1
XPHY_EDGE_ROW_85_Left_239 VGND VGND VPWR VPWR sky130_fd_sc_hd__decap_3
XFILLER_132_97 VPWR VGND VPWR VGND sky130_ef_sc_hd__decap_12
XFILLER_27_673 VPWR VGND VPWR VGND sky130_ef_sc_hd__decap_12
XFILLER_25_51 VGND VGND VPWR VPWR sky130_fd_sc_hd__decap_4
XFILLER_30_805 VGND VGND VPWR VPWR sky130_fd_sc_hd__decap_6
XFILLER_42_643 VGND VGND VPWR VPWR sky130_fd_sc_hd__fill_1
XPHY_EDGE_ROW_153_Right_153 VGND VGND VPWR VPWR sky130_fd_sc_hd__decap_3
XTAP_TAPCELL_ROW_12_524 VGND VPWR sky130_fd_sc_hd__tapvpwrvgnd_1
XANTENNA__3261__RESET_B net36 VGND VGND VPWR VPWR sky130_fd_sc_hd__diode_2
XFILLER_128_737 VPWR VGND VPWR VGND sky130_ef_sc_hd__decap_12
XFILLER_127_225 VPWR VGND VPWR VGND sky130_ef_sc_hd__decap_12
XFILLER_6_533 VPWR VGND VPWR VGND sky130_ef_sc_hd__decap_12
XFILLER_143_729 VPWR VGND VPWR VGND sky130_ef_sc_hd__decap_12
XTAP_TAPCELL_ROW_94_1843 VGND VPWR sky130_fd_sc_hd__tapvpwrvgnd_1
XTAP_TAPCELL_ROW_94_1832 VGND VPWR sky130_fd_sc_hd__tapvpwrvgnd_1
XPHY_EDGE_ROW_94_Left_248 VGND VGND VPWR VPWR sky130_fd_sc_hd__decap_3
XFILLER_136_781 VPWR VGND VPWR VGND sky130_ef_sc_hd__decap_12
XFILLER_123_497 VGND VGND VPWR VPWR sky130_fd_sc_hd__decap_6
XFILLER_111_615 VGND VGND VPWR VPWR sky130_fd_sc_hd__fill_1
XFILLER_69_529 VGND VGND VPWR VPWR sky130_fd_sc_hd__decap_4
XFILLER_1_293 VPWR VGND VPWR VGND sky130_ef_sc_hd__decap_12
XFILLER_77_573 VPWR VGND VPWR VGND sky130_ef_sc_hd__decap_12
XFILLER_65_702 VGND VGND VPWR VPWR sky130_fd_sc_hd__decap_8
XFILLER_64_201 VPWR VGND VPWR VGND sky130_ef_sc_hd__decap_12
XFILLER_2_77 VGND VGND VPWR VPWR sky130_fd_sc_hd__decap_6
XANTENNA__2258__A A_reg\[3\] VGND VGND VPWR VPWR sky130_fd_sc_hd__diode_2
XTAP_TAPCELL_ROW_125_2331 VGND VPWR sky130_fd_sc_hd__tapvpwrvgnd_1
XFILLER_64_289 VPWR VGND VPWR VGND sky130_ef_sc_hd__decap_12
XANTENNA__2256__A1 A_reg\[2\] VGND VGND VPWR VPWR sky130_fd_sc_hd__diode_2
XFILLER_17_161 VGND VGND VPWR VPWR sky130_fd_sc_hd__decap_6
XFILLER_24_109 VPWR VGND VPWR VGND sky130_ef_sc_hd__decap_12
XFILLER_33_665 VGND VGND VPWR VPWR sky130_fd_sc_hd__decap_6
XTAP_TAPCELL_ROW_103_1972 VGND VPWR sky130_fd_sc_hd__tapvpwrvgnd_1
XFILLER_32_153 VPWR VGND VPWR VGND sky130_ef_sc_hd__decap_12
XPHY_EDGE_ROW_120_Right_120 VGND VGND VPWR VPWR sky130_fd_sc_hd__decap_3
XTAP_TAPCELL_ROW_103_1983 VGND VPWR sky130_fd_sc_hd__tapvpwrvgnd_1
XTAP_TAPCELL_ROW_31_822 VGND VPWR sky130_fd_sc_hd__tapvpwrvgnd_1
XTAP_TAPCELL_ROW_31_833 VGND VPWR sky130_fd_sc_hd__tapvpwrvgnd_1
XFILLER_32_197 VPWR VGND VPWR VGND sky130_ef_sc_hd__decap_12
XFILLER_146_501 VPWR VGND VPWR VGND sky130_ef_sc_hd__decap_12
XFILLER_146_545 VPWR VGND VPWR VGND sky130_ef_sc_hd__decap_12
XFILLER_9_393 VPWR VGND VPWR VGND sky130_ef_sc_hd__decap_12
XFILLER_146_589 VPWR VGND VPWR VGND sky130_ef_sc_hd__decap_12
X_2625_ _0318_ _0369_ VGND VGND VPWR VPWR _0370_ sky130_fd_sc_hd__nand2_1
XFILLER_133_217 VGND VGND VPWR VPWR sky130_fd_sc_hd__decap_6
XANTENNA__3237__CLK clknet_3_3__leaf_clk VGND VGND VPWR VPWR sky130_fd_sc_hd__diode_2
XFILLER_88_805 VGND VGND VPWR VPWR sky130_fd_sc_hd__decap_6
X_2556_ _0293_ _0299_ _0302_ VGND VGND VPWR VPWR _0303_ sky130_fd_sc_hd__a21o_1
XFILLER_141_261 VPWR VGND VPWR VGND sky130_ef_sc_hd__decap_12
XFILLER_114_475 VGND VGND VPWR VPWR sky130_fd_sc_hd__fill_1
XFILLER_102_637 VGND VGND VPWR VPWR sky130_fd_sc_hd__decap_6
XFILLER_88_849 VPWR VGND VPWR VGND sky130_ef_sc_hd__decap_12
XFILLER_87_304 VPWR VGND VPWR VGND sky130_ef_sc_hd__decap_12
X_2487_ _0234_ _0218_ VGND VGND VPWR VPWR _0235_ sky130_fd_sc_hd__nand2b_1
XFILLER_101_125 VPWR VGND VPWR VGND sky130_ef_sc_hd__decap_12
XFILLER_87_337 VPWR VGND VPWR VGND sky130_ef_sc_hd__decap_12
XFILLER_101_169 VPWR VGND VPWR VGND sky130_ef_sc_hd__decap_12
XFILLER_96_893 VPWR VGND VPWR VGND sky130_ef_sc_hd__decap_12
XFILLER_56_713 VPWR VGND VPWR VGND sky130_ef_sc_hd__decap_12
XFILLER_110_681 VPWR VGND VPWR VGND sky130_ef_sc_hd__decap_12
XFILLER_55_223 VGND VGND VPWR VPWR sky130_fd_sc_hd__fill_1
X_3108_ _0784_ _0795_ VGND VGND VPWR VPWR _0796_ sky130_fd_sc_hd__nor2_1
XTAP_TAPCELL_ROW_39_955 VGND VPWR sky130_fd_sc_hd__tapvpwrvgnd_1
XFILLER_71_727 VGND VGND VPWR VPWR sky130_fd_sc_hd__fill_1
X_3039_ _0725_ _0726_ VGND VGND VPWR VPWR _0727_ sky130_fd_sc_hd__nand2_1
XFILLER_36_470 VGND VGND VPWR VPWR sky130_fd_sc_hd__decap_6
XFILLER_43_429 VPWR VGND VPWR VGND sky130_ef_sc_hd__decap_12
XANTENNA__2247__A1 A_reg\[3\] VGND VGND VPWR VPWR sky130_fd_sc_hd__diode_2
XFILLER_62_27 VGND VGND VPWR VPWR sky130_fd_sc_hd__fill_1
XFILLER_24_643 VGND VGND VPWR VPWR sky130_fd_sc_hd__fill_1
XTAP_TAPCELL_ROW_61_1308 VGND VPWR sky130_fd_sc_hd__tapvpwrvgnd_1
XFILLER_12_805 VGND VGND VPWR VPWR sky130_fd_sc_hd__decap_6
XFILLER_11_337 VGND VGND VPWR VPWR sky130_fd_sc_hd__fill_1
XFILLER_12_849 VPWR VGND VPWR VGND sky130_ef_sc_hd__decap_12
XFILLER_149_361 VPWR VGND VPWR VGND sky130_ef_sc_hd__decap_12
XFILLER_109_225 VPWR VGND VPWR VGND sky130_ef_sc_hd__decap_12
XFILLER_20_893 VPWR VGND VPWR VGND sky130_ef_sc_hd__decap_12
XFILLER_125_729 VPWR VGND VPWR VGND sky130_ef_sc_hd__decap_12
XFILLER_118_781 VPWR VGND VPWR VGND sky130_ef_sc_hd__decap_12
XTAP_TAPCELL_ROW_76_1551 VGND VPWR sky130_fd_sc_hd__tapvpwrvgnd_1
XTAP_TAPCELL_ROW_76_1540 VGND VPWR sky130_fd_sc_hd__tapvpwrvgnd_1
XFILLER_120_401 VPWR VGND VPWR VGND sky130_ef_sc_hd__decap_12
XFILLER_105_497 VGND VGND VPWR VPWR sky130_fd_sc_hd__decap_6
XANTENNA__2722__A2 a_r3\[3\] VGND VGND VPWR VPWR sky130_fd_sc_hd__diode_2
XFILLER_87_57 VGND VGND VPWR VPWR sky130_fd_sc_hd__fill_2
XFILLER_87_46 VGND VGND VPWR VPWR sky130_fd_sc_hd__decap_8
XANTENNA__3235__Q a_r3\[3\] VGND VGND VPWR VPWR sky130_fd_sc_hd__diode_2
XFILLER_120_445 VPWR VGND VPWR VGND sky130_ef_sc_hd__decap_12
XFILLER_120_489 VPWR VGND VPWR VGND sky130_ef_sc_hd__decap_12
XFILLER_93_329 VGND VGND VPWR VPWR sky130_fd_sc_hd__decap_6
XANTENNA__2078__A B_reg\[1\] VGND VGND VPWR VPWR sky130_fd_sc_hd__diode_2
XTAP_TAPCELL_ROW_107_2050 VGND VPWR sky130_fd_sc_hd__tapvpwrvgnd_1
XFILLER_74_587 VGND VGND VPWR VPWR sky130_fd_sc_hd__fill_1
XFILLER_62_749 VGND VGND VPWR VPWR sky130_fd_sc_hd__decap_6
XFILLER_61_204 VPWR VGND VPWR VGND sky130_ef_sc_hd__decap_12
XTAP_TAPCELL_ROW_17_605 VGND VPWR sky130_fd_sc_hd__tapvpwrvgnd_1
XFILLER_61_237 VPWR VGND VPWR VGND sky130_ef_sc_hd__decap_12
XFILLER_36_83 VGND VGND VPWR VPWR sky130_fd_sc_hd__fill_1
XTAP_TAPCELL_ROW_120_2250 VGND VPWR sky130_fd_sc_hd__tapvpwrvgnd_1
XFILLER_14_153 VPWR VGND VPWR VGND sky130_ef_sc_hd__decap_12
XFILLER_15_665 VGND VGND VPWR VPWR sky130_fd_sc_hd__decap_6
XFILLER_30_613 VPWR VGND VPWR VGND sky130_ef_sc_hd__decap_12
XFILLER_14_197 VPWR VGND VPWR VGND sky130_ef_sc_hd__decap_12
XFILLER_128_501 VPWR VGND VPWR VGND sky130_ef_sc_hd__decap_12
XFILLER_30_657 VPWR VGND VPWR VGND sky130_ef_sc_hd__decap_12
XFILLER_128_545 VPWR VGND VPWR VGND sky130_ef_sc_hd__decap_12
Xinput25 B_in[2] VGND VGND VPWR VPWR net25 sky130_fd_sc_hd__clkbuf_1
Xinput14 A_in[7] VGND VGND VPWR VPWR net14 sky130_fd_sc_hd__clkbuf_1
Xinput36 rst_n VGND VGND VPWR VPWR net36 sky130_fd_sc_hd__clkbuf_16
XFILLER_128_589 VPWR VGND VPWR VGND sky130_ef_sc_hd__decap_12
XFILLER_7_853 VPWR VGND VPWR VGND sky130_ef_sc_hd__decap_12
XFILLER_115_217 VGND VGND VPWR VPWR sky130_fd_sc_hd__decap_6
X_2410_ _0159_ _0162_ _0157_ VGND VGND VPWR VPWR _0164_ sky130_fd_sc_hd__a21o_1
XFILLER_7_897 VPWR VGND VPWR VGND sky130_ef_sc_hd__decap_12
XFILLER_6_363 VGND VGND VPWR VPWR sky130_fd_sc_hd__fill_1
XFILLER_143_559 VGND VGND VPWR VPWR sky130_fd_sc_hd__fill_1
XFILLER_130_209 VPWR VGND VPWR VGND sky130_ef_sc_hd__decap_12
XFILLER_123_261 VPWR VGND VPWR VGND sky130_ef_sc_hd__decap_12
X_2341_ _1593_ VGND VGND VPWR VPWR _1594_ sky130_fd_sc_hd__inv_2
XFILLER_69_304 VPWR VGND VPWR VGND sky130_ef_sc_hd__decap_12
XFILLER_69_337 VPWR VGND VPWR VGND sky130_ef_sc_hd__decap_12
X_2272_ _1524_ _1525_ _1527_ A_reg\[1\] VGND VGND VPWR VPWR _1529_ sky130_fd_sc_hd__a2bb2o_1
XFILLER_28_3 VPWR VGND VPWR VGND sky130_ef_sc_hd__decap_12
XFILLER_38_713 VPWR VGND VPWR VGND sky130_ef_sc_hd__decap_12
XFILLER_93_841 VPWR VGND VPWR VGND sky130_ef_sc_hd__decap_12
XFILLER_78_893 VPWR VGND VPWR VGND sky130_ef_sc_hd__decap_12
XANTENNA__2477__B2 a_r1\[0\] VGND VGND VPWR VPWR sky130_fd_sc_hd__diode_2
XANTENNA__2477__A1 b_r1\[0\] VGND VGND VPWR VPWR sky130_fd_sc_hd__diode_2
XFILLER_37_223 VGND VGND VPWR VPWR sky130_fd_sc_hd__fill_1
XFILLER_38_757 VPWR VGND VPWR VGND sky130_ef_sc_hd__decap_12
XTAP_TAPCELL_ROW_36_903 VGND VPWR sky130_fd_sc_hd__tapvpwrvgnd_1
XTAP_TAPCELL_ROW_36_914 VGND VPWR sky130_fd_sc_hd__tapvpwrvgnd_1
XFILLER_33_473 VPWR VGND VPWR VGND sky130_ef_sc_hd__decap_12
XTAP_TAPCELL_ROW_43_1016 VGND VPWR sky130_fd_sc_hd__tapvpwrvgnd_1
XTAP_TAPCELL_ROW_138_2533 VGND VPWR sky130_fd_sc_hd__tapvpwrvgnd_1
XFILLER_60_281 VPWR VGND VPWR VGND sky130_ef_sc_hd__decap_12
XTAP_TAPCELL_ROW_43_1027 VGND VPWR sky130_fd_sc_hd__tapvpwrvgnd_1
XFILLER_147_821 VPWR VGND VPWR VGND sky130_ef_sc_hd__decap_12
XTAP_TAPCELL_ROW_138_2544 VGND VPWR sky130_fd_sc_hd__tapvpwrvgnd_1
XFILLER_138_309 VPWR VGND VPWR VGND sky130_ef_sc_hd__decap_12
X_1987_ b_r2\[0\] _1251_ Encode_EN VGND VGND VPWR VPWR _0011_ sky130_fd_sc_hd__mux2_1
XFILLER_147_865 VPWR VGND VPWR VGND sky130_ef_sc_hd__decap_12
XANTENNA__2451__A _0187_ VGND VGND VPWR VPWR sky130_fd_sc_hd__diode_2
XFILLER_20_189 VGND VGND VPWR VPWR sky130_fd_sc_hd__decap_6
XTAP_TAPCELL_ROW_151_2744 VGND VPWR sky130_fd_sc_hd__tapvpwrvgnd_1
XFILLER_107_729 VPWR VGND VPWR VGND sky130_ef_sc_hd__decap_12
XTAP_TAPCELL_ROW_151_2755 VGND VPWR sky130_fd_sc_hd__tapvpwrvgnd_1
X_2608_ _0326_ _0346_ _0352_ VGND VGND VPWR VPWR _0353_ sky130_fd_sc_hd__nand3_2
XFILLER_142_581 VGND VGND VPWR VPWR sky130_fd_sc_hd__decap_6
XFILLER_88_602 VGND VGND VPWR VPWR sky130_fd_sc_hd__fill_1
XFILLER_0_517 VGND VGND VPWR VPWR sky130_fd_sc_hd__fill_2
X_2539_ _0258_ _0282_ _0280_ VGND VGND VPWR VPWR _0287_ sky130_fd_sc_hd__o21ai_1
XFILLER_0_539 VGND VGND VPWR VPWR sky130_fd_sc_hd__fill_1
XFILLER_87_167 VGND VGND VPWR VPWR sky130_fd_sc_hd__fill_1
XTAP_TAPCELL_ROW_71_1470 VGND VPWR sky130_fd_sc_hd__tapvpwrvgnd_1
XTAP_TAPCELL_ROW_54_1189 VGND VPWR sky130_fd_sc_hd__tapvpwrvgnd_1
XFILLER_56_521 VGND VGND VPWR VPWR sky130_fd_sc_hd__decap_8
XFILLER_113_55 VGND VGND VPWR VPWR sky130_fd_sc_hd__fill_1
XTAP_TAPCELL_ROW_3_377 VGND VPWR sky130_fd_sc_hd__tapvpwrvgnd_1
XFILLER_83_373 VPWR VGND VPWR VGND sky130_ef_sc_hd__decap_12
XANTENNA__2626__A _0185_ VGND VGND VPWR VPWR sky130_fd_sc_hd__diode_2
XFILLER_73_15 VPWR VGND VPWR VGND sky130_ef_sc_hd__decap_12
XFILLER_56_587 VGND VGND VPWR VPWR sky130_fd_sc_hd__fill_1
XFILLER_28_289 VGND VGND VPWR VPWR sky130_fd_sc_hd__decap_8
XFILLER_44_716 VPWR VGND VPWR VGND sky130_ef_sc_hd__decap_12
XFILLER_43_237 VPWR VGND VPWR VGND sky130_ef_sc_hd__decap_12
XFILLER_51_281 VPWR VGND VPWR VGND sky130_ef_sc_hd__decap_12
XFILLER_132_3 VPWR VGND VPWR VGND sky130_ef_sc_hd__decap_12
XFILLER_7_105 VGND VGND VPWR VPWR sky130_fd_sc_hd__decap_6
XFILLER_12_657 VPWR VGND VPWR VGND sky130_ef_sc_hd__decap_12
XFILLER_11_167 VGND VGND VPWR VPWR sky130_fd_sc_hd__fill_1
XFILLER_22_41 VPWR VGND VPWR VGND sky130_ef_sc_hd__decap_12
XTAP_TAPCELL_ROW_22_685 VGND VPWR sky130_fd_sc_hd__tapvpwrvgnd_1
XFILLER_153_813 VPWR VGND VPWR VGND sky130_ef_sc_hd__decap_12
XFILLER_138_41 VPWR VGND VPWR VGND sky130_ef_sc_hd__decap_12
XFILLER_7_149 VPWR VGND VPWR VGND sky130_ef_sc_hd__decap_12
XFILLER_22_85 VPWR VGND VPWR VGND sky130_ef_sc_hd__decap_12
XFILLER_152_301 VGND VGND VPWR VPWR sky130_fd_sc_hd__decap_6
XFILLER_138_85 VPWR VGND VPWR VGND sky130_ef_sc_hd__decap_12
XFILLER_152_345 VPWR VGND VPWR VGND sky130_ef_sc_hd__decap_12
XFILLER_125_559 VGND VGND VPWR VPWR sky130_fd_sc_hd__fill_1
XFILLER_4_867 VGND VGND VPWR VPWR sky130_fd_sc_hd__fill_1
XFILLER_152_389 VPWR VGND VPWR VGND sky130_ef_sc_hd__decap_12
XFILLER_121_721 VGND VGND VPWR VPWR sky130_fd_sc_hd__decap_6
XFILLER_112_209 VPWR VGND VPWR VGND sky130_ef_sc_hd__decap_12
XFILLER_105_261 VPWR VGND VPWR VGND sky130_ef_sc_hd__decap_12
XFILLER_121_765 VPWR VGND VPWR VGND sky130_ef_sc_hd__decap_12
XFILLER_120_253 VPWR VGND VPWR VGND sky130_ef_sc_hd__decap_12
XFILLER_66_307 VGND VGND VPWR VPWR sky130_fd_sc_hd__fill_1
XFILLER_93_137 VPWR VGND VPWR VGND sky130_ef_sc_hd__decap_12
XANTENNA__2459__B2 _0185_ VGND VGND VPWR VPWR sky130_fd_sc_hd__diode_2
XFILLER_78_189 VGND VGND VPWR VPWR sky130_fd_sc_hd__decap_6
XFILLER_75_841 VPWR VGND VPWR VGND sky130_ef_sc_hd__decap_12
XFILLER_19_223 VGND VGND VPWR VPWR sky130_fd_sc_hd__fill_1
XTAP_TAPCELL_ROW_105_2009 VGND VPWR sky130_fd_sc_hd__tapvpwrvgnd_1
XTAP_TAPCELL_ROW_89_1753 VGND VPWR sky130_fd_sc_hd__tapvpwrvgnd_1
XFILLER_47_554 VGND VGND VPWR VPWR sky130_fd_sc_hd__decap_6
XFILLER_19_245 VGND VGND VPWR VPWR sky130_fd_sc_hd__fill_1
XFILLER_90_811 VGND VGND VPWR VPWR sky130_fd_sc_hd__fill_1
XFILLER_19_267 VPWR VGND VPWR VGND sky130_ef_sc_hd__decap_12
XFILLER_35_727 VGND VGND VPWR VPWR sky130_fd_sc_hd__fill_1
XFILLER_47_93 VPWR VGND VPWR VGND sky130_ef_sc_hd__decap_12
XFILLER_62_557 VPWR VGND VPWR VGND sky130_ef_sc_hd__decap_12
XFILLER_34_248 VGND VGND VPWR VPWR sky130_fd_sc_hd__fill_2
X_2890_ _0572_ _0577_ VGND VGND VPWR VPWR _0578_ sky130_fd_sc_hd__nor2_1
X_1910_ B_reg\[15\] B_reg\[13\] B_reg\[12\] VGND VGND VPWR VPWR _1175_ sky130_fd_sc_hd__and3_1
XFILLER_15_473 VPWR VGND VPWR VGND sky130_ef_sc_hd__decap_12
XFILLER_30_421 VPWR VGND VPWR VGND sky130_ef_sc_hd__decap_12
XFILLER_129_821 VPWR VGND VPWR VGND sky130_ef_sc_hd__decap_12
XTAP_TAPCELL_ROW_100_1931 VGND VPWR sky130_fd_sc_hd__tapvpwrvgnd_1
X_1841_ a_r1\[2\] _0911_ _1110_ _1111_ VGND VGND VPWR VPWR _0005_ sky130_fd_sc_hd__a22o_1
XANTENNA__2271__A A_reg\[1\] VGND VGND VPWR VPWR sky130_fd_sc_hd__diode_2
XFILLER_8_65 VPWR VGND VPWR VGND sky130_ef_sc_hd__decap_12
XTAP_TAPCELL_ROW_41_983 VGND VPWR sky130_fd_sc_hd__tapvpwrvgnd_1
XTAP_TAPCELL_ROW_41_994 VGND VPWR sky130_fd_sc_hd__tapvpwrvgnd_1
XFILLER_144_813 VPWR VGND VPWR VGND sky130_ef_sc_hd__decap_12
XFILLER_129_865 VPWR VGND VPWR VGND sky130_ef_sc_hd__decap_12
X_1772_ _1040_ _1042_ _1044_ VGND VGND VPWR VPWR _1045_ sky130_fd_sc_hd__a21o_1
XTAP_TAPCELL_ROW_133_2463 VGND VPWR sky130_fd_sc_hd__tapvpwrvgnd_1
XTAP_TAPCELL_ROW_133_2452 VGND VPWR sky130_fd_sc_hd__tapvpwrvgnd_1
XFILLER_131_529 VPWR VGND VPWR VGND sky130_ef_sc_hd__decap_12
XFILLER_124_581 VGND VGND VPWR VPWR sky130_fd_sc_hd__decap_6
X_2324_ _1566_ _1568_ _1563_ VGND VGND VPWR VPWR _1577_ sky130_fd_sc_hd__a21boi_1
XANTENNA__1615__A A_reg\[2\] VGND VGND VPWR VPWR sky130_fd_sc_hd__diode_2
XFILLER_100_905 VGND VGND VPWR VPWR sky130_fd_sc_hd__decap_4
XFILLER_57_329 VGND VGND VPWR VPWR sky130_fd_sc_hd__decap_6
X_2255_ _1510_ _1511_ VGND VGND VPWR VPWR _1512_ sky130_fd_sc_hd__nand2_1
X_2186_ A_reg\[9\] _1431_ _1440_ VGND VGND VPWR VPWR _1443_ sky130_fd_sc_hd__nand3_1
XFILLER_81_833 VGND VGND VPWR VPWR sky130_fd_sc_hd__decap_6
XFILLER_53_524 VGND VGND VPWR VPWR sky130_fd_sc_hd__decap_8
XTAP_TAPCELL_ROW_0_314 VGND VPWR sky130_fd_sc_hd__tapvpwrvgnd_1
XTAP_TAPCELL_ROW_0_325 VGND VPWR sky130_fd_sc_hd__tapvpwrvgnd_1
XTAP_TAPCELL_ROW_0_336 VGND VPWR sky130_fd_sc_hd__tapvpwrvgnd_1
XFILLER_38_587 VGND VGND VPWR VPWR sky130_fd_sc_hd__fill_1
XFILLER_80_321 VPWR VGND VPWR VGND sky130_ef_sc_hd__decap_12
XFILLER_25_237 VPWR VGND VPWR VGND sky130_ef_sc_hd__decap_12
XFILLER_26_749 VGND VGND VPWR VPWR sky130_fd_sc_hd__decap_6
XFILLER_81_877 VPWR VGND VPWR VGND sky130_ef_sc_hd__decap_12
XFILLER_21_421 VGND VGND VPWR VPWR sky130_fd_sc_hd__fill_1
XFILLER_33_270 VGND VGND VPWR VPWR sky130_fd_sc_hd__decap_8
XFILLER_33_281 VPWR VGND VPWR VGND sky130_ef_sc_hd__decap_12
XFILLER_34_793 VGND VGND VPWR VPWR sky130_fd_sc_hd__decap_4
XFILLER_139_629 VPWR VGND VPWR VGND sky130_ef_sc_hd__decap_12
XFILLER_138_139 VGND VGND VPWR VPWR sky130_fd_sc_hd__fill_1
XFILLER_153_109 VGND VGND VPWR VPWR sky130_fd_sc_hd__decap_3
XFILLER_147_673 VPWR VGND VPWR VGND sky130_ef_sc_hd__decap_12
XFILLER_5_609 VGND VGND VPWR VPWR sky130_fd_sc_hd__decap_6
XFILLER_134_301 VGND VGND VPWR VPWR sky130_fd_sc_hd__decap_6
XFILLER_150_805 VGND VGND VPWR VPWR sky130_fd_sc_hd__decap_6
XFILLER_134_345 VPWR VGND VPWR VGND sky130_ef_sc_hd__decap_12
XTAP_TAPCELL_ROW_56_1229 VGND VPWR sky130_fd_sc_hd__tapvpwrvgnd_1
XFILLER_150_849 VPWR VGND VPWR VGND sky130_ef_sc_hd__decap_12
XFILLER_134_389 VPWR VGND VPWR VGND sky130_ef_sc_hd__decap_12
XFILLER_108_77 VGND VGND VPWR VPWR sky130_fd_sc_hd__decap_6
XFILLER_88_410 VGND VGND VPWR VPWR sky130_fd_sc_hd__decap_8
XFILLER_68_15 VPWR VGND VPWR VGND sky130_ef_sc_hd__decap_12
XFILLER_103_721 VGND VGND VPWR VPWR sky130_fd_sc_hd__decap_6
XANTENNA__2689__B2 a_r3\[0\] VGND VGND VPWR VPWR sky130_fd_sc_hd__diode_2
XFILLER_88_421 VGND VGND VPWR VPWR sky130_fd_sc_hd__fill_1
XFILLER_68_59 VPWR VGND VPWR VGND sky130_ef_sc_hd__decap_12
XTAP_TAPCELL_ROW_8_458 VGND VPWR sky130_fd_sc_hd__tapvpwrvgnd_1
XFILLER_103_765 VPWR VGND VPWR VGND sky130_ef_sc_hd__decap_12
XFILLER_102_253 VPWR VGND VPWR VGND sky130_ef_sc_hd__decap_12
XFILLER_49_819 VPWR VGND VPWR VGND sky130_ef_sc_hd__decap_12
XFILLER_48_307 VGND VGND VPWR VPWR sky130_fd_sc_hd__fill_1
XFILLER_124_65 VPWR VGND VPWR VGND sky130_ef_sc_hd__decap_12
XFILLER_75_159 VGND VGND VPWR VPWR sky130_fd_sc_hd__decap_8
XFILLER_57_841 VPWR VGND VPWR VGND sky130_ef_sc_hd__decap_12
XFILLER_17_727 VGND VGND VPWR VPWR sky130_fd_sc_hd__fill_1
XFILLER_44_502 VPWR VGND VPWR VGND sky130_ef_sc_hd__decap_12
XFILLER_84_693 VGND VGND VPWR VPWR sky130_fd_sc_hd__decap_6
XFILLER_83_181 VPWR VGND VPWR VGND sky130_ef_sc_hd__decap_12
XFILLER_16_248 VGND VGND VPWR VPWR sky130_fd_sc_hd__decap_4
XFILLER_140_53 VPWR VGND VPWR VGND sky130_ef_sc_hd__decap_12
XTAP_TAPCELL_ROW_84_1672 VGND VPWR sky130_fd_sc_hd__tapvpwrvgnd_1
XTAP_TAPCELL_ROW_27_766 VGND VPWR sky130_fd_sc_hd__tapvpwrvgnd_1
XFILLER_140_97 VPWR VGND VPWR VGND sky130_ef_sc_hd__decap_12
XTAP_TAPCELL_ROW_84_1683 VGND VPWR sky130_fd_sc_hd__tapvpwrvgnd_1
XFILLER_12_421 VPWR VGND VPWR VGND sky130_ef_sc_hd__decap_12
XFILLER_33_51 VGND VGND VPWR VPWR sky130_fd_sc_hd__decap_4
XFILLER_149_51 VGND VGND VPWR VPWR sky130_fd_sc_hd__decap_4
XFILLER_12_465 VGND VGND VPWR VPWR sky130_fd_sc_hd__decap_8
XFILLER_144_109 VPWR VGND VPWR VGND sky130_ef_sc_hd__decap_12
XFILLER_126_813 VPWR VGND VPWR VGND sky130_ef_sc_hd__decap_12
XFILLER_137_161 VGND VGND VPWR VPWR sky130_fd_sc_hd__decap_6
XANTENNA__2731__D_N a_r3\[1\] VGND VGND VPWR VPWR sky130_fd_sc_hd__diode_2
XTAP_TAPCELL_ROW_115_2171 VGND VPWR sky130_fd_sc_hd__tapvpwrvgnd_1
XANTENNA__2129__A0 B_reg\[5\] VGND VGND VPWR VPWR sky130_fd_sc_hd__diode_2
XFILLER_4_620 VGND VGND VPWR VPWR sky130_fd_sc_hd__decap_6
XFILLER_152_153 VPWR VGND VPWR VGND sky130_ef_sc_hd__decap_12
XFILLER_113_529 VPWR VGND VPWR VGND sky130_ef_sc_hd__decap_12
XFILLER_106_570 VPWR VGND VPWR VGND sky130_ef_sc_hd__decap_12
XFILLER_98_218 VPWR VGND VPWR VGND sky130_ef_sc_hd__decap_12
XFILLER_152_197 VPWR VGND VPWR VGND sky130_ef_sc_hd__decap_12
XFILLER_67_605 VGND VGND VPWR VPWR sky130_fd_sc_hd__decap_8
XFILLER_121_573 VPWR VGND VPWR VGND sky130_ef_sc_hd__decap_12
XFILLER_58_70 VGND VGND VPWR VPWR sky130_fd_sc_hd__fill_1
XFILLER_0_881 VPWR VGND VPWR VGND sky130_ef_sc_hd__decap_12
XFILLER_39_329 VGND VGND VPWR VPWR sky130_fd_sc_hd__decap_6
X_2040_ _1292_ _1294_ _1299_ _1293_ VGND VGND VPWR VPWR _1302_ sky130_fd_sc_hd__o22ai_1
XFILLER_66_137 VGND VGND VPWR VPWR sky130_fd_sc_hd__decap_3
XANTENNA__2852__A1 B_reg\[2\] VGND VGND VPWR VPWR sky130_fd_sc_hd__diode_2
XFILLER_74_192 VGND VGND VPWR VPWR sky130_fd_sc_hd__decap_4
XFILLER_63_833 VGND VGND VPWR VPWR sky130_fd_sc_hd__decap_6
XFILLER_63_877 VPWR VGND VPWR VGND sky130_ef_sc_hd__decap_12
XFILLER_62_365 VGND VGND VPWR VPWR sky130_fd_sc_hd__decap_3
XFILLER_95_3 VPWR VGND VPWR VGND sky130_ef_sc_hd__decap_12
X_2942_ _0566_ _0570_ _0574_ VGND VGND VPWR VPWR _0630_ sky130_fd_sc_hd__o21ba_1
XFILLER_62_387 VPWR VGND VPWR VGND sky130_ef_sc_hd__decap_12
XFILLER_16_793 VPWR VGND VPWR VGND sky130_ef_sc_hd__decap_12
XFILLER_15_281 VPWR VGND VPWR VGND sky130_ef_sc_hd__decap_12
XFILLER_31_741 VPWR VGND VPWR VGND sky130_ef_sc_hd__decap_12
XANTENNA__2713__B b_r3\[3\] VGND VGND VPWR VPWR sky130_fd_sc_hd__diode_2
XFILLER_90_90 VGND VGND VPWR VPWR sky130_fd_sc_hd__decap_8
X_2873_ _0559_ _0560_ VGND VGND VPWR VPWR _0561_ sky130_fd_sc_hd__or2_1
XFILLER_30_251 VGND VGND VPWR VPWR sky130_fd_sc_hd__fill_1
XFILLER_31_785 VGND VGND VPWR VPWR sky130_fd_sc_hd__decap_8
X_1824_ _1087_ _1088_ VGND VGND VPWR VPWR _1097_ sky130_fd_sc_hd__nor2_1
XFILLER_129_673 VPWR VGND VPWR VGND sky130_ef_sc_hd__decap_12
XFILLER_116_301 VGND VGND VPWR VPWR sky130_fd_sc_hd__decap_6
X_1755_ _1021_ _1027_ _0889_ VGND VGND VPWR VPWR _1028_ sky130_fd_sc_hd__o21ai_1
XFILLER_144_643 VGND VGND VPWR VPWR sky130_fd_sc_hd__fill_1
XFILLER_132_805 VGND VGND VPWR VPWR sky130_fd_sc_hd__decap_6
XFILLER_116_345 VPWR VGND VPWR VGND sky130_ef_sc_hd__decap_12
XFILLER_116_389 VPWR VGND VPWR VGND sky130_ef_sc_hd__decap_12
X_1686_ A_reg\[6\] _0960_ VGND VGND VPWR VPWR _0962_ sky130_fd_sc_hd__nor2_1
XFILLER_132_849 VPWR VGND VPWR VGND sky130_ef_sc_hd__decap_12
XFILLER_131_337 VPWR VGND VPWR VGND sky130_ef_sc_hd__decap_12
XTAP_TAPCELL_ROW_5_417 VGND VPWR sky130_fd_sc_hd__tapvpwrvgnd_1
XTAP_TAPCELL_ROW_5_406 VGND VPWR sky130_fd_sc_hd__tapvpwrvgnd_1
XFILLER_140_893 VPWR VGND VPWR VGND sky130_ef_sc_hd__decap_12
XFILLER_100_713 VPWR VGND VPWR VGND sky130_ef_sc_hd__decap_12
XFILLER_58_638 VGND VGND VPWR VPWR sky130_fd_sc_hd__decap_6
X_2307_ _1555_ _1557_ _0899_ VGND VGND VPWR VPWR _1560_ sky130_fd_sc_hd__a21oi_1
XTAP_TAPCELL_ROW_51_1148 VGND VPWR sky130_fd_sc_hd__tapvpwrvgnd_1
X_3287_ clknet_3_5__leaf_clk _0070_ net36 VGND VGND VPWR VPWR A_reg\[13\] sky130_fd_sc_hd__dfrtp_4
XFILLER_38_29 VPWR VGND VPWR VGND sky130_ef_sc_hd__decap_12
XTAP_TAPCELL_ROW_146_2665 VGND VPWR sky130_fd_sc_hd__tapvpwrvgnd_1
XFILLER_100_757 VPWR VGND VPWR VGND sky130_ef_sc_hd__decap_12
XFILLER_57_137 VPWR VGND VPWR VGND sky130_ef_sc_hd__decap_12
X_2238_ _1481_ _1483_ _1494_ VGND VGND VPWR VPWR _1495_ sky130_fd_sc_hd__a21oi_1
XANTENNA__1632__X _0911_ VGND VGND VPWR VPWR sky130_fd_sc_hd__diode_2
XFILLER_26_513 VPWR VGND VPWR VGND sky130_ef_sc_hd__decap_12
XFILLER_81_641 VPWR VGND VPWR VGND sky130_ef_sc_hd__decap_12
XFILLER_66_693 VGND VGND VPWR VPWR sky130_fd_sc_hd__decap_6
XFILLER_65_181 VGND VGND VPWR VPWR sky130_fd_sc_hd__decap_8
XANTENNA__2176__A A_reg\[10\] VGND VGND VPWR VPWR sky130_fd_sc_hd__diode_2
X_2169_ _1413_ _1414_ VGND VGND VPWR VPWR _1426_ sky130_fd_sc_hd__nand2b_1
XANTENNA__2843__A1 A_reg\[9\] VGND VGND VPWR VPWR sky130_fd_sc_hd__diode_2
XFILLER_54_877 VGND VGND VPWR VPWR sky130_fd_sc_hd__decap_3
XFILLER_41_505 VPWR VGND VPWR VGND sky130_ef_sc_hd__decap_12
XFILLER_81_685 VPWR VGND VPWR VGND sky130_ef_sc_hd__decap_12
XTAP_TAPCELL_ROW_66_1391 VGND VPWR sky130_fd_sc_hd__tapvpwrvgnd_1
XTAP_TAPCELL_ROW_66_1380 VGND VPWR sky130_fd_sc_hd__tapvpwrvgnd_1
XTAP_TAPCELL_ROW_24_714 VGND VPWR sky130_fd_sc_hd__tapvpwrvgnd_1
XFILLER_70_27 VGND VGND VPWR VPWR sky130_fd_sc_hd__fill_1
XFILLER_126_109 VPWR VGND VPWR VGND sky130_ef_sc_hd__decap_12
XFILLER_119_161 VGND VGND VPWR VPWR sky130_fd_sc_hd__decap_6
XFILLER_108_813 VPWR VGND VPWR VGND sky130_ef_sc_hd__decap_12
XFILLER_150_613 VPWR VGND VPWR VGND sky130_ef_sc_hd__decap_12
XFILLER_135_665 VGND VGND VPWR VPWR sky130_fd_sc_hd__decap_6
XFILLER_134_153 VPWR VGND VPWR VGND sky130_ef_sc_hd__decap_12
XFILLER_79_69 VPWR VGND VPWR VGND sky130_ef_sc_hd__decap_12
XFILLER_150_657 VPWR VGND VPWR VGND sky130_ef_sc_hd__decap_12
XFILLER_134_197 VPWR VGND VPWR VGND sky130_ef_sc_hd__decap_12
XFILLER_89_741 VPWR VGND VPWR VGND sky130_ef_sc_hd__decap_12
XANTENNA__3286__RESET_B net36 VGND VGND VPWR VPWR sky130_fd_sc_hd__diode_2
XFILLER_88_251 VGND VGND VPWR VPWR sky130_fd_sc_hd__fill_1
XTAP_TAPCELL_ROW_110_2090 VGND VPWR sky130_fd_sc_hd__tapvpwrvgnd_1
XFILLER_95_57 VGND VGND VPWR VPWR sky130_fd_sc_hd__decap_4
XFILLER_89_785 VPWR VGND VPWR VGND sky130_ef_sc_hd__decap_12
XFILLER_76_413 VGND VGND VPWR VPWR sky130_fd_sc_hd__decap_6
XANTENNA__3215__RESET_B net36 VGND VGND VPWR VPWR sky130_fd_sc_hd__diode_2
XFILLER_76_457 VPWR VGND VPWR VGND sky130_ef_sc_hd__decap_12
XFILLER_91_405 VGND VGND VPWR VPWR sky130_fd_sc_hd__decap_4
XTAP_TAPCELL_ROW_86_1712 VGND VPWR sky130_fd_sc_hd__tapvpwrvgnd_1
XTAP_TAPCELL_ROW_86_1701 VGND VPWR sky130_fd_sc_hd__tapvpwrvgnd_1
XFILLER_57_671 VGND VGND VPWR VPWR sky130_fd_sc_hd__fill_1
XANTENNA_input15_A A_in[8] VGND VGND VPWR VPWR sky130_fd_sc_hd__diode_2
XFILLER_29_373 VGND VGND VPWR VPWR sky130_fd_sc_hd__fill_2
XFILLER_91_449 VPWR VGND VPWR VGND sky130_ef_sc_hd__decap_12
XFILLER_91_438 VGND VGND VPWR VPWR sky130_fd_sc_hd__decap_8
XANTENNA__2834__A1 A_reg\[0\] VGND VGND VPWR VPWR sky130_fd_sc_hd__diode_2
XFILLER_44_321 VPWR VGND VPWR VGND sky130_ef_sc_hd__decap_12
XFILLER_45_833 VGND VGND VPWR VPWR sky130_fd_sc_hd__decap_6
XFILLER_44_365 VGND VGND VPWR VPWR sky130_fd_sc_hd__fill_1
XFILLER_60_847 VPWR VGND VPWR VGND sky130_ef_sc_hd__decap_12
XFILLER_44_387 VPWR VGND VPWR VGND sky130_ef_sc_hd__decap_12
XFILLER_60_869 VGND VGND VPWR VPWR sky130_fd_sc_hd__decap_8
XFILLER_13_741 VPWR VGND VPWR VGND sky130_ef_sc_hd__decap_12
XFILLER_44_83 VGND VGND VPWR VPWR sky130_fd_sc_hd__fill_1
XTAP_TAPCELL_ROW_117_2200 VGND VPWR sky130_fd_sc_hd__tapvpwrvgnd_1
XFILLER_12_251 VGND VGND VPWR VPWR sky130_fd_sc_hd__fill_1
XFILLER_13_785 VPWR VGND VPWR VGND sky130_ef_sc_hd__decap_12
XTAP_TAPCELL_ROW_117_2211 VGND VPWR sky130_fd_sc_hd__tapvpwrvgnd_1
XFILLER_74_8 VPWR VGND VPWR VGND sky130_ef_sc_hd__decap_12
XFILLER_8_233 VPWR VGND VPWR VGND sky130_ef_sc_hd__decap_12
XFILLER_145_429 VPWR VGND VPWR VGND sky130_ef_sc_hd__decap_12
XFILLER_60_82 VGND VGND VPWR VPWR sky130_fd_sc_hd__fill_2
XFILLER_8_277 VPWR VGND VPWR VGND sky130_ef_sc_hd__decap_12
XTAP_TAPCELL_ROW_130_2411 VGND VPWR sky130_fd_sc_hd__tapvpwrvgnd_1
XFILLER_126_643 VGND VGND VPWR VPWR sky130_fd_sc_hd__fill_1
XTAP_TAPCELL_ROW_97_1885 VGND VPWR sky130_fd_sc_hd__tapvpwrvgnd_1
XTAP_TAPCELL_ROW_10_485 VGND VPWR sky130_fd_sc_hd__tapvpwrvgnd_1
XFILLER_153_473 VGND VGND VPWR VPWR sky130_fd_sc_hd__decap_3
XFILLER_114_805 VGND VGND VPWR VPWR sky130_fd_sc_hd__decap_6
XFILLER_99_505 VGND VGND VPWR VPWR sky130_fd_sc_hd__decap_4
XTAP_TAPCELL_ROW_10_496 VGND VPWR sky130_fd_sc_hd__tapvpwrvgnd_1
XFILLER_5_55 VGND VGND VPWR VPWR sky130_fd_sc_hd__fill_1
XFILLER_114_849 VPWR VGND VPWR VGND sky130_ef_sc_hd__decap_12
XFILLER_113_337 VPWR VGND VPWR VGND sky130_ef_sc_hd__decap_12
XANTENNA__3270__CLK clknet_3_5__leaf_clk VGND VGND VPWR VPWR sky130_fd_sc_hd__diode_2
XFILLER_79_240 VGND VGND VPWR VPWR sky130_fd_sc_hd__decap_3
X_3210_ X_crt\[14\] _0912_ VGND VGND VPWR VPWR _0103_ sky130_fd_sc_hd__and2_1
XFILLER_140_189 VGND VGND VPWR VPWR sky130_fd_sc_hd__decap_6
XFILLER_122_893 VPWR VGND VPWR VGND sky130_ef_sc_hd__decap_12
X_3141_ _0803_ _0826_ VGND VGND VPWR VPWR _0829_ sky130_fd_sc_hd__nor2_1
XPHY_EDGE_ROW_105_Left_259 VGND VGND VPWR VPWR sky130_fd_sc_hd__decap_3
XFILLER_95_777 VGND VGND VPWR VPWR sky130_fd_sc_hd__decap_6
XFILLER_94_221 VPWR VGND VPWR VGND sky130_ef_sc_hd__decap_12
XFILLER_67_446 VGND VGND VPWR VPWR sky130_fd_sc_hd__fill_2
XFILLER_10_3 VPWR VGND VPWR VGND sky130_ef_sc_hd__decap_12
XFILLER_39_137 VPWR VGND VPWR VGND sky130_ef_sc_hd__decap_12
XTAP_TAPCELL_ROW_128_2384 VGND VPWR sky130_fd_sc_hd__tapvpwrvgnd_1
XTAP_TAPCELL_ROW_128_2373 VGND VPWR sky130_fd_sc_hd__tapvpwrvgnd_1
XFILLER_94_265 VPWR VGND VPWR VGND sky130_ef_sc_hd__decap_12
XFILLER_36_811 VGND VGND VPWR VPWR sky130_fd_sc_hd__fill_1
X_3072_ _0751_ _0759_ _0742_ VGND VGND VPWR VPWR _0760_ sky130_fd_sc_hd__a21o_1
X_2023_ _1283_ _1284_ VGND VGND VPWR VPWR _1285_ sky130_fd_sc_hd__nand2_1
XFILLER_63_641 VGND VGND VPWR VPWR sky130_fd_sc_hd__decap_6
XFILLER_54_129 VGND VGND VPWR VPWR sky130_fd_sc_hd__fill_2
XFILLER_48_682 VGND VGND VPWR VPWR sky130_fd_sc_hd__decap_6
XFILLER_35_332 VGND VGND VPWR VPWR sky130_fd_sc_hd__decap_4
XFILLER_47_181 VPWR VGND VPWR VGND sky130_ef_sc_hd__decap_12
XFILLER_63_652 VPWR VGND VPWR VGND sky130_ef_sc_hd__decap_12
XFILLER_23_505 VPWR VGND VPWR VGND sky130_ef_sc_hd__decap_12
XTAP_TAPCELL_ROW_141_2595 VGND VPWR sky130_fd_sc_hd__tapvpwrvgnd_1
XTAP_TAPCELL_ROW_141_2584 VGND VPWR sky130_fd_sc_hd__tapvpwrvgnd_1
XFILLER_63_685 VPWR VGND VPWR VGND sky130_ef_sc_hd__decap_12
XFILLER_50_357 VGND VGND VPWR VPWR sky130_fd_sc_hd__decap_6
XPHY_EDGE_ROW_114_Left_268 VGND VGND VPWR VPWR sky130_fd_sc_hd__decap_3
X_2925_ _0607_ _0611_ VGND VGND VPWR VPWR _0613_ sky130_fd_sc_hd__xor2_2
XFILLER_148_245 VGND VGND VPWR VPWR sky130_fd_sc_hd__decap_6
X_2856_ net29 B_reg\[6\] _0383_ VGND VGND VPWR VPWR _0079_ sky130_fd_sc_hd__mux2_1
XFILLER_148_289 VPWR VGND VPWR VGND sky130_ef_sc_hd__decap_12
XFILLER_108_109 VPWR VGND VPWR VGND sky130_ef_sc_hd__decap_12
X_1807_ A_reg\[3\] _1079_ VGND VGND VPWR VPWR _1080_ sky130_fd_sc_hd__or2_1
X_2787_ _0512_ _0523_ VGND VGND VPWR VPWR _0527_ sky130_fd_sc_hd__xor2_1
XFILLER_132_613 VPWR VGND VPWR VGND sky130_ef_sc_hd__decap_12
XFILLER_117_665 VGND VGND VPWR VPWR sky130_fd_sc_hd__decap_6
XFILLER_116_153 VPWR VGND VPWR VGND sky130_ef_sc_hd__decap_12
X_1738_ A_reg\[13\] _0923_ VGND VGND VPWR VPWR _1011_ sky130_fd_sc_hd__nor2_1
XFILLER_116_197 VPWR VGND VPWR VGND sky130_ef_sc_hd__decap_12
X_1669_ _0943_ _0944_ _0890_ VGND VGND VPWR VPWR _0945_ sky130_fd_sc_hd__a21o_1
XTAP_TAPCELL_ROW_148_2705 VGND VPWR sky130_fd_sc_hd__tapvpwrvgnd_1
XFILLER_132_657 VPWR VGND VPWR VGND sky130_ef_sc_hd__decap_12
XPHY_EDGE_ROW_123_Left_277 VGND VGND VPWR VPWR sky130_fd_sc_hd__decap_3
XFILLER_49_39 VPWR VGND VPWR VGND sky130_ef_sc_hd__decap_12
XFILLER_131_167 VGND VGND VPWR VPWR sky130_fd_sc_hd__fill_1
XFILLER_86_722 VPWR VGND VPWR VGND sky130_ef_sc_hd__decap_12
XANTENNA_input7_A A_in[15] VGND VGND VPWR VPWR sky130_fd_sc_hd__diode_2
XFILLER_58_446 VPWR VGND VPWR VGND sky130_ef_sc_hd__decap_12
XFILLER_73_405 VPWR VGND VPWR VGND sky130_ef_sc_hd__decap_12
XFILLER_39_671 VGND VGND VPWR VPWR sky130_fd_sc_hd__fill_1
XPHY_EDGE_ROW_134_Right_134 VGND VGND VPWR VPWR sky130_fd_sc_hd__decap_3
XFILLER_73_449 VPWR VGND VPWR VGND sky130_ef_sc_hd__decap_12
XTAP_TAPCELL_ROW_68_1420 VGND VPWR sky130_fd_sc_hd__tapvpwrvgnd_1
XFILLER_54_630 VPWR VGND VPWR VGND sky130_ef_sc_hd__decap_12
XFILLER_27_833 VGND VGND VPWR VPWR sky130_fd_sc_hd__decap_6
XFILLER_26_332 VPWR VGND VPWR VGND sky130_ef_sc_hd__decap_12
XFILLER_26_365 VPWR VGND VPWR VGND sky130_ef_sc_hd__decap_12
XFILLER_27_877 VPWR VGND VPWR VGND sky130_ef_sc_hd__decap_12
XFILLER_121_55 VGND VGND VPWR VPWR sky130_fd_sc_hd__fill_1
XFILLER_81_460 VGND VGND VPWR VPWR sky130_fd_sc_hd__fill_1
XFILLER_81_15 VPWR VGND VPWR VGND sky130_ef_sc_hd__decap_12
XPHY_EDGE_ROW_132_Left_286 VGND VGND VPWR VPWR sky130_fd_sc_hd__decap_3
XTAP_TAPCELL_ROW_81_1631 VGND VPWR sky130_fd_sc_hd__tapvpwrvgnd_1
XTAP_TAPCELL_ROW_81_1620 VGND VPWR sky130_fd_sc_hd__tapvpwrvgnd_1
XFILLER_42_869 VPWR VGND VPWR VGND sky130_ef_sc_hd__decap_12
XFILLER_139_223 VGND VGND VPWR VPWR sky130_fd_sc_hd__fill_1
XFILLER_14_53 VPWR VGND VPWR VGND sky130_ef_sc_hd__decap_12
XFILLER_127_429 VPWR VGND VPWR VGND sky130_ef_sc_hd__decap_12
XFILLER_10_755 VGND VGND VPWR VPWR sky130_fd_sc_hd__fill_1
XFILLER_14_97 VPWR VGND VPWR VGND sky130_ef_sc_hd__decap_12
XFILLER_108_643 VGND VGND VPWR VPWR sky130_fd_sc_hd__fill_1
XANTENNA__3293__CLK clknet_3_2__leaf_clk VGND VGND VPWR VPWR sky130_fd_sc_hd__diode_2
XFILLER_6_737 VPWR VGND VPWR VGND sky130_ef_sc_hd__decap_12
XFILLER_5_225 VGND VGND VPWR VPWR sky130_fd_sc_hd__decap_8
XFILLER_30_41 VPWR VGND VPWR VGND sky130_ef_sc_hd__decap_12
XFILLER_146_41 VPWR VGND VPWR VGND sky130_ef_sc_hd__decap_12
XFILLER_135_473 VPWR VGND VPWR VGND sky130_ef_sc_hd__decap_12
XTAP_TAPCELL_ROW_112_2130 VGND VPWR sky130_fd_sc_hd__tapvpwrvgnd_1
XTAP_TAPCELL_ROW_79_1593 VGND VPWR sky130_fd_sc_hd__tapvpwrvgnd_1
XFILLER_150_421 VPWR VGND VPWR VGND sky130_ef_sc_hd__decap_12
XPHY_EDGE_ROW_141_Left_295 VGND VGND VPWR VPWR sky130_fd_sc_hd__decap_3
XFILLER_30_85 VPWR VGND VPWR VGND sky130_ef_sc_hd__decap_12
XFILLER_146_85 VPWR VGND VPWR VGND sky130_ef_sc_hd__decap_12
XFILLER_122_189 VGND VGND VPWR VPWR sky130_fd_sc_hd__decap_6
XFILLER_110_307 VGND VGND VPWR VPWR sky130_fd_sc_hd__fill_1
XFILLER_104_893 VPWR VGND VPWR VGND sky130_ef_sc_hd__decap_12
XFILLER_103_370 VGND VGND VPWR VPWR sky130_fd_sc_hd__fill_2
XFILLER_77_733 VGND VGND VPWR VPWR sky130_fd_sc_hd__fill_1
XFILLER_77_722 VGND VGND VPWR VPWR sky130_fd_sc_hd__decap_6
XFILLER_76_221 VPWR VGND VPWR VGND sky130_ef_sc_hd__decap_12
XFILLER_49_446 VGND VGND VPWR VPWR sky130_fd_sc_hd__fill_2
XFILLER_1_497 VGND VGND VPWR VPWR sky130_fd_sc_hd__decap_6
XFILLER_92_725 VPWR VGND VPWR VGND sky130_ef_sc_hd__decap_12
XFILLER_76_265 VGND VGND VPWR VPWR sky130_fd_sc_hd__decap_6
XFILLER_18_811 VGND VGND VPWR VPWR sky130_fd_sc_hd__fill_1
XPHY_EDGE_ROW_101_Right_101 VGND VGND VPWR VPWR sky130_fd_sc_hd__decap_3
XFILLER_92_769 VPWR VGND VPWR VGND sky130_ef_sc_hd__decap_12
XFILLER_91_213 VGND VGND VPWR VPWR sky130_fd_sc_hd__fill_1
XFILLER_80_909 VGND VGND VPWR VPWR sky130_fd_sc_hd__fill_1
XFILLER_64_438 VGND VGND VPWR VPWR sky130_fd_sc_hd__fill_2
XFILLER_29_181 VPWR VGND VPWR VGND sky130_ef_sc_hd__decap_12
XFILLER_91_279 VGND VGND VPWR VPWR sky130_fd_sc_hd__fill_1
XTAP_TAPCELL_ROW_123_2292 VGND VPWR sky130_fd_sc_hd__tapvpwrvgnd_1
XFILLER_45_685 VGND VGND VPWR VPWR sky130_fd_sc_hd__decap_8
XFILLER_32_357 VGND VGND VPWR VPWR sky130_fd_sc_hd__decap_4
XFILLER_60_699 VGND VGND VPWR VPWR sky130_fd_sc_hd__fill_1
XTAP_TAPCELL_ROW_15_566 VGND VPWR sky130_fd_sc_hd__tapvpwrvgnd_1
XTAP_TAPCELL_ROW_15_577 VGND VPWR sky130_fd_sc_hd__tapvpwrvgnd_1
X_2710_ _0411_ _0449_ _0448_ VGND VGND VPWR VPWR _0450_ sky130_fd_sc_hd__a21oi_1
XTAP_TAPCELL_ROW_99_1914 VGND VPWR sky130_fd_sc_hd__tapvpwrvgnd_1
XFILLER_71_81 VPWR VGND VPWR VGND sky130_ef_sc_hd__decap_12
XFILLER_9_553 VGND VGND VPWR VPWR sky130_fd_sc_hd__decap_6
XFILLER_146_749 VGND VGND VPWR VPWR sky130_fd_sc_hd__decap_6
XFILLER_145_237 VPWR VGND VPWR VGND sky130_ef_sc_hd__decap_12
XFILLER_9_597 VPWR VGND VPWR VGND sky130_ef_sc_hd__decap_12
X_2641_ CU_state_dbg\[2\] _0884_ CU_state_dbg\[1\] VGND VGND VPWR VPWR _0383_ sky130_fd_sc_hd__or3_4
X_2572_ _0316_ _0312_ VGND VGND VPWR VPWR _0317_ sky130_fd_sc_hd__and2b_1
XFILLER_58_3 VPWR VGND VPWR VGND sky130_ef_sc_hd__decap_12
XFILLER_153_281 VPWR VGND VPWR VGND sky130_ef_sc_hd__decap_12
XFILLER_114_613 VPWR VGND VPWR VGND sky130_ef_sc_hd__decap_12
XFILLER_99_335 VGND VGND VPWR VPWR sky130_fd_sc_hd__fill_1
XFILLER_114_657 VPWR VGND VPWR VGND sky130_ef_sc_hd__decap_12
XFILLER_99_379 VPWR VGND VPWR VGND sky130_ef_sc_hd__decap_12
XFILLER_113_167 VGND VGND VPWR VPWR sky130_fd_sc_hd__fill_1
XFILLER_101_329 VGND VGND VPWR VPWR sky130_fd_sc_hd__decap_6
XANTENNA__1623__A B_reg\[7\] VGND VGND VPWR VPWR sky130_fd_sc_hd__diode_2
XFILLER_68_744 VPWR VGND VPWR VGND sky130_ef_sc_hd__decap_12
XTAP_TAPCELL_ROW_143_2624 VGND VPWR sky130_fd_sc_hd__tapvpwrvgnd_1
XTAP_TAPCELL_ROW_143_2613 VGND VPWR sky130_fd_sc_hd__tapvpwrvgnd_1
XFILLER_95_574 VPWR VGND VPWR VGND sky130_ef_sc_hd__decap_12
XFILLER_55_405 VPWR VGND VPWR VGND sky130_ef_sc_hd__decap_12
X_3124_ _0794_ _0799_ VGND VGND VPWR VPWR _0812_ sky130_fd_sc_hd__or2_1
X_3055_ _0604_ _0702_ VGND VGND VPWR VPWR _0743_ sky130_fd_sc_hd__xnor2_2
XFILLER_55_449 VPWR VGND VPWR VGND sky130_ef_sc_hd__decap_12
XFILLER_82_246 VGND VGND VPWR VPWR sky130_fd_sc_hd__decap_6
XFILLER_71_909 VGND VGND VPWR VPWR sky130_fd_sc_hd__fill_1
X_2006_ B_reg\[11\] _1264_ _1266_ VGND VGND VPWR VPWR _1268_ sky130_fd_sc_hd__nand3_1
XFILLER_24_825 VPWR VGND VPWR VGND sky130_ef_sc_hd__decap_12
XFILLER_63_493 VGND VGND VPWR VPWR sky130_fd_sc_hd__fill_1
XFILLER_24_869 VPWR VGND VPWR VGND sky130_ef_sc_hd__decap_12
XFILLER_50_165 VPWR VGND VPWR VGND sky130_ef_sc_hd__decap_12
XTAP_TAPCELL_ROW_46_1069 VGND VPWR sky130_fd_sc_hd__tapvpwrvgnd_1
XTAP_TAPCELL_ROW_34_875 VGND VPWR sky130_fd_sc_hd__tapvpwrvgnd_1
X_2908_ _0583_ _0594_ VGND VGND VPWR VPWR _0596_ sky130_fd_sc_hd__nand2_1
XFILLER_137_727 VGND VGND VPWR VPWR sky130_fd_sc_hd__fill_1
X_2839_ net12 A_reg\[5\] _0383_ VGND VGND VPWR VPWR _0062_ sky130_fd_sc_hd__mux2_1
XFILLER_132_421 VPWR VGND VPWR VGND sky130_ef_sc_hd__decap_12
XFILLER_117_473 VPWR VGND VPWR VGND sky130_ef_sc_hd__decap_12
XFILLER_3_729 VPWR VGND VPWR VGND sky130_ef_sc_hd__decap_12
XFILLER_104_189 VGND VGND VPWR VPWR sky130_fd_sc_hd__decap_6
XFILLER_59_711 VPWR VGND VPWR VGND sky130_ef_sc_hd__decap_12
XFILLER_116_77 VGND VGND VPWR VPWR sky130_fd_sc_hd__decap_6
XFILLER_101_841 VPWR VGND VPWR VGND sky130_ef_sc_hd__decap_12
XFILLER_58_221 VPWR VGND VPWR VGND sky130_ef_sc_hd__decap_12
XFILLER_132_65 VPWR VGND VPWR VGND sky130_ef_sc_hd__decap_12
XFILLER_27_641 VPWR VGND VPWR VGND sky130_ef_sc_hd__decap_12
XFILLER_73_279 VGND VGND VPWR VPWR sky130_fd_sc_hd__fill_1
XFILLER_27_685 VPWR VGND VPWR VGND sky130_ef_sc_hd__decap_12
XFILLER_54_493 VGND VGND VPWR VPWR sky130_fd_sc_hd__decap_4
XFILLER_26_195 VGND VGND VPWR VPWR sky130_fd_sc_hd__fill_1
XTAP_TAPCELL_ROW_12_525 VGND VPWR sky130_fd_sc_hd__tapvpwrvgnd_1
XFILLER_6_501 VPWR VGND VPWR VGND sky130_ef_sc_hd__decap_12
XFILLER_128_749 VGND VGND VPWR VPWR sky130_fd_sc_hd__decap_6
XFILLER_127_237 VPWR VGND VPWR VGND sky130_ef_sc_hd__decap_12
XFILLER_6_545 VGND VGND VPWR VPWR sky130_fd_sc_hd__decap_4
XFILLER_41_51 VGND VGND VPWR VPWR sky130_fd_sc_hd__decap_4
XTAP_TAPCELL_ROW_94_1833 VGND VPWR sky130_fd_sc_hd__tapvpwrvgnd_1
XFILLER_136_793 VPWR VGND VPWR VGND sky130_ef_sc_hd__decap_12
XFILLER_135_281 VPWR VGND VPWR VGND sky130_ef_sc_hd__decap_12
XANTENNA__3230__RESET_B net36 VGND VGND VPWR VPWR sky130_fd_sc_hd__diode_2
XFILLER_6_589 VGND VGND VPWR VPWR sky130_fd_sc_hd__decap_8
XFILLER_151_741 VPWR VGND VPWR VGND sky130_ef_sc_hd__decap_12
XFILLER_151_785 VPWR VGND VPWR VGND sky130_ef_sc_hd__decap_12
XFILLER_150_251 VGND VGND VPWR VPWR sky130_fd_sc_hd__fill_1
XFILLER_97_839 VGND VGND VPWR VPWR sky130_fd_sc_hd__fill_1
XFILLER_1_261 VPWR VGND VPWR VGND sky130_ef_sc_hd__decap_12
XFILLER_77_541 VPWR VGND VPWR VGND sky130_ef_sc_hd__decap_12
XFILLER_37_405 VGND VGND VPWR VPWR sky130_fd_sc_hd__decap_8
XTAP_TAPCELL_ROW_125_2332 VGND VPWR sky130_fd_sc_hd__tapvpwrvgnd_1
XFILLER_77_585 VPWR VGND VPWR VGND sky130_ef_sc_hd__decap_12
XFILLER_65_725 VGND VGND VPWR VPWR sky130_fd_sc_hd__decap_3
XFILLER_64_213 VPWR VGND VPWR VGND sky130_ef_sc_hd__decap_12
XFILLER_37_449 VPWR VGND VPWR VGND sky130_ef_sc_hd__decap_12
XFILLER_53_909 VGND VGND VPWR VPWR sky130_fd_sc_hd__fill_1
XFILLER_52_419 VGND VGND VPWR VPWR sky130_fd_sc_hd__fill_1
XANTENNA__2274__A A_reg\[1\] VGND VGND VPWR VPWR sky130_fd_sc_hd__diode_2
XFILLER_32_121 VPWR VGND VPWR VGND sky130_ef_sc_hd__decap_12
XTAP_TAPCELL_ROW_103_1973 VGND VPWR sky130_fd_sc_hd__tapvpwrvgnd_1
XFILLER_32_165 VPWR VGND VPWR VGND sky130_ef_sc_hd__decap_12
XTAP_TAPCELL_ROW_103_1984 VGND VPWR sky130_fd_sc_hd__tapvpwrvgnd_1
XFILLER_21_839 VGND VGND VPWR VPWR sky130_fd_sc_hd__fill_1
XTAP_TAPCELL_ROW_31_823 VGND VPWR sky130_fd_sc_hd__tapvpwrvgnd_1
XTAP_TAPCELL_ROW_31_834 VGND VPWR sky130_fd_sc_hd__tapvpwrvgnd_1
XFILLER_146_513 VPWR VGND VPWR VGND sky130_ef_sc_hd__decap_12
XFILLER_119_727 VGND VGND VPWR VPWR sky130_fd_sc_hd__fill_1
XFILLER_9_361 VPWR VGND VPWR VGND sky130_ef_sc_hd__decap_12
XANTENNA__3318__RESET_B net36 VGND VGND VPWR VPWR sky130_fd_sc_hd__diode_2
XFILLER_146_557 VPWR VGND VPWR VGND sky130_ef_sc_hd__decap_12
X_2624_ a_r2\[0\] b_r2\[0\] _0187_ VGND VGND VPWR VPWR _0369_ sky130_fd_sc_hd__or3_1
XFILLER_114_421 VPWR VGND VPWR VGND sky130_ef_sc_hd__decap_12
X_2555_ _0294_ _0297_ _0235_ VGND VGND VPWR VPWR _0302_ sky130_fd_sc_hd__o21ai_1
XANTENNA__1640__B1_N A_reg\[15\] VGND VGND VPWR VPWR sky130_fd_sc_hd__diode_2
XFILLER_141_273 VGND VGND VPWR VPWR sky130_fd_sc_hd__decap_6
XFILLER_87_316 VPWR VGND VPWR VGND sky130_ef_sc_hd__decap_12
X_2486_ OpSel_reg\[0\] b_r1\[2\] _0232_ _0233_ VGND VGND VPWR VPWR _0234_ sky130_fd_sc_hd__nand4_2
XFILLER_101_137 VPWR VGND VPWR VGND sky130_ef_sc_hd__decap_12
XFILLER_87_349 VPWR VGND VPWR VGND sky130_ef_sc_hd__decap_12
XFILLER_96_861 VGND VGND VPWR VPWR sky130_fd_sc_hd__decap_6
XFILLER_28_405 VPWR VGND VPWR VGND sky130_ef_sc_hd__decap_12
XFILLER_110_693 VGND VGND VPWR VPWR sky130_fd_sc_hd__decap_6
XFILLER_95_393 VPWR VGND VPWR VGND sky130_ef_sc_hd__decap_12
XFILLER_56_725 VPWR VGND VPWR VGND sky130_ef_sc_hd__decap_12
X_3107_ _0786_ _0794_ VGND VGND VPWR VPWR _0795_ sky130_fd_sc_hd__or2_1
XFILLER_28_427 VGND VGND VPWR VPWR sky130_fd_sc_hd__fill_1
XFILLER_46_29 VPWR VGND VPWR VGND sky130_ef_sc_hd__decap_12
XFILLER_55_257 VGND VGND VPWR VPWR sky130_fd_sc_hd__fill_2
XTAP_TAPCELL_ROW_39_956 VGND VPWR sky130_fd_sc_hd__tapvpwrvgnd_1
X_3038_ _0558_ _0715_ VGND VGND VPWR VPWR _0726_ sky130_fd_sc_hd__xor2_1
XTAP_TAPCELL_ROW_61_1309 VGND VPWR sky130_fd_sc_hd__tapvpwrvgnd_1
XFILLER_24_699 VGND VGND VPWR VPWR sky130_fd_sc_hd__fill_1
XFILLER_149_373 VPWR VGND VPWR VGND sky130_ef_sc_hd__decap_12
XFILLER_11_349 VPWR VGND VPWR VGND sky130_ef_sc_hd__decap_12
XFILLER_20_861 VGND VGND VPWR VPWR sky130_fd_sc_hd__decap_6
XFILLER_109_237 VPWR VGND VPWR VGND sky130_ef_sc_hd__decap_12
XFILLER_118_793 VPWR VGND VPWR VGND sky130_ef_sc_hd__decap_12
XTAP_TAPCELL_ROW_76_1552 VGND VPWR sky130_fd_sc_hd__tapvpwrvgnd_1
XTAP_TAPCELL_ROW_76_1541 VGND VPWR sky130_fd_sc_hd__tapvpwrvgnd_1
XFILLER_133_741 VPWR VGND VPWR VGND sky130_ef_sc_hd__decap_12
XFILLER_117_281 VPWR VGND VPWR VGND sky130_ef_sc_hd__decap_12
XFILLER_3_559 VGND VGND VPWR VPWR sky130_fd_sc_hd__fill_1
XFILLER_133_785 VPWR VGND VPWR VGND sky130_ef_sc_hd__decap_12
XFILLER_132_251 VGND VGND VPWR VPWR sky130_fd_sc_hd__fill_1
XFILLER_120_413 VGND VGND VPWR VPWR sky130_fd_sc_hd__decap_6
XFILLER_79_839 VGND VGND VPWR VPWR sky130_fd_sc_hd__fill_1
XFILLER_59_541 VPWR VGND VPWR VGND sky130_ef_sc_hd__decap_12
XFILLER_120_457 VPWR VGND VPWR VGND sky130_ef_sc_hd__decap_12
XFILLER_19_405 VPWR VGND VPWR VGND sky130_ef_sc_hd__decap_12
XFILLER_101_671 VGND VGND VPWR VPWR sky130_fd_sc_hd__fill_1
XFILLER_74_533 VPWR VGND VPWR VGND sky130_ef_sc_hd__decap_12
XTAP_TAPCELL_ROW_107_2051 VGND VPWR sky130_fd_sc_hd__tapvpwrvgnd_1
XTAP_TAPCELL_ROW_107_2040 VGND VPWR sky130_fd_sc_hd__tapvpwrvgnd_1
XFILLER_19_449 VPWR VGND VPWR VGND sky130_ef_sc_hd__decap_12
XFILLER_61_216 VGND VGND VPWR VPWR sky130_fd_sc_hd__decap_8
XTAP_TAPCELL_ROW_17_606 VGND VPWR sky130_fd_sc_hd__tapvpwrvgnd_1
XFILLER_27_460 VPWR VGND VPWR VGND sky130_ef_sc_hd__decap_12
XFILLER_34_419 VGND VGND VPWR VPWR sky130_fd_sc_hd__fill_1
XFILLER_61_249 VPWR VGND VPWR VGND sky130_ef_sc_hd__decap_12
XFILLER_14_121 VPWR VGND VPWR VGND sky130_ef_sc_hd__decap_12
XTAP_TAPCELL_ROW_120_2251 VGND VPWR sky130_fd_sc_hd__tapvpwrvgnd_1
XFILLER_14_165 VPWR VGND VPWR VGND sky130_ef_sc_hd__decap_12
XFILLER_30_625 VPWR VGND VPWR VGND sky130_ef_sc_hd__decap_12
XANTENNA__3199__B1 _0912_ VGND VGND VPWR VPWR sky130_fd_sc_hd__diode_2
XFILLER_128_513 VPWR VGND VPWR VGND sky130_ef_sc_hd__decap_12
XFILLER_30_669 VPWR VGND VPWR VGND sky130_ef_sc_hd__decap_12
Xinput26 B_in[3] VGND VGND VPWR VPWR net26 sky130_fd_sc_hd__clkbuf_1
XFILLER_7_821 VPWR VGND VPWR VGND sky130_ef_sc_hd__decap_12
Xinput15 A_in[8] VGND VGND VPWR VPWR net15 sky130_fd_sc_hd__clkbuf_1
XFILLER_143_505 VPWR VGND VPWR VGND sky130_ef_sc_hd__decap_12
XFILLER_128_557 VPWR VGND VPWR VGND sky130_ef_sc_hd__decap_12
XFILLER_7_865 VPWR VGND VPWR VGND sky130_ef_sc_hd__decap_12
XFILLER_69_316 VPWR VGND VPWR VGND sky130_ef_sc_hd__decap_12
X_2340_ _1583_ _1584_ _1587_ _1589_ VGND VGND VPWR VPWR _1593_ sky130_fd_sc_hd__a22oi_2
XFILLER_123_273 VGND VGND VPWR VPWR sky130_fd_sc_hd__decap_6
XFILLER_85_809 VPWR VGND VPWR VGND sky130_ef_sc_hd__decap_12
XFILLER_69_349 VPWR VGND VPWR VGND sky130_ef_sc_hd__decap_12
X_2271_ A_reg\[1\] _1527_ VGND VGND VPWR VPWR _1528_ sky130_fd_sc_hd__nand2_1
XFILLER_2_592 VPWR VGND VPWR VGND sky130_ef_sc_hd__decap_12
XFILLER_111_479 VGND VGND VPWR VPWR sky130_fd_sc_hd__decap_6
XFILLER_78_861 VGND VGND VPWR VPWR sky130_fd_sc_hd__decap_6
XFILLER_77_393 VPWR VGND VPWR VGND sky130_ef_sc_hd__decap_12
XFILLER_65_500 VGND VGND VPWR VPWR sky130_fd_sc_hd__decap_4
XFILLER_38_725 VPWR VGND VPWR VGND sky130_ef_sc_hd__decap_12
XFILLER_93_853 VPWR VGND VPWR VGND sky130_ef_sc_hd__decap_12
XFILLER_26_909 VGND VGND VPWR VPWR sky130_fd_sc_hd__fill_1
XANTENNA__1685__B1 A_reg\[6\] VGND VGND VPWR VPWR sky130_fd_sc_hd__diode_2
XFILLER_38_769 VPWR VGND VPWR VGND sky130_ef_sc_hd__decap_12
XFILLER_93_897 VPWR VGND VPWR VGND sky130_ef_sc_hd__decap_12
XTAP_TAPCELL_ROW_36_904 VGND VPWR sky130_fd_sc_hd__tapvpwrvgnd_1
XTAP_TAPCELL_ROW_36_915 VGND VPWR sky130_fd_sc_hd__tapvpwrvgnd_1
XFILLER_33_441 VGND VGND VPWR VPWR sky130_fd_sc_hd__decap_6
XFILLER_61_783 VGND VGND VPWR VPWR sky130_fd_sc_hd__fill_1
XFILLER_33_485 VGND VGND VPWR VPWR sky130_fd_sc_hd__decap_8
XTAP_TAPCELL_ROW_43_1017 VGND VPWR sky130_fd_sc_hd__tapvpwrvgnd_1
XTAP_TAPCELL_ROW_138_2545 VGND VPWR sky130_fd_sc_hd__tapvpwrvgnd_1
XTAP_TAPCELL_ROW_138_2534 VGND VPWR sky130_fd_sc_hd__tapvpwrvgnd_1
X_1986_ B_reg\[0\] _1246_ _1250_ VGND VGND VPWR VPWR _1251_ sky130_fd_sc_hd__o21a_1
XFILLER_60_293 VPWR VGND VPWR VGND sky130_ef_sc_hd__decap_12
XFILLER_147_833 VGND VGND VPWR VPWR sky130_fd_sc_hd__decap_6
XFILLER_146_321 VPWR VGND VPWR VGND sky130_ef_sc_hd__decap_12
XTAP_TAPCELL_ROW_151_2745 VGND VPWR sky130_fd_sc_hd__tapvpwrvgnd_1
XFILLER_147_877 VPWR VGND VPWR VGND sky130_ef_sc_hd__decap_12
XFILLER_146_365 VPWR VGND VPWR VGND sky130_ef_sc_hd__decap_12
XFILLER_115_741 VPWR VGND VPWR VGND sky130_ef_sc_hd__decap_12
X_2607_ _0185_ _0351_ _0347_ _0343_ VGND VGND VPWR VPWR _0352_ sky130_fd_sc_hd__a2bb2o_1
XTAP_TAPCELL_ROW_58_1260 VGND VPWR sky130_fd_sc_hd__tapvpwrvgnd_1
XFILLER_115_785 VPWR VGND VPWR VGND sky130_ef_sc_hd__decap_12
XFILLER_114_251 VGND VGND VPWR VPWR sky130_fd_sc_hd__fill_1
XFILLER_88_625 VPWR VGND VPWR VGND sky130_ef_sc_hd__decap_12
X_2538_ _0258_ _0280_ _0283_ VGND VGND VPWR VPWR _0286_ sky130_fd_sc_hd__or3b_1
XFILLER_130_755 VGND VGND VPWR VPWR sky130_fd_sc_hd__fill_1
XFILLER_87_113 VPWR VGND VPWR VGND sky130_ef_sc_hd__decap_12
XTAP_TAPCELL_ROW_71_1471 VGND VPWR sky130_fd_sc_hd__tapvpwrvgnd_1
XTAP_TAPCELL_ROW_71_1460 VGND VPWR sky130_fd_sc_hd__tapvpwrvgnd_1
X_2469_ a_r1\[0\] b_r1\[0\] VGND VGND VPWR VPWR _0217_ sky130_fd_sc_hd__or2_1
XFILLER_87_179 VPWR VGND VPWR VGND sky130_ef_sc_hd__decap_12
XFILLER_28_213 VGND VGND VPWR VPWR sky130_fd_sc_hd__fill_1
XFILLER_56_533 VPWR VGND VPWR VGND sky130_ef_sc_hd__decap_12
XTAP_TAPCELL_ROW_3_378 VGND VPWR sky130_fd_sc_hd__tapvpwrvgnd_1
XFILLER_17_909 VGND VGND VPWR VPWR sky130_fd_sc_hd__fill_1
XANTENNA__1811__A A_reg\[3\] VGND VGND VPWR VPWR sky130_fd_sc_hd__diode_2
XFILLER_44_706 VGND VGND VPWR VPWR sky130_fd_sc_hd__decap_4
XFILLER_83_385 VGND VGND VPWR VPWR sky130_fd_sc_hd__decap_6
XFILLER_73_27 VPWR VGND VPWR VGND sky130_ef_sc_hd__decap_12
XFILLER_71_503 VGND VGND VPWR VPWR sky130_fd_sc_hd__fill_1
XFILLER_16_419 VGND VGND VPWR VPWR sky130_fd_sc_hd__fill_1
XFILLER_44_728 VPWR VGND VPWR VGND sky130_ef_sc_hd__decap_12
XFILLER_43_249 VPWR VGND VPWR VGND sky130_ef_sc_hd__decap_12
XFILLER_12_603 VPWR VGND VPWR VGND sky130_ef_sc_hd__decap_12
XANTENNA__2640__A2 _0910_ VGND VGND VPWR VPWR sky130_fd_sc_hd__diode_2
XFILLER_11_113 VPWR VGND VPWR VGND sky130_ef_sc_hd__decap_12
XFILLER_138_811 VGND VGND VPWR VPWR sky130_fd_sc_hd__fill_1
XFILLER_51_293 VGND VGND VPWR VPWR sky130_fd_sc_hd__fill_1
XFILLER_12_669 VPWR VGND VPWR VGND sky130_ef_sc_hd__decap_12
XFILLER_149_181 VPWR VGND VPWR VGND sky130_ef_sc_hd__decap_12
XTAP_TAPCELL_ROW_22_686 VGND VPWR sky130_fd_sc_hd__tapvpwrvgnd_1
XFILLER_125_505 VPWR VGND VPWR VGND sky130_ef_sc_hd__decap_12
XFILLER_125_3 VPWR VGND VPWR VGND sky130_ef_sc_hd__decap_12
XFILLER_22_53 VPWR VGND VPWR VGND sky130_ef_sc_hd__decap_12
XFILLER_153_825 VPWR VGND VPWR VGND sky130_ef_sc_hd__decap_12
XFILLER_138_53 VPWR VGND VPWR VGND sky130_ef_sc_hd__decap_12
XFILLER_4_813 VPWR VGND VPWR VGND sky130_ef_sc_hd__decap_12
XFILLER_22_97 VPWR VGND VPWR VGND sky130_ef_sc_hd__decap_12
XFILLER_153_869 VPWR VGND VPWR VGND sky130_ef_sc_hd__decap_12
XFILLER_152_357 VGND VGND VPWR VPWR sky130_fd_sc_hd__decap_6
XFILLER_138_97 VPWR VGND VPWR VGND sky130_ef_sc_hd__decap_12
XANTENNA__2156__A1 A_reg\[11\] VGND VGND VPWR VPWR sky130_fd_sc_hd__diode_2
XFILLER_79_614 VGND VGND VPWR VPWR sky130_fd_sc_hd__fill_2
XFILLER_120_221 VPWR VGND VPWR VGND sky130_ef_sc_hd__decap_12
XFILLER_105_273 VGND VGND VPWR VPWR sky130_fd_sc_hd__decap_6
XFILLER_121_777 VGND VGND VPWR VPWR sky130_fd_sc_hd__decap_6
XFILLER_67_809 VPWR VGND VPWR VGND sky130_ef_sc_hd__decap_12
XFILLER_120_265 VPWR VGND VPWR VGND sky130_ef_sc_hd__decap_12
XFILLER_93_105 VGND VGND VPWR VPWR sky130_fd_sc_hd__decap_6
XFILLER_93_149 VPWR VGND VPWR VGND sky130_ef_sc_hd__decap_12
XTAP_TAPCELL_ROW_89_1754 VGND VPWR sky130_fd_sc_hd__tapvpwrvgnd_1
XFILLER_75_853 VPWR VGND VPWR VGND sky130_ef_sc_hd__decap_12
XFILLER_59_393 VPWR VGND VPWR VGND sky130_ef_sc_hd__decap_12
XANTENNA__1721__A A_reg\[0\] VGND VGND VPWR VPWR sky130_fd_sc_hd__diode_2
XFILLER_75_897 VPWR VGND VPWR VGND sky130_ef_sc_hd__decap_12
XFILLER_74_363 VGND VGND VPWR VPWR sky130_fd_sc_hd__fill_1
XFILLER_19_279 VGND VGND VPWR VPWR sky130_fd_sc_hd__fill_1
XFILLER_90_867 VGND VGND VPWR VPWR sky130_fd_sc_hd__fill_1
XANTENNA__3227__CLK clknet_3_3__leaf_clk VGND VGND VPWR VPWR sky130_fd_sc_hd__diode_2
XFILLER_62_569 VPWR VGND VPWR VGND sky130_ef_sc_hd__decap_12
XFILLER_15_485 VPWR VGND VPWR VGND sky130_ef_sc_hd__decap_12
Xclkbuf_3_4__f_clk clknet_0_clk VGND VGND VPWR VPWR clknet_3_4__leaf_clk sky130_fd_sc_hd__clkbuf_16
XFILLER_43_783 VGND VGND VPWR VPWR sky130_fd_sc_hd__fill_1
XTAP_TAPCELL_ROW_100_1932 VGND VPWR sky130_fd_sc_hd__tapvpwrvgnd_1
XFILLER_30_433 VPWR VGND VPWR VGND sky130_ef_sc_hd__decap_12
X_1840_ _0911_ _1104_ VGND VGND VPWR VPWR _1111_ sky130_fd_sc_hd__nor2_1
XFILLER_129_833 VGND VGND VPWR VPWR sky130_fd_sc_hd__decap_6
XFILLER_128_321 VPWR VGND VPWR VGND sky130_ef_sc_hd__decap_12
XFILLER_30_477 VPWR VGND VPWR VGND sky130_ef_sc_hd__decap_12
XTAP_TAPCELL_ROW_41_984 VGND VPWR sky130_fd_sc_hd__tapvpwrvgnd_1
XTAP_TAPCELL_ROW_41_995 VGND VPWR sky130_fd_sc_hd__tapvpwrvgnd_1
XFILLER_129_877 VPWR VGND VPWR VGND sky130_ef_sc_hd__decap_12
XFILLER_8_77 VGND VGND VPWR VPWR sky130_fd_sc_hd__decap_6
X_1771_ _1033_ _1043_ _1039_ VGND VGND VPWR VPWR _1044_ sky130_fd_sc_hd__a21boi_1
XFILLER_144_825 VPWR VGND VPWR VGND sky130_ef_sc_hd__decap_12
XTAP_TAPCELL_ROW_133_2453 VGND VPWR sky130_fd_sc_hd__tapvpwrvgnd_1
XFILLER_128_365 VPWR VGND VPWR VGND sky130_ef_sc_hd__decap_12
XFILLER_7_673 VPWR VGND VPWR VGND sky130_ef_sc_hd__decap_12
XFILLER_144_869 VPWR VGND VPWR VGND sky130_ef_sc_hd__decap_12
XFILLER_143_335 VGND VGND VPWR VPWR sky130_fd_sc_hd__fill_1
XTAP_TAPCELL_ROW_133_2464 VGND VPWR sky130_fd_sc_hd__tapvpwrvgnd_1
XFILLER_40_3 VPWR VGND VPWR VGND sky130_ef_sc_hd__decap_12
XFILLER_69_113 VPWR VGND VPWR VGND sky130_ef_sc_hd__decap_12
X_2323_ _1574_ _1575_ VGND VGND VPWR VPWR _1576_ sky130_fd_sc_hd__and2_1
XFILLER_112_755 VGND VGND VPWR VPWR sky130_fd_sc_hd__fill_1
XFILLER_85_617 VPWR VGND VPWR VGND sky130_ef_sc_hd__decap_12
X_2254_ _0896_ _1507_ _1500_ VGND VGND VPWR VPWR _1511_ sky130_fd_sc_hd__o21bai_1
X_2185_ A_reg\[9\] _1440_ VGND VGND VPWR VPWR _1442_ sky130_fd_sc_hd__xnor2_1
XFILLER_38_533 VPWR VGND VPWR VGND sky130_ef_sc_hd__decap_12
XFILLER_53_503 VGND VGND VPWR VPWR sky130_fd_sc_hd__fill_1
XTAP_TAPCELL_ROW_0_315 VGND VPWR sky130_fd_sc_hd__tapvpwrvgnd_1
XTAP_TAPCELL_ROW_0_326 VGND VPWR sky130_fd_sc_hd__tapvpwrvgnd_1
XTAP_TAPCELL_ROW_0_337 VGND VPWR sky130_fd_sc_hd__tapvpwrvgnd_1
XFILLER_25_205 VPWR VGND VPWR VGND sky130_ef_sc_hd__decap_12
XANTENNA__1631__A _0910_ VGND VGND VPWR VPWR sky130_fd_sc_hd__diode_2
XFILLER_92_193 VGND VGND VPWR VPWR sky130_fd_sc_hd__decap_3
XFILLER_80_333 VPWR VGND VPWR VGND sky130_ef_sc_hd__decap_12
XFILLER_25_249 VPWR VGND VPWR VGND sky130_ef_sc_hd__decap_12
XFILLER_81_889 VGND VGND VPWR VPWR sky130_fd_sc_hd__decap_6
XFILLER_53_569 VGND VGND VPWR VPWR sky130_fd_sc_hd__decap_8
XFILLER_33_293 VGND VGND VPWR VPWR sky130_fd_sc_hd__decap_4
XFILLER_147_641 VPWR VGND VPWR VGND sky130_ef_sc_hd__decap_12
X_1969_ _1231_ _1233_ VGND VGND VPWR VPWR _1234_ sky130_fd_sc_hd__nor2_1
XFILLER_147_685 VPWR VGND VPWR VGND sky130_ef_sc_hd__decap_12
XFILLER_107_505 VPWR VGND VPWR VGND sky130_ef_sc_hd__decap_12
XFILLER_4_109 VPWR VGND VPWR VGND sky130_ef_sc_hd__decap_12
XFILLER_146_195 VGND VGND VPWR VPWR sky130_fd_sc_hd__fill_1
XFILLER_134_357 VGND VGND VPWR VPWR sky130_fd_sc_hd__decap_6
XTAP_TAPCELL_ROW_73_1500 VGND VPWR sky130_fd_sc_hd__tapvpwrvgnd_1
XANTENNA__2138__A1 B_reg\[2\] VGND VGND VPWR VPWR sky130_fd_sc_hd__diode_2
XANTENNA__1806__A A_reg\[4\] VGND VGND VPWR VPWR sky130_fd_sc_hd__diode_2
XFILLER_102_221 VPWR VGND VPWR VGND sky130_ef_sc_hd__decap_12
XFILLER_88_433 VPWR VGND VPWR VGND sky130_ef_sc_hd__decap_12
XFILLER_68_27 VGND VGND VPWR VPWR sky130_fd_sc_hd__fill_1
XTAP_TAPCELL_ROW_8_459 VGND VPWR sky130_fd_sc_hd__tapvpwrvgnd_1
XFILLER_0_337 VPWR VGND VPWR VGND sky130_ef_sc_hd__decap_12
XFILLER_103_777 VGND VGND VPWR VPWR sky130_fd_sc_hd__decap_6
XFILLER_88_477 VPWR VGND VPWR VGND sky130_ef_sc_hd__decap_12
XFILLER_102_265 VPWR VGND VPWR VGND sky130_ef_sc_hd__decap_12
XFILLER_75_105 VGND VGND VPWR VPWR sky130_fd_sc_hd__decap_6
XFILLER_57_820 VGND VGND VPWR VPWR sky130_fd_sc_hd__fill_1
XFILLER_124_77 VGND VGND VPWR VPWR sky130_fd_sc_hd__decap_6
XFILLER_91_609 VGND VGND VPWR VPWR sky130_fd_sc_hd__decap_6
XFILLER_57_853 VPWR VGND VPWR VGND sky130_ef_sc_hd__decap_12
XFILLER_29_533 VGND VGND VPWR VPWR sky130_fd_sc_hd__fill_1
XFILLER_72_801 VGND VGND VPWR VPWR sky130_fd_sc_hd__decap_8
XFILLER_57_897 VPWR VGND VPWR VGND sky130_ef_sc_hd__decap_12
XFILLER_56_363 VGND VGND VPWR VPWR sky130_fd_sc_hd__fill_1
XFILLER_44_514 VPWR VGND VPWR VGND sky130_ef_sc_hd__decap_12
XFILLER_83_193 VPWR VGND VPWR VGND sky130_ef_sc_hd__decap_12
XFILLER_140_65 VPWR VGND VPWR VGND sky130_ef_sc_hd__decap_12
XFILLER_72_867 VGND VGND VPWR VPWR sky130_fd_sc_hd__fill_1
XTAP_TAPCELL_ROW_27_756 VGND VPWR sky130_fd_sc_hd__tapvpwrvgnd_1
XTAP_TAPCELL_ROW_27_767 VGND VPWR sky130_fd_sc_hd__tapvpwrvgnd_1
XFILLER_44_569 VPWR VGND VPWR VGND sky130_ef_sc_hd__decap_12
XTAP_TAPCELL_ROW_84_1673 VGND VPWR sky130_fd_sc_hd__tapvpwrvgnd_1
XFILLER_25_783 VGND VGND VPWR VPWR sky130_fd_sc_hd__fill_1
XFILLER_12_433 VPWR VGND VPWR VGND sky130_ef_sc_hd__decap_12
XFILLER_12_477 VPWR VGND VPWR VGND sky130_ef_sc_hd__decap_12
XFILLER_40_786 VPWR VGND VPWR VGND sky130_ef_sc_hd__decap_12
XFILLER_126_825 VPWR VGND VPWR VGND sky130_ef_sc_hd__decap_12
XFILLER_152_121 VPWR VGND VPWR VGND sky130_ef_sc_hd__decap_12
XFILLER_126_869 VPWR VGND VPWR VGND sky130_ef_sc_hd__decap_12
XFILLER_125_335 VGND VGND VPWR VPWR sky130_fd_sc_hd__fill_1
XTAP_TAPCELL_ROW_115_2172 VGND VPWR sky130_fd_sc_hd__tapvpwrvgnd_1
XFILLER_99_709 VPWR VGND VPWR VGND sky130_ef_sc_hd__decap_12
XFILLER_152_165 VPWR VGND VPWR VGND sky130_ef_sc_hd__decap_12
XFILLER_141_839 VGND VGND VPWR VPWR sky130_fd_sc_hd__fill_1
XFILLER_4_654 VPWR VGND VPWR VGND sky130_ef_sc_hd__decap_12
XPHY_EDGE_ROW_148_Right_148 VGND VGND VPWR VPWR sky130_fd_sc_hd__decap_3
XFILLER_106_582 VGND VGND VPWR VPWR sky130_fd_sc_hd__decap_6
XFILLER_4_698 VGND VGND VPWR VPWR sky130_fd_sc_hd__fill_2
XPHY_EDGE_ROW_18_Left_172 VGND VGND VPWR VPWR sky130_fd_sc_hd__decap_3
XFILLER_121_541 VPWR VGND VPWR VGND sky130_ef_sc_hd__decap_12
XFILLER_67_617 VPWR VGND VPWR VGND sky130_ef_sc_hd__decap_12
XFILLER_121_585 VPWR VGND VPWR VGND sky130_ef_sc_hd__decap_12
XFILLER_66_105 VPWR VGND VPWR VGND sky130_ef_sc_hd__decap_12
XFILLER_0_893 VGND VGND VPWR VPWR sky130_fd_sc_hd__decap_3
XFILLER_35_503 VGND VGND VPWR VPWR sky130_fd_sc_hd__fill_1
XFILLER_47_341 VGND VGND VPWR VPWR sky130_fd_sc_hd__fill_1
XFILLER_62_311 VPWR VGND VPWR VGND sky130_ef_sc_hd__decap_12
XFILLER_63_889 VGND VGND VPWR VPWR sky130_fd_sc_hd__decap_6
XFILLER_23_709 VPWR VGND VPWR VGND sky130_ef_sc_hd__decap_12
XPHY_EDGE_ROW_27_Left_181 VGND VGND VPWR VPWR sky130_fd_sc_hd__decap_3
X_2941_ _0598_ _0616_ _0618_ VGND VGND VPWR VPWR _0629_ sky130_fd_sc_hd__o21ai_1
XFILLER_62_399 VPWR VGND VPWR VGND sky130_ef_sc_hd__decap_12
XFILLER_15_293 VPWR VGND VPWR VGND sky130_ef_sc_hd__decap_12
XFILLER_31_753 VPWR VGND VPWR VGND sky130_ef_sc_hd__decap_12
XFILLER_88_3 VPWR VGND VPWR VGND sky130_ef_sc_hd__decap_12
X_2872_ _0554_ _0558_ VGND VGND VPWR VPWR _0560_ sky130_fd_sc_hd__and2_1
XFILLER_129_641 VPWR VGND VPWR VGND sky130_ef_sc_hd__decap_12
X_1823_ A_reg\[1\] _1094_ VGND VGND VPWR VPWR _1096_ sky130_fd_sc_hd__or2_1
XFILLER_129_685 VPWR VGND VPWR VGND sky130_ef_sc_hd__decap_12
X_1754_ A_reg\[10\] _1022_ _1024_ _1025_ VGND VGND VPWR VPWR _1027_ sky130_fd_sc_hd__o22a_1
XFILLER_128_195 VGND VGND VPWR VPWR sky130_fd_sc_hd__fill_1
XFILLER_131_305 VPWR VGND VPWR VGND sky130_ef_sc_hd__decap_12
XFILLER_116_357 VGND VGND VPWR VPWR sky130_fd_sc_hd__decap_6
XANTENNA__1626__A B_reg\[4\] VGND VGND VPWR VPWR sky130_fd_sc_hd__diode_2
X_1685_ _0958_ _0960_ A_reg\[6\] VGND VGND VPWR VPWR _0961_ sky130_fd_sc_hd__o21a_1
XPHY_EDGE_ROW_36_Left_190 VGND VGND VPWR VPWR sky130_fd_sc_hd__decap_3
XFILLER_144_699 VGND VGND VPWR VPWR sky130_fd_sc_hd__fill_1
XFILLER_131_349 VPWR VGND VPWR VGND sky130_ef_sc_hd__decap_12
XPHY_EDGE_ROW_115_Right_115 VGND VGND VPWR VPWR sky130_fd_sc_hd__decap_3
XFILLER_140_861 VGND VGND VPWR VPWR sky130_fd_sc_hd__decap_6
XTAP_TAPCELL_ROW_5_418 VGND VPWR sky130_fd_sc_hd__tapvpwrvgnd_1
XTAP_TAPCELL_ROW_5_407 VGND VPWR sky130_fd_sc_hd__tapvpwrvgnd_1
XFILLER_100_725 VPWR VGND VPWR VGND sky130_ef_sc_hd__decap_12
X_2306_ _1554_ _1555_ _1558_ _1550_ VGND VGND VPWR VPWR _1559_ sky130_fd_sc_hd__o22a_1
XTAP_TAPCELL_ROW_51_1149 VGND VPWR sky130_fd_sc_hd__tapvpwrvgnd_1
X_3286_ clknet_3_5__leaf_clk _0069_ net36 VGND VGND VPWR VPWR A_reg\[12\] sky130_fd_sc_hd__dfrtp_4
XTAP_TAPCELL_ROW_146_2666 VGND VPWR sky130_fd_sc_hd__tapvpwrvgnd_1
XFILLER_100_769 VPWR VGND VPWR VGND sky130_ef_sc_hd__decap_12
XFILLER_85_447 VGND VGND VPWR VPWR sky130_fd_sc_hd__fill_1
XFILLER_73_609 VGND VGND VPWR VPWR sky130_fd_sc_hd__decap_6
XFILLER_57_149 VPWR VGND VPWR VGND sky130_ef_sc_hd__decap_12
X_2237_ _1481_ _1485_ _1483_ VGND VGND VPWR VPWR _1494_ sky130_fd_sc_hd__a21oi_1
XFILLER_72_108 VPWR VGND VPWR VGND sky130_ef_sc_hd__decap_12
XFILLER_39_897 VGND VGND VPWR VPWR sky130_fd_sc_hd__decap_8
XFILLER_54_29 VPWR VGND VPWR VGND sky130_ef_sc_hd__decap_12
X_2168_ _1417_ _1418_ _1420_ A_reg\[10\] VGND VGND VPWR VPWR _1425_ sky130_fd_sc_hd__a2bb2o_1
XFILLER_26_525 VGND VGND VPWR VPWR sky130_fd_sc_hd__decap_6
XFILLER_81_653 VPWR VGND VPWR VGND sky130_ef_sc_hd__decap_12
XFILLER_54_867 VGND VGND VPWR VPWR sky130_fd_sc_hd__fill_1
X_2099_ B_reg\[15\] B_reg\[13\] B_reg\[14\] VGND VGND VPWR VPWR _1358_ sky130_fd_sc_hd__or3b_1
XFILLER_81_697 VPWR VGND VPWR VGND sky130_ef_sc_hd__decap_12
XTAP_TAPCELL_ROW_66_1381 VGND VPWR sky130_fd_sc_hd__tapvpwrvgnd_1
XTAP_TAPCELL_ROW_24_715 VGND VPWR sky130_fd_sc_hd__tapvpwrvgnd_1
XFILLER_41_517 VPWR VGND VPWR VGND sky130_ef_sc_hd__decap_12
XFILLER_139_405 VPWR VGND VPWR VGND sky130_ef_sc_hd__decap_12
XTAP_TAPCELL_ROW_66_1392 VGND VPWR sky130_fd_sc_hd__tapvpwrvgnd_1
XFILLER_139_449 VPWR VGND VPWR VGND sky130_ef_sc_hd__decap_12
XFILLER_21_241 VPWR VGND VPWR VGND sky130_ef_sc_hd__decap_12
XPHY_EDGE_ROW_17_Right_17 VGND VGND VPWR VPWR sky130_fd_sc_hd__decap_3
XFILLER_108_825 VPWR VGND VPWR VGND sky130_ef_sc_hd__decap_12
XFILLER_5_429 VPWR VGND VPWR VGND sky130_ef_sc_hd__decap_12
XFILLER_134_121 VPWR VGND VPWR VGND sky130_ef_sc_hd__decap_12
XFILLER_119_55 VGND VGND VPWR VPWR sky130_fd_sc_hd__fill_1
XFILLER_108_869 VPWR VGND VPWR VGND sky130_ef_sc_hd__decap_12
XFILLER_107_335 VGND VGND VPWR VPWR sky130_fd_sc_hd__fill_1
XFILLER_134_165 VPWR VGND VPWR VGND sky130_ef_sc_hd__decap_12
XFILLER_150_625 VPWR VGND VPWR VGND sky130_ef_sc_hd__decap_12
XFILLER_123_839 VGND VGND VPWR VPWR sky130_fd_sc_hd__fill_1
XFILLER_150_669 VPWR VGND VPWR VGND sky130_ef_sc_hd__decap_12
XFILLER_103_541 VPWR VGND VPWR VGND sky130_ef_sc_hd__decap_12
XFILLER_89_753 VPWR VGND VPWR VGND sky130_ef_sc_hd__decap_12
XTAP_TAPCELL_ROW_110_2091 VGND VPWR sky130_fd_sc_hd__tapvpwrvgnd_1
XFILLER_89_797 VPWR VGND VPWR VGND sky130_ef_sc_hd__decap_12
XPHY_EDGE_ROW_26_Right_26 VGND VGND VPWR VPWR sky130_fd_sc_hd__decap_3
XFILLER_28_41 VPWR VGND VPWR VGND sky130_ef_sc_hd__decap_12
XANTENNA__3255__RESET_B net36 VGND VGND VPWR VPWR sky130_fd_sc_hd__diode_2
XTAP_TAPCELL_ROW_86_1713 VGND VPWR sky130_fd_sc_hd__tapvpwrvgnd_1
XTAP_TAPCELL_ROW_86_1702 VGND VPWR sky130_fd_sc_hd__tapvpwrvgnd_1
XFILLER_76_469 VGND VGND VPWR VPWR sky130_fd_sc_hd__decap_6
XFILLER_17_503 VGND VGND VPWR VPWR sky130_fd_sc_hd__fill_1
XFILLER_28_85 VPWR VGND VPWR VGND sky130_ef_sc_hd__decap_12
XFILLER_29_385 VGND VGND VPWR VPWR sky130_fd_sc_hd__decap_6
XFILLER_44_333 VPWR VGND VPWR VGND sky130_ef_sc_hd__decap_12
XFILLER_71_185 VGND VGND VPWR VPWR sky130_fd_sc_hd__fill_1
XFILLER_44_399 VPWR VGND VPWR VGND sky130_ef_sc_hd__decap_12
XFILLER_60_859 VGND VGND VPWR VPWR sky130_fd_sc_hd__decap_8
XFILLER_13_753 VPWR VGND VPWR VGND sky130_ef_sc_hd__decap_12
XPHY_EDGE_ROW_35_Right_35 VGND VGND VPWR VPWR sky130_fd_sc_hd__decap_3
XFILLER_146_909 VGND VGND VPWR VPWR sky130_fd_sc_hd__fill_1
XTAP_TAPCELL_ROW_117_2201 VGND VPWR sky130_fd_sc_hd__tapvpwrvgnd_1
XFILLER_8_245 VGND VGND VPWR VPWR sky130_fd_sc_hd__decap_6
XFILLER_13_797 VPWR VGND VPWR VGND sky130_ef_sc_hd__decap_12
XFILLER_60_61 VPWR VGND VPWR VGND sky130_ef_sc_hd__decap_12
XTAP_TAPCELL_ROW_97_1886 VGND VPWR sky130_fd_sc_hd__tapvpwrvgnd_1
XFILLER_67_8 VGND VGND VPWR VPWR sky130_fd_sc_hd__decap_6
XTAP_TAPCELL_ROW_10_486 VGND VPWR sky130_fd_sc_hd__tapvpwrvgnd_1
XFILLER_8_289 VPWR VGND VPWR VGND sky130_ef_sc_hd__decap_12
XTAP_TAPCELL_ROW_130_2412 VGND VPWR sky130_fd_sc_hd__tapvpwrvgnd_1
XFILLER_113_305 VPWR VGND VPWR VGND sky130_ef_sc_hd__decap_12
XFILLER_99_517 VPWR VGND VPWR VGND sky130_ef_sc_hd__decap_12
XTAP_TAPCELL_ROW_10_497 VGND VPWR sky130_fd_sc_hd__tapvpwrvgnd_1
XFILLER_126_699 VGND VGND VPWR VPWR sky130_fd_sc_hd__fill_1
XFILLER_99_539 VPWR VGND VPWR VGND sky130_ef_sc_hd__decap_12
XFILLER_122_861 VGND VGND VPWR VPWR sky130_fd_sc_hd__decap_6
XFILLER_113_349 VPWR VGND VPWR VGND sky130_ef_sc_hd__decap_12
XPHY_EDGE_ROW_44_Right_44 VGND VGND VPWR VPWR sky130_fd_sc_hd__decap_3
X_3140_ _0825_ _0822_ _0773_ VGND VGND VPWR VPWR _0828_ sky130_fd_sc_hd__mux2_1
XFILLER_39_105 VGND VGND VPWR VPWR sky130_fd_sc_hd__decap_6
XFILLER_121_393 VPWR VGND VPWR VGND sky130_ef_sc_hd__decap_12
XFILLER_94_233 VPWR VGND VPWR VGND sky130_ef_sc_hd__decap_12
XFILLER_39_149 VPWR VGND VPWR VGND sky130_ef_sc_hd__decap_12
XTAP_TAPCELL_ROW_128_2385 VGND VPWR sky130_fd_sc_hd__tapvpwrvgnd_1
XTAP_TAPCELL_ROW_128_2374 VGND VPWR sky130_fd_sc_hd__tapvpwrvgnd_1
XFILLER_94_277 VPWR VGND VPWR VGND sky130_ef_sc_hd__decap_12
XFILLER_82_406 VPWR VGND VPWR VGND sky130_ef_sc_hd__decap_12
X_3071_ _0754_ _0756_ _0758_ VGND VGND VPWR VPWR _0759_ sky130_fd_sc_hd__or3_1
X_2022_ _0901_ _1275_ _1278_ VGND VGND VPWR VPWR _1284_ sky130_fd_sc_hd__or3_1
XFILLER_63_664 VGND VGND VPWR VPWR sky130_fd_sc_hd__decap_8
XFILLER_62_141 VPWR VGND VPWR VGND sky130_ef_sc_hd__decap_12
XFILLER_47_193 VPWR VGND VPWR VGND sky130_ef_sc_hd__decap_12
XTAP_TAPCELL_ROW_141_2585 VGND VPWR sky130_fd_sc_hd__tapvpwrvgnd_1
XFILLER_63_697 VPWR VGND VPWR VGND sky130_ef_sc_hd__decap_12
XFILLER_23_517 VPWR VGND VPWR VGND sky130_ef_sc_hd__decap_12
XFILLER_62_185 VGND VGND VPWR VPWR sky130_fd_sc_hd__decap_3
XPHY_EDGE_ROW_53_Right_53 VGND VGND VPWR VPWR sky130_fd_sc_hd__decap_3
X_2924_ _0562_ _0606_ _0611_ VGND VGND VPWR VPWR _0612_ sky130_fd_sc_hd__and3_1
XFILLER_31_561 VGND VGND VPWR VPWR sky130_fd_sc_hd__decap_4
XFILLER_137_909 VGND VGND VPWR VPWR sky130_fd_sc_hd__fill_1
X_2855_ net28 B_reg\[5\] _0383_ VGND VGND VPWR VPWR _0078_ sky130_fd_sc_hd__mux2_1
XFILLER_136_419 VGND VGND VPWR VPWR sky130_fd_sc_hd__fill_1
X_1806_ A_reg\[4\] _1076_ VGND VGND VPWR VPWR _1079_ sky130_fd_sc_hd__xnor2_1
XFILLER_116_121 VPWR VGND VPWR VGND sky130_ef_sc_hd__decap_12
X_2786_ _0420_ _0525_ VGND VGND VPWR VPWR _0526_ sky130_fd_sc_hd__nand2_1
X_1737_ A_reg\[13\] _0913_ _1008_ A_reg\[12\] A_reg\[14\] VGND VGND VPWR VPWR _1010_
+ sky130_fd_sc_hd__o221a_1
XFILLER_132_625 VPWR VGND VPWR VGND sky130_ef_sc_hd__decap_12
XFILLER_131_113 VPWR VGND VPWR VGND sky130_ef_sc_hd__decap_12
XFILLER_116_165 VPWR VGND VPWR VGND sky130_ef_sc_hd__decap_12
XFILLER_105_839 VGND VGND VPWR VPWR sky130_fd_sc_hd__fill_1
XPHY_EDGE_ROW_62_Right_62 VGND VGND VPWR VPWR sky130_fd_sc_hd__decap_3
X_1668_ _0934_ _0937_ _0938_ VGND VGND VPWR VPWR _0944_ sky130_fd_sc_hd__or3_1
XTAP_TAPCELL_ROW_148_2706 VGND VPWR sky130_fd_sc_hd__tapvpwrvgnd_1
XFILLER_132_669 VPWR VGND VPWR VGND sky130_ef_sc_hd__decap_12
XFILLER_86_734 VPWR VGND VPWR VGND sky130_ef_sc_hd__decap_12
XFILLER_85_200 VPWR VGND VPWR VGND sky130_ef_sc_hd__decap_12
XFILLER_105_57 VPWR VGND VPWR VGND sky130_ef_sc_hd__decap_12
XFILLER_100_533 VPWR VGND VPWR VGND sky130_ef_sc_hd__decap_12
XFILLER_58_458 VPWR VGND VPWR VGND sky130_ef_sc_hd__decap_12
XFILLER_85_277 VGND VGND VPWR VPWR sky130_fd_sc_hd__decap_3
XFILLER_73_417 VPWR VGND VPWR VGND sky130_ef_sc_hd__decap_12
XFILLER_65_28 VPWR VGND VPWR VGND sky130_ef_sc_hd__decap_12
XFILLER_46_609 VGND VGND VPWR VPWR sky130_fd_sc_hd__fill_1
X_3269_ clknet_3_5__leaf_clk _0052_ net36 VGND VGND VPWR VPWR net40 sky130_fd_sc_hd__dfrtp_1
XANTENNA__2816__A2 _0910_ VGND VGND VPWR VPWR sky130_fd_sc_hd__diode_2
XFILLER_73_439 VGND VGND VPWR VPWR sky130_fd_sc_hd__decap_8
XTAP_TAPCELL_ROW_68_1421 VGND VPWR sky130_fd_sc_hd__tapvpwrvgnd_1
XFILLER_54_642 VGND VGND VPWR VPWR sky130_fd_sc_hd__fill_2
XFILLER_26_344 VPWR VGND VPWR VGND sky130_ef_sc_hd__decap_12
XFILLER_81_27 VPWR VGND VPWR VGND sky130_ef_sc_hd__decap_12
XPHY_EDGE_ROW_71_Right_71 VGND VGND VPWR VPWR sky130_fd_sc_hd__decap_3
XFILLER_54_675 VGND VGND VPWR VPWR sky130_fd_sc_hd__fill_2
XFILLER_26_377 VGND VGND VPWR VPWR sky130_fd_sc_hd__decap_6
XFILLER_27_889 VGND VGND VPWR VPWR sky130_fd_sc_hd__decap_6
XTAP_TAPCELL_ROW_81_1632 VGND VPWR sky130_fd_sc_hd__tapvpwrvgnd_1
XTAP_TAPCELL_ROW_81_1621 VGND VPWR sky130_fd_sc_hd__tapvpwrvgnd_1
XFILLER_41_347 VPWR VGND VPWR VGND sky130_ef_sc_hd__decap_12
XFILLER_10_701 VPWR VGND VPWR VGND sky130_ef_sc_hd__decap_12
XFILLER_128_909 VGND VGND VPWR VPWR sky130_fd_sc_hd__fill_1
XFILLER_50_881 VPWR VGND VPWR VGND sky130_ef_sc_hd__decap_12
XFILLER_14_65 VPWR VGND VPWR VGND sky130_ef_sc_hd__decap_12
XFILLER_139_279 VGND VGND VPWR VPWR sky130_fd_sc_hd__fill_1
XFILLER_6_749 VGND VGND VPWR VPWR sky130_fd_sc_hd__decap_6
XFILLER_135_441 VGND VGND VPWR VPWR sky130_fd_sc_hd__decap_6
XTAP_TAPCELL_ROW_112_2120 VGND VPWR sky130_fd_sc_hd__tapvpwrvgnd_1
XANTENNA__2752__A1 _0187_ VGND VGND VPWR VPWR sky130_fd_sc_hd__diode_2
XPHY_EDGE_ROW_80_Right_80 VGND VGND VPWR VPWR sky130_fd_sc_hd__decap_3
XTAP_TAPCELL_ROW_79_1594 VGND VPWR sky130_fd_sc_hd__tapvpwrvgnd_1
XFILLER_30_53 VPWR VGND VPWR VGND sky130_ef_sc_hd__decap_12
XFILLER_146_53 VPWR VGND VPWR VGND sky130_ef_sc_hd__decap_12
XFILLER_135_485 VPWR VGND VPWR VGND sky130_ef_sc_hd__decap_12
XTAP_TAPCELL_ROW_112_2131 VGND VPWR sky130_fd_sc_hd__tapvpwrvgnd_1
XFILLER_108_699 VGND VGND VPWR VPWR sky130_fd_sc_hd__fill_1
XFILLER_30_97 VPWR VGND VPWR VGND sky130_ef_sc_hd__decap_12
XFILLER_150_433 VPWR VGND VPWR VGND sky130_ef_sc_hd__decap_12
XFILLER_146_97 VPWR VGND VPWR VGND sky130_ef_sc_hd__decap_12
XFILLER_111_809 VPWR VGND VPWR VGND sky130_ef_sc_hd__decap_12
XFILLER_150_477 VPWR VGND VPWR VGND sky130_ef_sc_hd__decap_12
XFILLER_104_861 VGND VGND VPWR VPWR sky130_fd_sc_hd__decap_6
XFILLER_89_561 VPWR VGND VPWR VGND sky130_ef_sc_hd__decap_12
XFILLER_39_51 VGND VGND VPWR VPWR sky130_fd_sc_hd__decap_4
XFILLER_103_393 VPWR VGND VPWR VGND sky130_ef_sc_hd__decap_12
XFILLER_77_756 VPWR VGND VPWR VGND sky130_ef_sc_hd__decap_12
XFILLER_76_233 VPWR VGND VPWR VGND sky130_ef_sc_hd__decap_12
XFILLER_92_737 VPWR VGND VPWR VGND sky130_ef_sc_hd__decap_12
XFILLER_91_225 VPWR VGND VPWR VGND sky130_ef_sc_hd__decap_12
XFILLER_76_288 VGND VGND VPWR VPWR sky130_fd_sc_hd__fill_2
XFILLER_18_867 VGND VGND VPWR VPWR sky130_fd_sc_hd__fill_1
XFILLER_29_193 VPWR VGND VPWR VGND sky130_ef_sc_hd__decap_12
XFILLER_44_141 VPWR VGND VPWR VGND sky130_ef_sc_hd__decap_12
XTAP_TAPCELL_ROW_123_2293 VGND VPWR sky130_fd_sc_hd__tapvpwrvgnd_1
XFILLER_60_623 VPWR VGND VPWR VGND sky130_ef_sc_hd__decap_12
XFILLER_60_601 VPWR VGND VPWR VGND sky130_ef_sc_hd__decap_12
XFILLER_60_645 VPWR VGND VPWR VGND sky130_ef_sc_hd__decap_12
XFILLER_60_667 VPWR VGND VPWR VGND sky130_ef_sc_hd__decap_12
XFILLER_13_561 VPWR VGND VPWR VGND sky130_ef_sc_hd__decap_12
XTAP_TAPCELL_ROW_15_567 VGND VPWR sky130_fd_sc_hd__tapvpwrvgnd_1
XTAP_TAPCELL_ROW_15_578 VGND VPWR sky130_fd_sc_hd__tapvpwrvgnd_1
XFILLER_119_909 VGND VGND VPWR VPWR sky130_fd_sc_hd__fill_1
XTAP_TAPCELL_ROW_99_1915 VGND VPWR sky130_fd_sc_hd__tapvpwrvgnd_1
XFILLER_145_205 VPWR VGND VPWR VGND sky130_ef_sc_hd__decap_12
XFILLER_118_419 VGND VGND VPWR VPWR sky130_fd_sc_hd__fill_1
X_2640_ u_crt.r2\[2\] _0910_ _0184_ _0382_ VGND VGND VPWR VPWR _0034_ sky130_fd_sc_hd__a22o_1
XFILLER_71_93 VPWR VGND VPWR VGND sky130_ef_sc_hd__decap_12
XFILLER_145_249 VPWR VGND VPWR VGND sky130_ef_sc_hd__decap_12
X_2571_ _0314_ _0315_ VGND VGND VPWR VPWR _0316_ sky130_fd_sc_hd__or2_1
XFILLER_114_625 VPWR VGND VPWR VGND sky130_ef_sc_hd__decap_12
XFILLER_113_113 VPWR VGND VPWR VGND sky130_ef_sc_hd__decap_12
XFILLER_99_303 VPWR VGND VPWR VGND sky130_ef_sc_hd__decap_12
XFILLER_153_293 VPWR VGND VPWR VGND sky130_ef_sc_hd__decap_12
XFILLER_114_669 VPWR VGND VPWR VGND sky130_ef_sc_hd__decap_12
XFILLER_68_701 VGND VGND VPWR VPWR sky130_fd_sc_hd__decap_6
XFILLER_95_531 VPWR VGND VPWR VGND sky130_ef_sc_hd__decap_12
XTAP_TAPCELL_ROW_143_2625 VGND VPWR sky130_fd_sc_hd__tapvpwrvgnd_1
XTAP_TAPCELL_ROW_143_2614 VGND VPWR sky130_fd_sc_hd__tapvpwrvgnd_1
X_3123_ _0790_ _0806_ VGND VGND VPWR VPWR _0811_ sky130_fd_sc_hd__nand2_1
XFILLER_95_586 VPWR VGND VPWR VGND sky130_ef_sc_hd__decap_12
XFILLER_55_417 VPWR VGND VPWR VGND sky130_ef_sc_hd__decap_12
X_3054_ _0739_ _0740_ VGND VGND VPWR VPWR _0742_ sky130_fd_sc_hd__xnor2_1
X_2005_ _1264_ _1266_ B_reg\[11\] VGND VGND VPWR VPWR _1267_ sky130_fd_sc_hd__a21o_1
XFILLER_24_837 VPWR VGND VPWR VGND sky130_ef_sc_hd__decap_12
XTAP_TAPCELL_ROW_63_1340 VGND VPWR sky130_fd_sc_hd__tapvpwrvgnd_1
XFILLER_51_678 VPWR VGND VPWR VGND sky130_ef_sc_hd__decap_12
XTAP_TAPCELL_ROW_34_876 VGND VPWR sky130_fd_sc_hd__tapvpwrvgnd_1
X_2907_ _0583_ _0585_ VGND VGND VPWR VPWR _0595_ sky130_fd_sc_hd__nor2_1
XFILLER_50_177 VPWR VGND VPWR VGND sky130_ef_sc_hd__decap_12
XFILLER_31_380 VPWR VGND VPWR VGND sky130_ef_sc_hd__decap_12
X_2838_ net11 A_reg\[4\] _0383_ VGND VGND VPWR VPWR _0061_ sky130_fd_sc_hd__mux2_1
XFILLER_117_441 VGND VGND VPWR VPWR sky130_fd_sc_hd__decap_6
X_2769_ _0499_ _0508_ VGND VGND VPWR VPWR _0509_ sky130_fd_sc_hd__nand2_1
XFILLER_145_783 VGND VGND VPWR VPWR sky130_fd_sc_hd__fill_1
XFILLER_117_485 VPWR VGND VPWR VGND sky130_ef_sc_hd__decap_12
XANTENNA__2734__A1 a_r3\[3\] VGND VGND VPWR VPWR sky130_fd_sc_hd__diode_2
XFILLER_132_433 VPWR VGND VPWR VGND sky130_ef_sc_hd__decap_12
XFILLER_132_477 VPWR VGND VPWR VGND sky130_ef_sc_hd__decap_12
XFILLER_76_27 VGND VGND VPWR VPWR sky130_fd_sc_hd__fill_1
XFILLER_58_233 VPWR VGND VPWR VGND sky130_ef_sc_hd__decap_12
XFILLER_101_853 VPWR VGND VPWR VGND sky130_ef_sc_hd__decap_12
XFILLER_19_609 VGND VGND VPWR VPWR sky130_fd_sc_hd__decap_6
XFILLER_101_897 VPWR VGND VPWR VGND sky130_ef_sc_hd__decap_12
XFILLER_100_363 VGND VGND VPWR VPWR sky130_fd_sc_hd__fill_1
XANTENNA__2916__Y _0604_ VGND VGND VPWR VPWR sky130_fd_sc_hd__diode_2
XFILLER_73_225 VPWR VGND VPWR VGND sky130_ef_sc_hd__decap_12
XFILLER_132_77 VGND VGND VPWR VPWR sky130_fd_sc_hd__decap_6
XFILLER_27_653 VPWR VGND VPWR VGND sky130_ef_sc_hd__decap_12
XFILLER_39_491 VGND VGND VPWR VPWR sky130_fd_sc_hd__fill_1
XFILLER_82_781 VPWR VGND VPWR VGND sky130_ef_sc_hd__decap_12
XFILLER_26_141 VPWR VGND VPWR VGND sky130_ef_sc_hd__decap_12
XFILLER_27_697 VPWR VGND VPWR VGND sky130_ef_sc_hd__decap_12
XFILLER_42_601 VPWR VGND VPWR VGND sky130_ef_sc_hd__decap_12
XFILLER_14_325 VPWR VGND VPWR VGND sky130_ef_sc_hd__decap_12
XFILLER_41_111 VGND VGND VPWR VPWR sky130_fd_sc_hd__fill_1
XFILLER_42_645 VGND VGND VPWR VPWR sky130_fd_sc_hd__decap_6
XANTENNA__3260__CLK clknet_3_7__leaf_clk VGND VGND VPWR VPWR sky130_fd_sc_hd__diode_2
XTAP_TAPCELL_ROW_12_526 VGND VPWR sky130_fd_sc_hd__tapvpwrvgnd_1
XFILLER_127_205 VPWR VGND VPWR VGND sky130_ef_sc_hd__decap_12
XFILLER_10_531 VGND VGND VPWR VPWR sky130_fd_sc_hd__fill_1
XFILLER_127_249 VPWR VGND VPWR VGND sky130_ef_sc_hd__decap_12
XFILLER_6_513 VPWR VGND VPWR VGND sky130_ef_sc_hd__decap_12
XFILLER_143_709 VPWR VGND VPWR VGND sky130_ef_sc_hd__decap_12
XFILLER_108_474 VGND VGND VPWR VPWR sky130_fd_sc_hd__fill_2
XTAP_TAPCELL_ROW_94_1834 VGND VPWR sky130_fd_sc_hd__tapvpwrvgnd_1
XFILLER_151_753 VPWR VGND VPWR VGND sky130_ef_sc_hd__decap_12
XFILLER_135_293 VPWR VGND VPWR VGND sky130_ef_sc_hd__decap_12
XFILLER_151_797 VPWR VGND VPWR VGND sky130_ef_sc_hd__decap_12
XFILLER_111_617 VPWR VGND VPWR VGND sky130_ef_sc_hd__decap_12
XANTENNA__1724__A _0911_ VGND VGND VPWR VPWR sky130_fd_sc_hd__diode_2
XANTENNA__3270__RESET_B net36 VGND VGND VPWR VPWR sky130_fd_sc_hd__diode_2
XFILLER_1_273 VGND VGND VPWR VPWR sky130_fd_sc_hd__decap_6
XFILLER_77_553 VGND VGND VPWR VPWR sky130_fd_sc_hd__decap_6
XTAP_TAPCELL_ROW_125_2333 VGND VPWR sky130_fd_sc_hd__tapvpwrvgnd_1
XFILLER_77_597 VPWR VGND VPWR VGND sky130_ef_sc_hd__decap_12
XFILLER_66_93 VPWR VGND VPWR VGND sky130_ef_sc_hd__decap_12
XFILLER_92_589 VGND VGND VPWR VPWR sky130_fd_sc_hd__decap_4
XFILLER_80_718 VPWR VGND VPWR VGND sky130_ef_sc_hd__decap_12
XFILLER_33_601 VPWR VGND VPWR VGND sky130_ef_sc_hd__decap_12
XFILLER_45_461 VGND VGND VPWR VPWR sky130_fd_sc_hd__decap_8
XFILLER_45_483 VPWR VGND VPWR VGND sky130_ef_sc_hd__decap_12
XFILLER_32_133 VGND VGND VPWR VPWR sky130_fd_sc_hd__decap_6
XTAP_TAPCELL_ROW_103_1985 VGND VPWR sky130_fd_sc_hd__tapvpwrvgnd_1
XTAP_TAPCELL_ROW_103_1974 VGND VPWR sky130_fd_sc_hd__tapvpwrvgnd_1
XFILLER_60_475 VGND VGND VPWR VPWR sky130_fd_sc_hd__fill_1
XFILLER_14_881 VPWR VGND VPWR VGND sky130_ef_sc_hd__decap_12
XTAP_TAPCELL_ROW_31_824 VGND VPWR sky130_fd_sc_hd__tapvpwrvgnd_1
XTAP_TAPCELL_ROW_31_835 VGND VPWR sky130_fd_sc_hd__tapvpwrvgnd_1
XFILLER_32_177 VPWR VGND VPWR VGND sky130_ef_sc_hd__decap_12
XFILLER_13_380 VGND VGND VPWR VPWR sky130_fd_sc_hd__decap_4
XFILLER_146_525 VGND VGND VPWR VPWR sky130_fd_sc_hd__decap_6
XFILLER_70_3 VPWR VGND VPWR VGND sky130_ef_sc_hd__decap_12
XFILLER_9_373 VPWR VGND VPWR VGND sky130_ef_sc_hd__decap_12
XFILLER_146_569 VPWR VGND VPWR VGND sky130_ef_sc_hd__decap_12
X_2623_ _0326_ _0353_ _0364_ _0367_ VGND VGND VPWR VPWR _0368_ sky130_fd_sc_hd__a31o_1
XFILLER_127_783 VGND VGND VPWR VPWR sky130_fd_sc_hd__fill_1
XFILLER_99_111 VGND VGND VPWR VPWR sky130_fd_sc_hd__fill_1
X_2554_ u_crt.r1\[0\] _0910_ _0184_ _0301_ VGND VGND VPWR VPWR _0029_ sky130_fd_sc_hd__a22o_1
XFILLER_114_433 VPWR VGND VPWR VGND sky130_ef_sc_hd__decap_12
XFILLER_114_477 VPWR VGND VPWR VGND sky130_ef_sc_hd__decap_12
XFILLER_101_105 VGND VGND VPWR VPWR sky130_fd_sc_hd__decap_6
X_2485_ a_r1\[0\] a_r1\[1\] a_r1\[2\] VGND VGND VPWR VPWR _0233_ sky130_fd_sc_hd__a21oi_2
XFILLER_87_328 VGND VGND VPWR VPWR sky130_fd_sc_hd__decap_8
XFILLER_68_531 VGND VGND VPWR VPWR sky130_fd_sc_hd__fill_1
XFILLER_101_149 VPWR VGND VPWR VGND sky130_ef_sc_hd__decap_12
XFILLER_95_361 VPWR VGND VPWR VGND sky130_ef_sc_hd__decap_12
XFILLER_56_737 VPWR VGND VPWR VGND sky130_ef_sc_hd__decap_12
XFILLER_55_225 VPWR VGND VPWR VGND sky130_ef_sc_hd__decap_12
XFILLER_55_203 VPWR VGND VPWR VGND sky130_ef_sc_hd__decap_12
XFILLER_28_417 VGND VGND VPWR VPWR sky130_fd_sc_hd__decap_3
X_3106_ _0788_ _0790_ _0791_ _0793_ VGND VGND VPWR VPWR _0794_ sky130_fd_sc_hd__nand4_1
XTAP_TAPCELL_ROW_39_957 VGND VPWR sky130_fd_sc_hd__tapvpwrvgnd_1
XFILLER_71_729 VPWR VGND VPWR VGND sky130_ef_sc_hd__decap_12
X_3037_ _0723_ _0724_ VGND VGND VPWR VPWR _0725_ sky130_fd_sc_hd__nor2_1
XANTENNA__3283__CLK clknet_3_1__leaf_clk VGND VGND VPWR VPWR sky130_fd_sc_hd__diode_2
XFILLER_24_601 VPWR VGND VPWR VGND sky130_ef_sc_hd__decap_12
XFILLER_23_111 VGND VGND VPWR VPWR sky130_fd_sc_hd__fill_1
XFILLER_24_645 VPWR VGND VPWR VGND sky130_ef_sc_hd__decap_12
XFILLER_62_29 VPWR VGND VPWR VGND sky130_ef_sc_hd__decap_12
XFILLER_137_503 VGND VGND VPWR VPWR sky130_fd_sc_hd__fill_1
XFILLER_109_205 VPWR VGND VPWR VGND sky130_ef_sc_hd__decap_12
XFILLER_149_385 VGND VGND VPWR VPWR sky130_fd_sc_hd__decap_6
XFILLER_125_709 VPWR VGND VPWR VGND sky130_ef_sc_hd__decap_12
XFILLER_109_249 VPWR VGND VPWR VGND sky130_ef_sc_hd__decap_12
XFILLER_105_411 VGND VGND VPWR VPWR sky130_fd_sc_hd__fill_1
XTAP_TAPCELL_ROW_76_1542 VGND VPWR sky130_fd_sc_hd__tapvpwrvgnd_1
XFILLER_11_55 VGND VGND VPWR VPWR sky130_fd_sc_hd__fill_1
XFILLER_3_505 VGND VGND VPWR VPWR sky130_fd_sc_hd__decap_8
XFILLER_133_753 VPWR VGND VPWR VGND sky130_ef_sc_hd__decap_12
XFILLER_127_55 VGND VGND VPWR VPWR sky130_fd_sc_hd__fill_1
XFILLER_117_293 VPWR VGND VPWR VGND sky130_ef_sc_hd__decap_12
XFILLER_87_15 VGND VGND VPWR VPWR sky130_fd_sc_hd__fill_2
XTAP_TAPCELL_ROW_76_1553 VGND VPWR sky130_fd_sc_hd__tapvpwrvgnd_1
XFILLER_133_797 VPWR VGND VPWR VGND sky130_ef_sc_hd__decap_12
XFILLER_120_469 VGND VGND VPWR VPWR sky130_fd_sc_hd__decap_6
XFILLER_59_553 VGND VGND VPWR VPWR sky130_fd_sc_hd__decap_4
XFILLER_87_895 VGND VGND VPWR VPWR sky130_fd_sc_hd__fill_1
XFILLER_74_501 VPWR VGND VPWR VGND sky130_ef_sc_hd__decap_12
XFILLER_19_417 VPWR VGND VPWR VGND sky130_ef_sc_hd__decap_12
XTAP_TAPCELL_ROW_107_2041 VGND VPWR sky130_fd_sc_hd__tapvpwrvgnd_1
XFILLER_74_545 VPWR VGND VPWR VGND sky130_ef_sc_hd__decap_12
XFILLER_55_770 VPWR VGND VPWR VGND sky130_ef_sc_hd__decap_12
XTAP_TAPCELL_ROW_17_607 VGND VPWR sky130_fd_sc_hd__tapvpwrvgnd_1
XFILLER_27_472 VPWR VGND VPWR VGND sky130_ef_sc_hd__decap_12
XFILLER_36_41 VPWR VGND VPWR VGND sky130_ef_sc_hd__decap_12
XANTENNA__2643__A0 net34 VGND VGND VPWR VPWR sky130_fd_sc_hd__diode_2
XFILLER_36_85 VPWR VGND VPWR VGND sky130_ef_sc_hd__decap_12
XTAP_TAPCELL_ROW_120_2252 VGND VPWR sky130_fd_sc_hd__tapvpwrvgnd_1
XFILLER_14_133 VGND VGND VPWR VPWR sky130_fd_sc_hd__decap_6
XFILLER_14_177 VPWR VGND VPWR VGND sky130_ef_sc_hd__decap_12
XFILLER_30_637 VGND VGND VPWR VPWR sky130_fd_sc_hd__decap_6
XFILLER_42_475 VGND VGND VPWR VPWR sky130_fd_sc_hd__fill_1
XFILLER_128_525 VGND VGND VPWR VPWR sky130_fd_sc_hd__decap_6
Xinput27 B_in[4] VGND VGND VPWR VPWR net27 sky130_fd_sc_hd__clkbuf_1
XFILLER_7_833 VGND VGND VPWR VPWR sky130_fd_sc_hd__decap_6
Xinput16 A_in[9] VGND VGND VPWR VPWR net16 sky130_fd_sc_hd__clkbuf_1
XFILLER_11_895 VGND VGND VPWR VPWR sky130_fd_sc_hd__fill_1
XFILLER_128_569 VPWR VGND VPWR VGND sky130_ef_sc_hd__decap_12
XFILLER_7_877 VPWR VGND VPWR VGND sky130_ef_sc_hd__decap_12
XFILLER_6_321 VPWR VGND VPWR VGND sky130_ef_sc_hd__decap_12
XFILLER_143_517 VPWR VGND VPWR VGND sky130_ef_sc_hd__decap_12
XFILLER_109_783 VGND VGND VPWR VPWR sky130_fd_sc_hd__fill_1
XFILLER_6_365 VPWR VGND VPWR VGND sky130_ef_sc_hd__decap_12
XFILLER_151_561 VPWR VGND VPWR VGND sky130_ef_sc_hd__decap_12
XFILLER_97_615 VGND VGND VPWR VPWR sky130_fd_sc_hd__fill_1
XFILLER_69_328 VGND VGND VPWR VPWR sky130_fd_sc_hd__decap_8
X_2270_ _0895_ _1519_ VGND VGND VPWR VPWR _1527_ sky130_fd_sc_hd__xnor2_1
XFILLER_111_447 VGND VGND VPWR VPWR sky130_fd_sc_hd__fill_1
XFILLER_93_821 VPWR VGND VPWR VGND sky130_ef_sc_hd__decap_12
XFILLER_77_361 VGND VGND VPWR VPWR sky130_fd_sc_hd__decap_4
XFILLER_38_737 VPWR VGND VPWR VGND sky130_ef_sc_hd__decap_12
XFILLER_93_865 VPWR VGND VPWR VGND sky130_ef_sc_hd__decap_12
XFILLER_37_225 VPWR VGND VPWR VGND sky130_ef_sc_hd__decap_12
XANTENNA__2285__A A_reg\[0\] VGND VGND VPWR VPWR sky130_fd_sc_hd__diode_2
XFILLER_53_729 VPWR VGND VPWR VGND sky130_ef_sc_hd__decap_12
XTAP_TAPCELL_ROW_36_905 VGND VPWR sky130_fd_sc_hd__tapvpwrvgnd_1
XFILLER_80_537 VGND VGND VPWR VPWR sky130_fd_sc_hd__fill_1
XANTENNA__2634__B1 _0910_ VGND VGND VPWR VPWR sky130_fd_sc_hd__diode_2
XFILLER_46_781 VGND VGND VPWR VPWR sky130_fd_sc_hd__decap_8
XFILLER_21_615 VGND VGND VPWR VPWR sky130_fd_sc_hd__fill_1
XTAP_TAPCELL_ROW_43_1018 VGND VPWR sky130_fd_sc_hd__tapvpwrvgnd_1
XTAP_TAPCELL_ROW_138_2546 VGND VPWR sky130_fd_sc_hd__tapvpwrvgnd_1
XTAP_TAPCELL_ROW_138_2535 VGND VPWR sky130_fd_sc_hd__tapvpwrvgnd_1
XFILLER_119_503 VGND VGND VPWR VPWR sky130_fd_sc_hd__fill_1
XANTENNA__1629__A B_reg\[1\] VGND VGND VPWR VPWR sky130_fd_sc_hd__diode_2
X_1985_ _1246_ _1248_ B_reg\[0\] VGND VGND VPWR VPWR _1250_ sky130_fd_sc_hd__o21ai_1
XFILLER_147_889 VGND VGND VPWR VPWR sky130_fd_sc_hd__decap_6
XFILLER_146_333 VPWR VGND VPWR VGND sky130_ef_sc_hd__decap_12
XFILLER_107_709 VPWR VGND VPWR VGND sky130_ef_sc_hd__decap_12
XFILLER_9_181 VPWR VGND VPWR VGND sky130_ef_sc_hd__decap_12
XTAP_TAPCELL_ROW_151_2746 VGND VPWR sky130_fd_sc_hd__tapvpwrvgnd_1
XFILLER_146_377 VPWR VGND VPWR VGND sky130_ef_sc_hd__decap_12
X_2606_ _0188_ _0321_ _0348_ _0349_ _0350_ VGND VGND VPWR VPWR _0351_ sky130_fd_sc_hd__o32a_1
XFILLER_115_753 VPWR VGND VPWR VGND sky130_ef_sc_hd__decap_12
XTAP_TAPCELL_ROW_58_1261 VGND VPWR sky130_fd_sc_hd__tapvpwrvgnd_1
XANTENNA__1635__Y CRT_Start VGND VGND VPWR VPWR sky130_fd_sc_hd__diode_2
XFILLER_130_701 VPWR VGND VPWR VGND sky130_ef_sc_hd__decap_12
X_2537_ _0237_ _0284_ VGND VGND VPWR VPWR _0285_ sky130_fd_sc_hd__nor2_1
XFILLER_115_797 VPWR VGND VPWR VGND sky130_ef_sc_hd__decap_12
XFILLER_102_436 VGND VGND VPWR VPWR sky130_fd_sc_hd__fill_2
XFILLER_102_414 VGND VGND VPWR VPWR sky130_fd_sc_hd__fill_1
XFILLER_88_637 VGND VGND VPWR VPWR sky130_fd_sc_hd__decap_6
XFILLER_87_125 VPWR VGND VPWR VGND sky130_ef_sc_hd__decap_12
X_2468_ a_r1\[0\] b_r1\[0\] VGND VGND VPWR VPWR _0216_ sky130_fd_sc_hd__nand2_2
XFILLER_102_458 VPWR VGND VPWR VGND sky130_ef_sc_hd__decap_12
XFILLER_87_169 VGND VGND VPWR VPWR sky130_fd_sc_hd__decap_3
XTAP_TAPCELL_ROW_71_1472 VGND VPWR sky130_fd_sc_hd__tapvpwrvgnd_1
XTAP_TAPCELL_ROW_71_1461 VGND VPWR sky130_fd_sc_hd__tapvpwrvgnd_1
X_2399_ _0135_ _0152_ _0141_ VGND VGND VPWR VPWR _0153_ sky130_fd_sc_hd__a21bo_1
XFILLER_96_681 VPWR VGND VPWR VGND sky130_ef_sc_hd__decap_12
XFILLER_69_895 VGND VGND VPWR VPWR sky130_fd_sc_hd__fill_1
XFILLER_56_501 VGND VGND VPWR VPWR sky130_fd_sc_hd__decap_6
XFILLER_110_491 VGND VGND VPWR VPWR sky130_fd_sc_hd__decap_3
XFILLER_83_320 VGND VGND VPWR VPWR sky130_fd_sc_hd__decap_4
XFILLER_56_545 VGND VGND VPWR VPWR sky130_fd_sc_hd__decap_8
XFILLER_113_57 VPWR VGND VPWR VGND sky130_ef_sc_hd__decap_12
XFILLER_56_589 VPWR VGND VPWR VGND sky130_ef_sc_hd__decap_12
XTAP_TAPCELL_ROW_3_379 VGND VPWR sky130_fd_sc_hd__tapvpwrvgnd_1
XFILLER_73_39 VPWR VGND VPWR VGND sky130_ef_sc_hd__decap_12
XFILLER_52_751 VGND VGND VPWR VPWR sky130_fd_sc_hd__decap_4
XFILLER_12_615 VPWR VGND VPWR VGND sky130_ef_sc_hd__decap_12
XFILLER_24_475 VGND VGND VPWR VPWR sky130_fd_sc_hd__fill_1
XFILLER_11_125 VPWR VGND VPWR VGND sky130_ef_sc_hd__decap_12
XFILLER_11_169 VPWR VGND VPWR VGND sky130_ef_sc_hd__decap_12
XTAP_TAPCELL_ROW_22_676 VGND VPWR sky130_fd_sc_hd__tapvpwrvgnd_1
XFILLER_149_193 VPWR VGND VPWR VGND sky130_ef_sc_hd__decap_12
XFILLER_138_867 VGND VGND VPWR VPWR sky130_fd_sc_hd__fill_1
XPHY_EDGE_ROW_129_Right_129 VGND VGND VPWR VPWR sky130_fd_sc_hd__decap_3
XFILLER_20_681 VPWR VGND VPWR VGND sky130_ef_sc_hd__decap_12
XFILLER_22_65 VPWR VGND VPWR VGND sky130_ef_sc_hd__decap_12
XTAP_TAPCELL_ROW_22_687 VGND VPWR sky130_fd_sc_hd__tapvpwrvgnd_1
XFILLER_153_837 VGND VGND VPWR VPWR sky130_fd_sc_hd__decap_3
XFILLER_138_65 VPWR VGND VPWR VGND sky130_ef_sc_hd__decap_12
XFILLER_125_517 VPWR VGND VPWR VGND sky130_ef_sc_hd__decap_12
XFILLER_118_3 VPWR VGND VPWR VGND sky130_ef_sc_hd__decap_12
XFILLER_4_825 VPWR VGND VPWR VGND sky130_ef_sc_hd__decap_12
XFILLER_4_869 VPWR VGND VPWR VGND sky130_ef_sc_hd__decap_12
XFILLER_3_335 VGND VGND VPWR VPWR sky130_fd_sc_hd__fill_1
XFILLER_133_561 VPWR VGND VPWR VGND sky130_ef_sc_hd__decap_12
XFILLER_0_3 VPWR VGND VPWR VGND sky130_ef_sc_hd__decap_12
XFILLER_120_233 VPWR VGND VPWR VGND sky130_ef_sc_hd__decap_12
XFILLER_66_309 VPWR VGND VPWR VGND sky130_ef_sc_hd__decap_12
XFILLER_120_277 VPWR VGND VPWR VGND sky130_ef_sc_hd__decap_12
XFILLER_75_821 VPWR VGND VPWR VGND sky130_ef_sc_hd__decap_12
XFILLER_59_361 VPWR VGND VPWR VGND sky130_ef_sc_hd__decap_12
XTAP_TAPCELL_ROW_89_1755 VGND VPWR sky130_fd_sc_hd__tapvpwrvgnd_1
XFILLER_75_865 VPWR VGND VPWR VGND sky130_ef_sc_hd__decap_12
XFILLER_19_225 VPWR VGND VPWR VGND sky130_ef_sc_hd__decap_12
XFILLER_47_51 VGND VGND VPWR VPWR sky130_fd_sc_hd__decap_4
XFILLER_90_813 VPWR VGND VPWR VGND sky130_ef_sc_hd__decap_12
XFILLER_35_729 VPWR VGND VPWR VGND sky130_ef_sc_hd__decap_12
XFILLER_28_781 VPWR VGND VPWR VGND sky130_ef_sc_hd__decap_12
XFILLER_34_228 VPWR VGND VPWR VGND sky130_ef_sc_hd__decap_12
XFILLER_97_8 VPWR VGND VPWR VGND sky130_ef_sc_hd__decap_12
XTAP_TAPCELL_ROW_100_1933 VGND VPWR sky130_fd_sc_hd__tapvpwrvgnd_1
XFILLER_15_497 VGND VGND VPWR VPWR sky130_fd_sc_hd__decap_6
XFILLER_30_445 VPWR VGND VPWR VGND sky130_ef_sc_hd__decap_12
X_1770_ A_reg\[9\] _1030_ _1036_ VGND VGND VPWR VPWR _1043_ sky130_fd_sc_hd__or3_1
XFILLER_30_489 VPWR VGND VPWR VGND sky130_ef_sc_hd__decap_12
XTAP_TAPCELL_ROW_41_985 VGND VPWR sky130_fd_sc_hd__tapvpwrvgnd_1
XFILLER_128_333 VPWR VGND VPWR VGND sky130_ef_sc_hd__decap_12
XFILLER_7_641 VPWR VGND VPWR VGND sky130_ef_sc_hd__decap_12
XFILLER_144_837 VPWR VGND VPWR VGND sky130_ef_sc_hd__decap_12
XTAP_TAPCELL_ROW_133_2454 VGND VPWR sky130_fd_sc_hd__tapvpwrvgnd_1
XFILLER_129_889 VGND VGND VPWR VPWR sky130_fd_sc_hd__decap_6
XFILLER_128_377 VPWR VGND VPWR VGND sky130_ef_sc_hd__decap_12
XFILLER_7_685 VPWR VGND VPWR VGND sky130_ef_sc_hd__decap_12
XTAP_TAPCELL_ROW_133_2465 VGND VPWR sky130_fd_sc_hd__tapvpwrvgnd_1
XFILLER_6_195 VGND VGND VPWR VPWR sky130_fd_sc_hd__fill_1
XFILLER_112_701 VPWR VGND VPWR VGND sky130_ef_sc_hd__decap_12
XFILLER_152_881 VPWR VGND VPWR VGND sky130_ef_sc_hd__decap_12
XFILLER_97_412 VGND VGND VPWR VPWR sky130_fd_sc_hd__decap_3
XFILLER_69_125 VGND VGND VPWR VPWR sky130_fd_sc_hd__decap_8
X_2322_ _1562_ _1571_ VGND VGND VPWR VPWR _1575_ sky130_fd_sc_hd__xnor2_1
XFILLER_33_3 VPWR VGND VPWR VGND sky130_ef_sc_hd__decap_12
XFILLER_151_391 VGND VGND VPWR VPWR sky130_fd_sc_hd__fill_1
XFILLER_97_445 VGND VGND VPWR VPWR sky130_fd_sc_hd__decap_3
XFILLER_85_629 VPWR VGND VPWR VGND sky130_ef_sc_hd__decap_12
XFILLER_78_681 VPWR VGND VPWR VGND sky130_ef_sc_hd__decap_12
XFILLER_69_169 VPWR VGND VPWR VGND sky130_ef_sc_hd__decap_12
XTAP_TAPCELL_ROW_53_1180 VGND VPWR sky130_fd_sc_hd__tapvpwrvgnd_1
X_2253_ _0896_ _1507_ _1500_ VGND VGND VPWR VPWR _1510_ sky130_fd_sc_hd__or3b_1
X_2184_ _0890_ _1440_ VGND VGND VPWR VPWR _1441_ sky130_fd_sc_hd__xnor2_1
XFILLER_38_545 VPWR VGND VPWR VGND sky130_ef_sc_hd__decap_12
XFILLER_93_673 VPWR VGND VPWR VGND sky130_ef_sc_hd__decap_12
XFILLER_80_301 VGND VGND VPWR VPWR sky130_fd_sc_hd__decap_6
XTAP_TAPCELL_ROW_0_316 VGND VPWR sky130_fd_sc_hd__tapvpwrvgnd_1
XTAP_TAPCELL_ROW_0_327 VGND VPWR sky130_fd_sc_hd__tapvpwrvgnd_1
XFILLER_38_589 VPWR VGND VPWR VGND sky130_ef_sc_hd__decap_12
XFILLER_53_548 VGND VGND VPWR VPWR sky130_fd_sc_hd__fill_1
XTAP_TAPCELL_ROW_0_338 VGND VPWR sky130_fd_sc_hd__tapvpwrvgnd_1
XFILLER_25_217 VGND VGND VPWR VPWR sky130_fd_sc_hd__decap_6
XFILLER_80_345 VPWR VGND VPWR VGND sky130_ef_sc_hd__decap_12
XFILLER_53_559 VGND VGND VPWR VPWR sky130_fd_sc_hd__fill_1
XANTENNA__2083__A1 B_reg\[1\] VGND VGND VPWR VPWR sky130_fd_sc_hd__diode_2
XFILLER_40_209 VGND VGND VPWR VPWR sky130_fd_sc_hd__decap_8
XFILLER_139_609 VGND VGND VPWR VPWR sky130_fd_sc_hd__decap_6
XANTENNA__3321__CLK clknet_3_5__leaf_clk VGND VGND VPWR VPWR sky130_fd_sc_hd__diode_2
XFILLER_21_434 VPWR VGND VPWR VGND sky130_ef_sc_hd__decap_12
XFILLER_147_653 VPWR VGND VPWR VGND sky130_ef_sc_hd__decap_12
X_1968_ B_reg\[3\] _1227_ VGND VGND VPWR VPWR _1233_ sky130_fd_sc_hd__nor2_1
XANTENNA__3302__RESET_B net36 VGND VGND VPWR VPWR sky130_fd_sc_hd__diode_2
XFILLER_147_697 VPWR VGND VPWR VGND sky130_ef_sc_hd__decap_12
XFILLER_146_141 VPWR VGND VPWR VGND sky130_ef_sc_hd__decap_12
XFILLER_107_517 VPWR VGND VPWR VGND sky130_ef_sc_hd__decap_12
X_1899_ _0884_ CU_state_dbg\[1\] _0911_ _1163_ VGND VGND VPWR VPWR _0009_ sky130_fd_sc_hd__o211ai_1
XFILLER_115_561 VPWR VGND VPWR VGND sky130_ef_sc_hd__decap_12
XTAP_TAPCELL_ROW_73_1501 VGND VPWR sky130_fd_sc_hd__tapvpwrvgnd_1
XFILLER_0_305 VGND VGND VPWR VPWR sky130_fd_sc_hd__decap_3
XFILLER_1_839 VGND VGND VPWR VPWR sky130_fd_sc_hd__fill_1
XFILLER_130_531 VGND VGND VPWR VPWR sky130_fd_sc_hd__fill_1
XFILLER_102_233 VPWR VGND VPWR VGND sky130_ef_sc_hd__decap_12
XFILLER_88_445 VPWR VGND VPWR VGND sky130_ef_sc_hd__decap_12
XFILLER_0_349 VPWR VGND VPWR VGND sky130_ef_sc_hd__decap_12
XFILLER_102_277 VPWR VGND VPWR VGND sky130_ef_sc_hd__decap_12
XFILLER_88_489 VPWR VGND VPWR VGND sky130_ef_sc_hd__decap_12
XFILLER_76_618 VPWR VGND VPWR VGND sky130_ef_sc_hd__decap_12
XFILLER_75_117 VGND VGND VPWR VPWR sky130_fd_sc_hd__fill_1
XFILLER_57_810 VGND VGND VPWR VPWR sky130_fd_sc_hd__fill_1
XFILLER_48_309 VPWR VGND VPWR VGND sky130_ef_sc_hd__decap_12
XANTENNA__1822__A A_reg\[1\] VGND VGND VPWR VPWR sky130_fd_sc_hd__diode_2
XFILLER_84_16 VGND VGND VPWR VPWR sky130_fd_sc_hd__fill_1
XFILLER_68_191 VGND VGND VPWR VPWR sky130_fd_sc_hd__decap_4
XTAP_TAPCELL_ROW_104_2000 VGND VPWR sky130_fd_sc_hd__tapvpwrvgnd_1
XFILLER_72_813 VPWR VGND VPWR VGND sky130_ef_sc_hd__decap_12
XFILLER_57_865 VPWR VGND VPWR VGND sky130_ef_sc_hd__decap_12
XFILLER_17_729 VPWR VGND VPWR VGND sky130_ef_sc_hd__decap_12
XFILLER_29_567 VPWR VGND VPWR VGND sky130_ef_sc_hd__decap_12
XFILLER_83_161 VGND VGND VPWR VPWR sky130_fd_sc_hd__decap_6
XFILLER_56_375 VGND VGND VPWR VPWR sky130_fd_sc_hd__decap_4
XFILLER_44_526 VGND VGND VPWR VPWR sky130_fd_sc_hd__decap_6
XTAP_TAPCELL_ROW_27_757 VGND VPWR sky130_fd_sc_hd__tapvpwrvgnd_1
XTAP_TAPCELL_ROW_27_768 VGND VPWR sky130_fd_sc_hd__tapvpwrvgnd_1
XFILLER_140_77 VGND VGND VPWR VPWR sky130_fd_sc_hd__decap_6
XTAP_TAPCELL_ROW_84_1674 VGND VPWR sky130_fd_sc_hd__tapvpwrvgnd_1
XFILLER_52_570 VPWR VGND VPWR VGND sky130_ef_sc_hd__decap_12
XFILLER_12_401 VPWR VGND VPWR VGND sky130_ef_sc_hd__decap_12
XFILLER_12_445 VGND VGND VPWR VPWR sky130_fd_sc_hd__fill_2
XFILLER_8_405 VPWR VGND VPWR VGND sky130_ef_sc_hd__decap_12
XFILLER_12_489 VPWR VGND VPWR VGND sky130_ef_sc_hd__decap_12
XFILLER_40_798 VPWR VGND VPWR VGND sky130_ef_sc_hd__decap_12
XFILLER_153_601 VPWR VGND VPWR VGND sky130_ef_sc_hd__decap_12
XFILLER_126_837 VPWR VGND VPWR VGND sky130_ef_sc_hd__decap_12
XFILLER_153_645 VPWR VGND VPWR VGND sky130_ef_sc_hd__decap_12
XFILLER_152_133 VGND VGND VPWR VPWR sky130_fd_sc_hd__decap_6
XTAP_TAPCELL_ROW_115_2173 VGND VPWR sky130_fd_sc_hd__tapvpwrvgnd_1
XFILLER_4_666 VPWR VGND VPWR VGND sky130_ef_sc_hd__decap_12
XFILLER_152_177 VPWR VGND VPWR VGND sky130_ef_sc_hd__decap_12
XFILLER_134_881 VPWR VGND VPWR VGND sky130_ef_sc_hd__decap_12
XFILLER_133_391 VGND VGND VPWR VPWR sky130_fd_sc_hd__fill_1
XFILLER_121_553 VGND VGND VPWR VPWR sky130_fd_sc_hd__decap_6
XFILLER_94_404 VPWR VGND VPWR VGND sky130_ef_sc_hd__decap_12
XFILLER_67_629 VGND VGND VPWR VPWR sky130_fd_sc_hd__decap_8
XFILLER_66_117 VPWR VGND VPWR VGND sky130_ef_sc_hd__decap_12
XFILLER_58_83 VGND VGND VPWR VPWR sky130_fd_sc_hd__fill_1
XFILLER_121_597 VPWR VGND VPWR VGND sky130_ef_sc_hd__decap_12
XANTENNA__2837__A0 net10 VGND VGND VPWR VPWR sky130_fd_sc_hd__diode_2
XFILLER_75_673 VPWR VGND VPWR VGND sky130_ef_sc_hd__decap_12
XFILLER_75_662 VGND VGND VPWR VPWR sky130_fd_sc_hd__decap_8
XFILLER_47_353 VPWR VGND VPWR VGND sky130_ef_sc_hd__decap_12
XANTENNA_clkload3_A clknet_3_3__leaf_clk VGND VGND VPWR VPWR sky130_fd_sc_hd__diode_2
XFILLER_62_323 VPWR VGND VPWR VGND sky130_ef_sc_hd__decap_12
XFILLER_90_643 VGND VGND VPWR VPWR sky130_fd_sc_hd__fill_1
XFILLER_35_559 VGND VGND VPWR VPWR sky130_fd_sc_hd__fill_1
X_2940_ _0621_ _0623_ VGND VGND VPWR VPWR _0628_ sky130_fd_sc_hd__nand2_1
XFILLER_22_209 VPWR VGND VPWR VGND sky130_ef_sc_hd__decap_12
XFILLER_31_721 VGND VGND VPWR VPWR sky130_fd_sc_hd__decap_6
X_2871_ _0554_ _0558_ VGND VGND VPWR VPWR _0559_ sky130_fd_sc_hd__nor2_1
XFILLER_30_253 VPWR VGND VPWR VGND sky130_ef_sc_hd__decap_12
XFILLER_31_765 VPWR VGND VPWR VGND sky130_ef_sc_hd__decap_12
X_1822_ A_reg\[1\] _1094_ VGND VGND VPWR VPWR _1095_ sky130_fd_sc_hd__nor2_1
XFILLER_129_653 VPWR VGND VPWR VGND sky130_ef_sc_hd__decap_12
XFILLER_144_601 VPWR VGND VPWR VGND sky130_ef_sc_hd__decap_12
XFILLER_128_141 VPWR VGND VPWR VGND sky130_ef_sc_hd__decap_12
X_1753_ _1024_ _1025_ VGND VGND VPWR VPWR _1026_ sky130_fd_sc_hd__or2_1
XFILLER_144_645 VPWR VGND VPWR VGND sky130_ef_sc_hd__decap_12
XFILLER_143_111 VGND VGND VPWR VPWR sky130_fd_sc_hd__fill_1
XFILLER_129_697 VPWR VGND VPWR VGND sky130_ef_sc_hd__decap_12
X_1684_ _0949_ _0959_ VGND VGND VPWR VPWR _0960_ sky130_fd_sc_hd__xnor2_1
XFILLER_131_317 VPWR VGND VPWR VGND sky130_ef_sc_hd__decap_12
XFILLER_97_220 VGND VGND VPWR VPWR sky130_fd_sc_hd__fill_1
XFILLER_86_905 VGND VGND VPWR VPWR sky130_fd_sc_hd__decap_4
XTAP_TAPCELL_ROW_5_419 VGND VPWR sky130_fd_sc_hd__tapvpwrvgnd_1
XTAP_TAPCELL_ROW_5_408 VGND VPWR sky130_fd_sc_hd__tapvpwrvgnd_1
X_2305_ _1555_ _1557_ _1553_ VGND VGND VPWR VPWR _1558_ sky130_fd_sc_hd__a21boi_1
X_3285_ clknet_3_5__leaf_clk _0068_ net36 VGND VGND VPWR VPWR A_reg\[11\] sky130_fd_sc_hd__dfrtp_4
XFILLER_39_821 VPWR VGND VPWR VGND sky130_ef_sc_hd__decap_12
XTAP_TAPCELL_ROW_146_2667 VGND VPWR sky130_fd_sc_hd__tapvpwrvgnd_1
XFILLER_100_737 VPWR VGND VPWR VGND sky130_ef_sc_hd__decap_12
X_2236_ _1477_ _1480_ _1485_ _1492_ VGND VGND VPWR VPWR _1493_ sky130_fd_sc_hd__a31o_1
XFILLER_54_813 VPWR VGND VPWR VGND sky130_ef_sc_hd__decap_12
XFILLER_93_470 VGND VGND VPWR VPWR sky130_fd_sc_hd__decap_4
XFILLER_81_610 VGND VGND VPWR VPWR sky130_fd_sc_hd__decap_6
XFILLER_54_835 VPWR VGND VPWR VGND sky130_ef_sc_hd__decap_12
X_2167_ _1412_ _1416_ _1422_ _1423_ VGND VGND VPWR VPWR _1424_ sky130_fd_sc_hd__o2bb2a_1
XFILLER_81_665 VGND VGND VPWR VPWR sky130_fd_sc_hd__decap_6
X_2098_ _0898_ _1356_ VGND VGND VPWR VPWR _1357_ sky130_fd_sc_hd__or2_1
XFILLER_53_345 VGND VGND VPWR VPWR sky130_fd_sc_hd__decap_3
XFILLER_26_559 VPWR VGND VPWR VGND sky130_ef_sc_hd__decap_12
XTAP_TAPCELL_ROW_66_1382 VGND VPWR sky130_fd_sc_hd__tapvpwrvgnd_1
XANTENNA__2473__A a_r1\[0\] VGND VGND VPWR VPWR sky130_fd_sc_hd__diode_2
XTAP_TAPCELL_ROW_24_716 VGND VPWR sky130_fd_sc_hd__tapvpwrvgnd_1
XFILLER_41_529 VPWR VGND VPWR VGND sky130_ef_sc_hd__decap_12
XTAP_TAPCELL_ROW_66_1393 VGND VPWR sky130_fd_sc_hd__tapvpwrvgnd_1
XFILLER_139_417 VPWR VGND VPWR VGND sky130_ef_sc_hd__decap_12
XFILLER_70_29 VPWR VGND VPWR VGND sky130_ef_sc_hd__decap_12
XFILLER_10_905 VGND VGND VPWR VPWR sky130_fd_sc_hd__decap_4
XFILLER_21_253 VPWR VGND VPWR VGND sky130_ef_sc_hd__decap_12
XFILLER_6_909 VGND VGND VPWR VPWR sky130_fd_sc_hd__fill_1
XFILLER_147_461 VPWR VGND VPWR VGND sky130_ef_sc_hd__decap_12
XFILLER_108_837 VPWR VGND VPWR VGND sky130_ef_sc_hd__decap_12
XFILLER_134_133 VGND VGND VPWR VPWR sky130_fd_sc_hd__decap_6
XFILLER_150_637 VGND VGND VPWR VPWR sky130_fd_sc_hd__decap_6
XFILLER_134_177 VPWR VGND VPWR VGND sky130_ef_sc_hd__decap_12
XFILLER_116_881 VPWR VGND VPWR VGND sky130_ef_sc_hd__decap_12
XFILLER_89_721 VGND VGND VPWR VPWR sky130_fd_sc_hd__decap_6
XANTENNA__3217__CLK clknet_3_4__leaf_clk VGND VGND VPWR VPWR sky130_fd_sc_hd__diode_2
XFILLER_135_55 VGND VGND VPWR VPWR sky130_fd_sc_hd__fill_1
XFILLER_115_391 VGND VGND VPWR VPWR sky130_fd_sc_hd__fill_1
XFILLER_103_553 VGND VGND VPWR VPWR sky130_fd_sc_hd__decap_6
XFILLER_89_765 VPWR VGND VPWR VGND sky130_ef_sc_hd__decap_12
XFILLER_0_113 VPWR VGND VPWR VGND sky130_ef_sc_hd__decap_12
XFILLER_131_895 VGND VGND VPWR VPWR sky130_fd_sc_hd__fill_1
XTAP_TAPCELL_ROW_110_2092 VGND VPWR sky130_fd_sc_hd__tapvpwrvgnd_1
XFILLER_103_564 VPWR VGND VPWR VGND sky130_ef_sc_hd__decap_12
XANTENNA__2648__A _0186_ VGND VGND VPWR VPWR sky130_fd_sc_hd__diode_2
XFILLER_95_37 VPWR VGND VPWR VGND sky130_ef_sc_hd__decap_12
XFILLER_88_253 VPWR VGND VPWR VGND sky130_ef_sc_hd__decap_12
XFILLER_48_139 VGND VGND VPWR VPWR sky130_fd_sc_hd__fill_1
XTAP_TAPCELL_ROW_86_1714 VGND VPWR sky130_fd_sc_hd__tapvpwrvgnd_1
XTAP_TAPCELL_ROW_86_1703 VGND VPWR sky130_fd_sc_hd__tapvpwrvgnd_1
XFILLER_63_109 VGND VGND VPWR VPWR sky130_fd_sc_hd__decap_3
XFILLER_57_673 VPWR VGND VPWR VGND sky130_ef_sc_hd__decap_12
XFILLER_28_53 VPWR VGND VPWR VGND sky130_ef_sc_hd__decap_12
XFILLER_29_331 VGND VGND VPWR VPWR sky130_fd_sc_hd__decap_4
XANTENNA__2295__A1 a_r3\[3\] VGND VGND VPWR VPWR sky130_fd_sc_hd__diode_2
XFILLER_28_97 VPWR VGND VPWR VGND sky130_ef_sc_hd__decap_12
XFILLER_44_301 VGND VGND VPWR VPWR sky130_fd_sc_hd__decap_6
XFILLER_72_643 VGND VGND VPWR VPWR sky130_fd_sc_hd__fill_1
XFILLER_60_805 VGND VGND VPWR VPWR sky130_fd_sc_hd__decap_4
XFILLER_17_559 VGND VGND VPWR VPWR sky130_fd_sc_hd__fill_1
XFILLER_44_345 VPWR VGND VPWR VGND sky130_ef_sc_hd__decap_12
XANTENNA__3295__RESET_B net36 VGND VGND VPWR VPWR sky130_fd_sc_hd__diode_2
XFILLER_32_507 VPWR VGND VPWR VGND sky130_ef_sc_hd__decap_12
XFILLER_44_41 VPWR VGND VPWR VGND sky130_ef_sc_hd__decap_12
XANTENNA__3224__RESET_B net36 VGND VGND VPWR VPWR sky130_fd_sc_hd__diode_2
XFILLER_13_721 VGND VGND VPWR VPWR sky130_fd_sc_hd__decap_6
XFILLER_44_85 VPWR VGND VPWR VGND sky130_ef_sc_hd__decap_12
XFILLER_12_253 VGND VGND VPWR VPWR sky130_fd_sc_hd__decap_8
XFILLER_13_765 VPWR VGND VPWR VGND sky130_ef_sc_hd__decap_12
XTAP_TAPCELL_ROW_117_2202 VGND VPWR sky130_fd_sc_hd__tapvpwrvgnd_1
XFILLER_126_601 VPWR VGND VPWR VGND sky130_ef_sc_hd__decap_12
XFILLER_60_73 VGND VGND VPWR VPWR sky130_fd_sc_hd__decap_6
XFILLER_126_645 VPWR VGND VPWR VGND sky130_ef_sc_hd__decap_12
XFILLER_125_111 VGND VGND VPWR VPWR sky130_fd_sc_hd__fill_1
XTAP_TAPCELL_ROW_97_1876 VGND VPWR sky130_fd_sc_hd__tapvpwrvgnd_1
XTAP_TAPCELL_ROW_130_2413 VGND VPWR sky130_fd_sc_hd__tapvpwrvgnd_1
XTAP_TAPCELL_ROW_97_1887 VGND VPWR sky130_fd_sc_hd__tapvpwrvgnd_1
XTAP_TAPCELL_ROW_10_498 VGND VPWR sky130_fd_sc_hd__tapvpwrvgnd_1
XTAP_TAPCELL_ROW_10_487 VGND VPWR sky130_fd_sc_hd__tapvpwrvgnd_1
XFILLER_141_615 VGND VGND VPWR VPWR sky130_fd_sc_hd__fill_1
XFILLER_113_317 VPWR VGND VPWR VGND sky130_ef_sc_hd__decap_12
XFILLER_99_529 VGND VGND VPWR VPWR sky130_fd_sc_hd__decap_6
XFILLER_5_57 VPWR VGND VPWR VGND sky130_ef_sc_hd__decap_12
XFILLER_106_380 VGND VGND VPWR VPWR sky130_fd_sc_hd__fill_1
XFILLER_69_82 VPWR VGND VPWR VGND sky130_ef_sc_hd__decap_12
XFILLER_68_905 VGND VGND VPWR VPWR sky130_fd_sc_hd__decap_4
XFILLER_121_361 VPWR VGND VPWR VGND sky130_ef_sc_hd__decap_12
XFILLER_67_426 VPWR VGND VPWR VGND sky130_ef_sc_hd__decap_12
X_3070_ _0749_ _0750_ VGND VGND VPWR VPWR _0758_ sky130_fd_sc_hd__xnor2_1
XTAP_TAPCELL_ROW_128_2386 VGND VPWR sky130_fd_sc_hd__tapvpwrvgnd_1
XTAP_TAPCELL_ROW_128_2375 VGND VPWR sky130_fd_sc_hd__tapvpwrvgnd_1
XFILLER_94_245 VGND VGND VPWR VPWR sky130_fd_sc_hd__decap_6
XFILLER_82_418 VGND VGND VPWR VPWR sky130_fd_sc_hd__fill_2
X_2021_ _1275_ _1281_ _0901_ VGND VGND VPWR VPWR _1283_ sky130_fd_sc_hd__o21ai_1
XFILLER_54_109 VPWR VGND VPWR VGND sky130_ef_sc_hd__decap_12
XFILLER_94_289 VPWR VGND VPWR VGND sky130_ef_sc_hd__decap_12
XFILLER_85_81 VPWR VGND VPWR VGND sky130_ef_sc_hd__decap_12
XFILLER_48_695 VGND VGND VPWR VPWR sky130_fd_sc_hd__decap_4
XFILLER_36_824 VPWR VGND VPWR VGND sky130_ef_sc_hd__decap_12
XFILLER_47_161 VGND VGND VPWR VPWR sky130_fd_sc_hd__decap_6
XFILLER_90_440 VGND VGND VPWR VPWR sky130_fd_sc_hd__decap_3
XTAP_TAPCELL_ROW_141_2586 VGND VPWR sky130_fd_sc_hd__tapvpwrvgnd_1
XANTENNA__2038__A1 B_reg\[7\] VGND VGND VPWR VPWR sky130_fd_sc_hd__diode_2
XFILLER_62_153 VPWR VGND VPWR VGND sky130_ef_sc_hd__decap_12
XFILLER_23_529 VPWR VGND VPWR VGND sky130_ef_sc_hd__decap_12
XFILLER_35_389 VGND VGND VPWR VPWR sky130_fd_sc_hd__decap_3
XFILLER_16_581 VGND VGND VPWR VPWR sky130_fd_sc_hd__decap_6
X_2923_ _0589_ _0609_ _0610_ _0591_ VGND VGND VPWR VPWR _0611_ sky130_fd_sc_hd__o211a_1
X_2854_ net27 B_reg\[4\] _0383_ VGND VGND VPWR VPWR _0077_ sky130_fd_sc_hd__mux2_1
XFILLER_129_461 VPWR VGND VPWR VGND sky130_ef_sc_hd__decap_12
X_2785_ _0523_ _0524_ VGND VGND VPWR VPWR _0525_ sky130_fd_sc_hd__and2_1
X_1805_ _1072_ _1077_ _1073_ VGND VGND VPWR VPWR _1078_ sky130_fd_sc_hd__o21a_1
X_1736_ A_reg\[13\] _0913_ _1008_ VGND VGND VPWR VPWR _1009_ sky130_fd_sc_hd__o21ba_1
XANTENNA__1637__A A_reg\[15\] VGND VGND VPWR VPWR sky130_fd_sc_hd__diode_2
XFILLER_116_133 VGND VGND VPWR VPWR sky130_fd_sc_hd__decap_6
XFILLER_144_475 VGND VGND VPWR VPWR sky130_fd_sc_hd__fill_1
XFILLER_132_637 VGND VGND VPWR VPWR sky130_fd_sc_hd__decap_6
XFILLER_116_177 VPWR VGND VPWR VGND sky130_ef_sc_hd__decap_12
X_1667_ _0941_ _0942_ _0935_ VGND VGND VPWR VPWR _0943_ sky130_fd_sc_hd__o21ai_1
XTAP_TAPCELL_ROW_148_2707 VGND VPWR sky130_fd_sc_hd__tapvpwrvgnd_1
XFILLER_131_125 VPWR VGND VPWR VGND sky130_ef_sc_hd__decap_12
XFILLER_131_169 VPWR VGND VPWR VGND sky130_ef_sc_hd__decap_12
XANTENNA__2468__A a_r1\[0\] VGND VGND VPWR VPWR sky130_fd_sc_hd__diode_2
XFILLER_140_681 VPWR VGND VPWR VGND sky130_ef_sc_hd__decap_12
XFILLER_113_895 VGND VGND VPWR VPWR sky130_fd_sc_hd__fill_1
XFILLER_100_545 VGND VGND VPWR VPWR sky130_fd_sc_hd__decap_8
XFILLER_86_757 VPWR VGND VPWR VGND sky130_ef_sc_hd__decap_12
XFILLER_86_746 VGND VGND VPWR VPWR sky130_fd_sc_hd__decap_8
XFILLER_85_212 VPWR VGND VPWR VGND sky130_ef_sc_hd__decap_12
XFILLER_105_69 VPWR VGND VPWR VGND sky130_ef_sc_hd__decap_12
X_3268_ clknet_3_6__leaf_clk _0051_ net36 VGND VGND VPWR VPWR net39 sky130_fd_sc_hd__dfrtp_1
XPHY_EDGE_ROW_0_Left_154 VGND VGND VPWR VPWR sky130_fd_sc_hd__decap_3
XFILLER_100_589 VPWR VGND VPWR VGND sky130_ef_sc_hd__decap_12
XFILLER_73_429 VGND VGND VPWR VPWR sky130_fd_sc_hd__decap_6
XTAP_TAPCELL_ROW_68_1422 VGND VPWR sky130_fd_sc_hd__tapvpwrvgnd_1
X_2219_ A_reg\[6\] _1474_ _1463_ VGND VGND VPWR VPWR _1476_ sky130_fd_sc_hd__a21oi_1
X_3199_ _0850_ _0875_ _0912_ VGND VGND VPWR VPWR _0879_ sky130_fd_sc_hd__a21o_1
XFILLER_39_673 VGND VGND VPWR VPWR sky130_fd_sc_hd__decap_8
XFILLER_26_356 VGND VGND VPWR VPWR sky130_fd_sc_hd__decap_8
XFILLER_42_805 VGND VGND VPWR VPWR sky130_fd_sc_hd__fill_1
XFILLER_121_57 VPWR VGND VPWR VGND sky130_ef_sc_hd__decap_12
XFILLER_54_687 VPWR VGND VPWR VGND sky130_ef_sc_hd__decap_12
XFILLER_53_142 VGND VGND VPWR VPWR sky130_fd_sc_hd__decap_8
XFILLER_42_838 VPWR VGND VPWR VGND sky130_ef_sc_hd__decap_12
XTAP_TAPCELL_ROW_81_1633 VGND VPWR sky130_fd_sc_hd__tapvpwrvgnd_1
XTAP_TAPCELL_ROW_81_1622 VGND VPWR sky130_fd_sc_hd__tapvpwrvgnd_1
XFILLER_81_39 VPWR VGND VPWR VGND sky130_ef_sc_hd__decap_12
XFILLER_41_326 VGND VGND VPWR VPWR sky130_fd_sc_hd__decap_8
XFILLER_41_337 VGND VGND VPWR VPWR sky130_fd_sc_hd__decap_4
XFILLER_41_359 VPWR VGND VPWR VGND sky130_ef_sc_hd__decap_12
XFILLER_139_225 VPWR VGND VPWR VGND sky130_ef_sc_hd__decap_12
XFILLER_50_893 VPWR VGND VPWR VGND sky130_ef_sc_hd__decap_12
XFILLER_10_713 VPWR VGND VPWR VGND sky130_ef_sc_hd__decap_12
XFILLER_14_77 VGND VGND VPWR VPWR sky130_fd_sc_hd__decap_6
XFILLER_108_601 VPWR VGND VPWR VGND sky130_ef_sc_hd__decap_12
XFILLER_10_757 VPWR VGND VPWR VGND sky130_ef_sc_hd__decap_12
XFILLER_148_781 VPWR VGND VPWR VGND sky130_ef_sc_hd__decap_12
XFILLER_108_645 VPWR VGND VPWR VGND sky130_ef_sc_hd__decap_12
XFILLER_107_111 VGND VGND VPWR VPWR sky130_fd_sc_hd__fill_1
XFILLER_5_205 VPWR VGND VPWR VGND sky130_ef_sc_hd__decap_12
XTAP_TAPCELL_ROW_112_2121 VGND VPWR sky130_fd_sc_hd__tapvpwrvgnd_1
XTAP_TAPCELL_ROW_79_1595 VGND VPWR sky130_fd_sc_hd__tapvpwrvgnd_1
XFILLER_30_65 VPWR VGND VPWR VGND sky130_ef_sc_hd__decap_12
XFILLER_150_401 VPWR VGND VPWR VGND sky130_ef_sc_hd__decap_12
XFILLER_146_65 VPWR VGND VPWR VGND sky130_ef_sc_hd__decap_12
XFILLER_135_497 VGND VGND VPWR VPWR sky130_fd_sc_hd__decap_6
XFILLER_123_615 VGND VGND VPWR VPWR sky130_fd_sc_hd__fill_1
XFILLER_100_3 VPWR VGND VPWR VGND sky130_ef_sc_hd__decap_12
XFILLER_150_445 VPWR VGND VPWR VGND sky130_ef_sc_hd__decap_12
XANTENNA__1960__B1 B_reg\[4\] VGND VGND VPWR VPWR sky130_fd_sc_hd__diode_2
XFILLER_150_489 VPWR VGND VPWR VGND sky130_ef_sc_hd__decap_12
XFILLER_110_309 VPWR VGND VPWR VGND sky130_ef_sc_hd__decap_12
XFILLER_103_361 VGND VGND VPWR VPWR sky130_fd_sc_hd__decap_6
XFILLER_89_573 VPWR VGND VPWR VGND sky130_ef_sc_hd__decap_12
XFILLER_77_768 VPWR VGND VPWR VGND sky130_ef_sc_hd__decap_12
XFILLER_76_245 VGND VGND VPWR VPWR sky130_fd_sc_hd__decap_6
XANTENNA_input20_A B_in[12] VGND VGND VPWR VPWR sky130_fd_sc_hd__diode_2
XFILLER_92_749 VGND VGND VPWR VPWR sky130_fd_sc_hd__decap_6
XANTENNA__2268__A1 A_reg\[2\] VGND VGND VPWR VPWR sky130_fd_sc_hd__diode_2
XFILLER_18_813 VPWR VGND VPWR VGND sky130_ef_sc_hd__decap_12
XFILLER_29_161 VGND VGND VPWR VPWR sky130_fd_sc_hd__decap_6
XFILLER_36_109 VPWR VGND VPWR VGND sky130_ef_sc_hd__decap_12
XFILLER_91_237 VPWR VGND VPWR VGND sky130_ef_sc_hd__decap_12
XFILLER_60_613 VGND VGND VPWR VPWR sky130_fd_sc_hd__fill_2
XFILLER_44_153 VGND VGND VPWR VPWR sky130_fd_sc_hd__decap_8
XTAP_TAPCELL_ROW_123_2294 VGND VPWR sky130_fd_sc_hd__tapvpwrvgnd_1
XFILLER_60_657 VGND VGND VPWR VPWR sky130_fd_sc_hd__decap_4
XFILLER_60_635 VGND VGND VPWR VPWR sky130_fd_sc_hd__decap_8
XFILLER_44_197 VPWR VGND VPWR VGND sky130_ef_sc_hd__decap_12
XFILLER_60_679 VPWR VGND VPWR VGND sky130_ef_sc_hd__decap_12
XTAP_TAPCELL_ROW_15_568 VGND VPWR sky130_fd_sc_hd__tapvpwrvgnd_1
XTAP_TAPCELL_ROW_99_1916 VGND VPWR sky130_fd_sc_hd__tapvpwrvgnd_1
XFILLER_13_573 VPWR VGND VPWR VGND sky130_ef_sc_hd__decap_12
XTAP_TAPCELL_ROW_15_579 VGND VPWR sky130_fd_sc_hd__tapvpwrvgnd_1
XFILLER_145_217 VGND VGND VPWR VPWR sky130_fd_sc_hd__decap_6
X_2570_ a_r2\[1\] b_r2\[2\] b_r2\[1\] a_r2\[2\] VGND VGND VPWR VPWR _0315_ sky130_fd_sc_hd__a22oi_1
XFILLER_126_475 VGND VGND VPWR VPWR sky130_fd_sc_hd__fill_1
XFILLER_114_637 VGND VGND VPWR VPWR sky130_fd_sc_hd__decap_6
XFILLER_99_315 VPWR VGND VPWR VGND sky130_ef_sc_hd__decap_12
XFILLER_5_783 VGND VGND VPWR VPWR sky130_fd_sc_hd__fill_1
XFILLER_113_125 VPWR VGND VPWR VGND sky130_ef_sc_hd__decap_12
XFILLER_99_337 VPWR VGND VPWR VGND sky130_ef_sc_hd__decap_12
XFILLER_113_169 VPWR VGND VPWR VGND sky130_ef_sc_hd__decap_12
XFILLER_122_681 VPWR VGND VPWR VGND sky130_ef_sc_hd__decap_12
XFILLER_95_543 VPWR VGND VPWR VGND sky130_ef_sc_hd__decap_12
XFILLER_68_757 VPWR VGND VPWR VGND sky130_ef_sc_hd__decap_12
XFILLER_67_223 VGND VGND VPWR VPWR sky130_fd_sc_hd__fill_1
X_3122_ _0808_ _0805_ _0801_ VGND VGND VPWR VPWR _0810_ sky130_fd_sc_hd__and3b_1
XTAP_TAPCELL_ROW_143_2615 VGND VPWR sky130_fd_sc_hd__tapvpwrvgnd_1
XTAP_TAPCELL_ROW_143_2626 VGND VPWR sky130_fd_sc_hd__tapvpwrvgnd_1
XFILLER_95_598 VPWR VGND VPWR VGND sky130_ef_sc_hd__decap_12
XFILLER_83_727 VGND VGND VPWR VPWR sky130_fd_sc_hd__fill_1
XFILLER_55_429 VPWR VGND VPWR VGND sky130_ef_sc_hd__decap_12
X_3053_ _0739_ _0740_ VGND VGND VPWR VPWR _0741_ sky130_fd_sc_hd__or2_1
X_2004_ _0898_ _1255_ _1265_ VGND VGND VPWR VPWR _1266_ sky130_fd_sc_hd__o21a_1
XFILLER_36_643 VGND VGND VPWR VPWR sky130_fd_sc_hd__fill_1
XFILLER_24_805 VGND VGND VPWR VPWR sky130_fd_sc_hd__decap_6
XFILLER_50_123 VPWR VGND VPWR VGND sky130_ef_sc_hd__decap_12
XFILLER_24_849 VPWR VGND VPWR VGND sky130_ef_sc_hd__decap_12
XTAP_TAPCELL_ROW_63_1341 VGND VPWR sky130_fd_sc_hd__tapvpwrvgnd_1
XTAP_TAPCELL_ROW_34_877 VGND VPWR sky130_fd_sc_hd__tapvpwrvgnd_1
X_2906_ _0563_ _0592_ VGND VGND VPWR VPWR _0594_ sky130_fd_sc_hd__xor2_2
XFILLER_50_189 VGND VGND VPWR VPWR sky130_fd_sc_hd__decap_4
XFILLER_137_729 VPWR VGND VPWR VGND sky130_ef_sc_hd__decap_12
X_2837_ net10 A_reg\[3\] _0383_ VGND VGND VPWR VPWR _0060_ sky130_fd_sc_hd__mux2_1
X_2768_ _0502_ _0505_ _0507_ VGND VGND VPWR VPWR _0508_ sky130_fd_sc_hd__a21o_1
XFILLER_3_709 VPWR VGND VPWR VGND sky130_ef_sc_hd__decap_12
XFILLER_132_401 VPWR VGND VPWR VGND sky130_ef_sc_hd__decap_12
X_2699_ a_r3\[0\] b_r3\[3\] b_r3\[2\] a_r3\[1\] VGND VGND VPWR VPWR _0439_ sky130_fd_sc_hd__a22o_1
X_1719_ _0983_ _0994_ VGND VGND VPWR VPWR _0995_ sky130_fd_sc_hd__xnor2_1
XFILLER_132_445 VPWR VGND VPWR VGND sky130_ef_sc_hd__decap_12
XFILLER_117_497 VGND VGND VPWR VPWR sky130_fd_sc_hd__decap_6
XFILLER_132_489 VPWR VGND VPWR VGND sky130_ef_sc_hd__decap_12
XFILLER_101_821 VPWR VGND VPWR VGND sky130_ef_sc_hd__decap_12
XFILLER_76_39 VPWR VGND VPWR VGND sky130_ef_sc_hd__decap_12
XFILLER_101_865 VPWR VGND VPWR VGND sky130_ef_sc_hd__decap_12
XFILLER_58_245 VGND VGND VPWR VPWR sky130_fd_sc_hd__decap_6
XFILLER_86_587 VGND VGND VPWR VPWR sky130_fd_sc_hd__fill_1
XFILLER_18_109 VPWR VGND VPWR VGND sky130_ef_sc_hd__decap_12
XFILLER_73_237 VPWR VGND VPWR VGND sky130_ef_sc_hd__decap_12
XANTENNA__2645__B a_r3\[0\] VGND VGND VPWR VPWR sky130_fd_sc_hd__diode_2
XFILLER_26_153 VPWR VGND VPWR VGND sky130_ef_sc_hd__decap_12
XFILLER_27_665 VGND VGND VPWR VPWR sky130_fd_sc_hd__decap_6
XFILLER_42_613 VPWR VGND VPWR VGND sky130_ef_sc_hd__decap_12
XFILLER_82_793 VPWR VGND VPWR VGND sky130_ef_sc_hd__decap_12
XFILLER_81_281 VPWR VGND VPWR VGND sky130_ef_sc_hd__decap_12
XFILLER_14_337 VPWR VGND VPWR VGND sky130_ef_sc_hd__decap_12
XFILLER_26_197 VPWR VGND VPWR VGND sky130_ef_sc_hd__decap_12
XFILLER_148_3 VPWR VGND VPWR VGND sky130_ef_sc_hd__decap_12
XPHY_EDGE_ROW_54_Left_208 VGND VGND VPWR VPWR sky130_fd_sc_hd__decap_3
XANTENNA__2661__A a_r3\[0\] VGND VGND VPWR VPWR sky130_fd_sc_hd__diode_2
XTAP_TAPCELL_ROW_12_516 VGND VPWR sky130_fd_sc_hd__tapvpwrvgnd_1
XTAP_TAPCELL_ROW_12_527 VGND VPWR sky130_fd_sc_hd__tapvpwrvgnd_1
XFILLER_41_167 VGND VGND VPWR VPWR sky130_fd_sc_hd__fill_1
XFILLER_127_217 VGND VGND VPWR VPWR sky130_fd_sc_hd__decap_6
XFILLER_10_587 VGND VGND VPWR VPWR sky130_fd_sc_hd__fill_1
XFILLER_6_525 VGND VGND VPWR VPWR sky130_fd_sc_hd__decap_6
XFILLER_151_721 VGND VGND VPWR VPWR sky130_fd_sc_hd__decap_6
XFILLER_142_209 VPWR VGND VPWR VGND sky130_ef_sc_hd__decap_12
XFILLER_135_261 VPWR VGND VPWR VGND sky130_ef_sc_hd__decap_12
XTAP_TAPCELL_ROW_94_1835 VGND VPWR sky130_fd_sc_hd__tapvpwrvgnd_1
XFILLER_151_765 VPWR VGND VPWR VGND sky130_ef_sc_hd__decap_12
XFILLER_150_253 VPWR VGND VPWR VGND sky130_ef_sc_hd__decap_12
XFILLER_111_629 VPWR VGND VPWR VGND sky130_ef_sc_hd__decap_12
XFILLER_96_318 VPWR VGND VPWR VGND sky130_ef_sc_hd__decap_12
XPHY_EDGE_ROW_63_Left_217 VGND VGND VPWR VPWR sky130_fd_sc_hd__decap_3
XFILLER_110_139 VGND VGND VPWR VPWR sky130_fd_sc_hd__fill_1
XFILLER_104_681 VPWR VGND VPWR VGND sky130_ef_sc_hd__decap_12
XFILLER_49_223 VGND VGND VPWR VPWR sky130_fd_sc_hd__fill_1
XTAP_TAPCELL_ROW_125_2334 VGND VPWR sky130_fd_sc_hd__tapvpwrvgnd_1
XFILLER_92_502 VPWR VGND VPWR VGND sky130_ef_sc_hd__decap_12
XFILLER_92_546 VPWR VGND VPWR VGND sky130_ef_sc_hd__decap_12
XFILLER_66_83 VGND VGND VPWR VPWR sky130_fd_sc_hd__fill_1
XFILLER_18_643 VGND VGND VPWR VPWR sky130_fd_sc_hd__fill_1
XFILLER_92_579 VGND VGND VPWR VPWR sky130_fd_sc_hd__fill_1
XFILLER_33_613 VGND VGND VPWR VPWR sky130_fd_sc_hd__decap_3
XANTENNA_clkbuf_3_1__f_clk_X clknet_3_1__leaf_clk VGND VGND VPWR VPWR sky130_fd_sc_hd__diode_2
XFILLER_72_270 VPWR VGND VPWR VGND sky130_ef_sc_hd__decap_12
XPHY_EDGE_ROW_72_Left_226 VGND VGND VPWR VPWR sky130_fd_sc_hd__decap_3
XFILLER_60_421 VPWR VGND VPWR VGND sky130_ef_sc_hd__decap_12
XFILLER_45_495 VGND VGND VPWR VPWR sky130_fd_sc_hd__decap_8
XFILLER_82_71 VPWR VGND VPWR VGND sky130_ef_sc_hd__decap_12
XTAP_TAPCELL_ROW_103_1986 VGND VPWR sky130_fd_sc_hd__tapvpwrvgnd_1
XTAP_TAPCELL_ROW_103_1975 VGND VPWR sky130_fd_sc_hd__tapvpwrvgnd_1
XFILLER_14_893 VPWR VGND VPWR VGND sky130_ef_sc_hd__decap_12
XFILLER_20_307 VGND VGND VPWR VPWR sky130_fd_sc_hd__fill_1
XTAP_TAPCELL_ROW_31_825 VGND VPWR sky130_fd_sc_hd__tapvpwrvgnd_1
XFILLER_32_189 VGND VGND VPWR VPWR sky130_fd_sc_hd__decap_6
XFILLER_119_729 VPWR VGND VPWR VGND sky130_ef_sc_hd__decap_12
XFILLER_9_385 VGND VGND VPWR VPWR sky130_fd_sc_hd__decap_6
X_2622_ _0365_ _0366_ VGND VGND VPWR VPWR _0367_ sky130_fd_sc_hd__nand2_1
XFILLER_63_3 VGND VGND VPWR VPWR sky130_fd_sc_hd__decap_8
XFILLER_114_401 VPWR VGND VPWR VGND sky130_ef_sc_hd__decap_12
X_2553_ _0299_ _0300_ VGND VGND VPWR VPWR _0301_ sky130_fd_sc_hd__nand2_1
XFILLER_114_445 VPWR VGND VPWR VGND sky130_ef_sc_hd__decap_12
XPHY_EDGE_ROW_81_Left_235 VGND VGND VPWR VPWR sky130_fd_sc_hd__decap_3
XFILLER_130_905 VGND VGND VPWR VPWR sky130_fd_sc_hd__decap_4
XFILLER_99_167 VGND VGND VPWR VPWR sky130_fd_sc_hd__fill_1
X_2484_ _0885_ _0227_ _0230_ VGND VGND VPWR VPWR _0232_ sky130_fd_sc_hd__a21oi_2
XFILLER_114_489 VPWR VGND VPWR VGND sky130_ef_sc_hd__decap_12
XFILLER_95_373 VPWR VGND VPWR VGND sky130_ef_sc_hd__decap_12
XFILLER_68_587 VGND VGND VPWR VPWR sky130_fd_sc_hd__fill_1
XFILLER_56_749 VGND VGND VPWR VPWR sky130_fd_sc_hd__decap_6
XFILLER_55_215 VGND VGND VPWR VPWR sky130_fd_sc_hd__decap_8
X_3105_ _0792_ VGND VGND VPWR VPWR _0793_ sky130_fd_sc_hd__inv_2
X_3036_ _0621_ _0711_ VGND VGND VPWR VPWR _0724_ sky130_fd_sc_hd__xnor2_1
XFILLER_55_237 VPWR VGND VPWR VGND sky130_ef_sc_hd__decap_12
XANTENNA__1650__A A_reg\[15\] VGND VGND VPWR VPWR sky130_fd_sc_hd__diode_2
XTAP_TAPCELL_ROW_39_958 VGND VPWR sky130_fd_sc_hd__tapvpwrvgnd_1
XFILLER_102_15 VPWR VGND VPWR VGND sky130_ef_sc_hd__decap_12
XPHY_EDGE_ROW_90_Left_244 VGND VGND VPWR VPWR sky130_fd_sc_hd__decap_3
XFILLER_63_281 VPWR VGND VPWR VGND sky130_ef_sc_hd__decap_12
XFILLER_51_410 VPWR VGND VPWR VGND sky130_ef_sc_hd__decap_12
XFILLER_24_613 VPWR VGND VPWR VGND sky130_ef_sc_hd__decap_12
XFILLER_24_657 VPWR VGND VPWR VGND sky130_ef_sc_hd__decap_12
XFILLER_23_167 VGND VGND VPWR VPWR sky130_fd_sc_hd__fill_1
XFILLER_109_217 VGND VGND VPWR VPWR sky130_fd_sc_hd__decap_6
XFILLER_137_559 VGND VGND VPWR VPWR sky130_fd_sc_hd__fill_1
XFILLER_124_209 VPWR VGND VPWR VGND sky130_ef_sc_hd__decap_12
XFILLER_117_261 VPWR VGND VPWR VGND sky130_ef_sc_hd__decap_12
XTAP_TAPCELL_ROW_76_1543 VGND VPWR sky130_fd_sc_hd__tapvpwrvgnd_1
XFILLER_133_721 VGND VGND VPWR VPWR sky130_fd_sc_hd__decap_6
XTAP_TAPCELL_ROW_76_1554 VGND VPWR sky130_fd_sc_hd__tapvpwrvgnd_1
XFILLER_133_765 VPWR VGND VPWR VGND sky130_ef_sc_hd__decap_12
XFILLER_132_253 VPWR VGND VPWR VGND sky130_ef_sc_hd__decap_12
XFILLER_78_307 VGND VGND VPWR VPWR sky130_fd_sc_hd__fill_1
XFILLER_87_841 VPWR VGND VPWR VGND sky130_ef_sc_hd__decap_12
XFILLER_143_55 VGND VGND VPWR VPWR sky130_fd_sc_hd__fill_1
XFILLER_101_673 VPWR VGND VPWR VGND sky130_ef_sc_hd__decap_12
XANTENNA__2656__A b_r3\[3\] VGND VGND VPWR VPWR sky130_fd_sc_hd__diode_2
XFILLER_74_513 VPWR VGND VPWR VGND sky130_ef_sc_hd__decap_12
XFILLER_19_429 VPWR VGND VPWR VGND sky130_ef_sc_hd__decap_12
XPHY_EDGE_ROW_129_Left_283 VGND VGND VPWR VPWR sky130_fd_sc_hd__decap_3
XTAP_TAPCELL_ROW_107_2042 VGND VPWR sky130_fd_sc_hd__tapvpwrvgnd_1
XFILLER_74_557 VPWR VGND VPWR VGND sky130_ef_sc_hd__decap_12
XTAP_TAPCELL_ROW_17_608 VGND VPWR sky130_fd_sc_hd__tapvpwrvgnd_1
XFILLER_36_53 VPWR VGND VPWR VGND sky130_ef_sc_hd__decap_12
XFILLER_55_782 VGND VGND VPWR VPWR sky130_fd_sc_hd__fill_2
XFILLER_27_484 VPWR VGND VPWR VGND sky130_ef_sc_hd__decap_12
XFILLER_36_97 VPWR VGND VPWR VGND sky130_ef_sc_hd__decap_12
XFILLER_42_421 VPWR VGND VPWR VGND sky130_ef_sc_hd__decap_12
XTAP_TAPCELL_ROW_120_2253 VGND VPWR sky130_fd_sc_hd__tapvpwrvgnd_1
XFILLER_52_41 VPWR VGND VPWR VGND sky130_ef_sc_hd__decap_12
XFILLER_14_189 VGND VGND VPWR VPWR sky130_fd_sc_hd__decap_6
XFILLER_52_85 VGND VGND VPWR VPWR sky130_fd_sc_hd__fill_2
XFILLER_52_74 VGND VGND VPWR VPWR sky130_fd_sc_hd__decap_4
XFILLER_11_841 VPWR VGND VPWR VGND sky130_ef_sc_hd__decap_12
XPHY_EDGE_ROW_138_Left_292 VGND VGND VPWR VPWR sky130_fd_sc_hd__decap_3
Xinput28 B_in[5] VGND VGND VPWR VPWR net28 sky130_fd_sc_hd__clkbuf_1
Xinput17 B_in[0] VGND VGND VPWR VPWR net17 sky130_fd_sc_hd__buf_1
XFILLER_10_362 VGND VGND VPWR VPWR sky130_fd_sc_hd__fill_2
XFILLER_6_333 VPWR VGND VPWR VGND sky130_ef_sc_hd__decap_12
XFILLER_143_529 VPWR VGND VPWR VGND sky130_ef_sc_hd__decap_12
XFILLER_7_889 VGND VGND VPWR VPWR sky130_fd_sc_hd__decap_6
XFILLER_6_377 VGND VGND VPWR VPWR sky130_fd_sc_hd__decap_8
XFILLER_136_581 VGND VGND VPWR VPWR sky130_fd_sc_hd__decap_6
XFILLER_112_905 VGND VGND VPWR VPWR sky130_fd_sc_hd__decap_4
XFILLER_151_573 VPWR VGND VPWR VGND sky130_ef_sc_hd__decap_12
XFILLER_93_833 VGND VGND VPWR VPWR sky130_fd_sc_hd__decap_6
XFILLER_92_321 VPWR VGND VPWR VGND sky130_ef_sc_hd__decap_12
XFILLER_65_535 VPWR VGND VPWR VGND sky130_ef_sc_hd__decap_12
XFILLER_37_237 VPWR VGND VPWR VGND sky130_ef_sc_hd__decap_12
XFILLER_38_749 VGND VGND VPWR VPWR sky130_fd_sc_hd__decap_6
XFILLER_93_877 VPWR VGND VPWR VGND sky130_ef_sc_hd__decap_12
XFILLER_53_708 VPWR VGND VPWR VGND sky130_ef_sc_hd__decap_12
XFILLER_18_451 VPWR VGND VPWR VGND sky130_ef_sc_hd__decap_12
XTAP_TAPCELL_ROW_36_906 VGND VPWR sky130_fd_sc_hd__tapvpwrvgnd_1
XFILLER_93_81 VPWR VGND VPWR VGND sky130_ef_sc_hd__decap_12
XFILLER_80_527 VGND VGND VPWR VPWR sky130_fd_sc_hd__decap_4
XANTENNA__2634__A1 _0184_ VGND VGND VPWR VPWR sky130_fd_sc_hd__diode_2
XFILLER_45_270 VGND VGND VPWR VPWR sky130_fd_sc_hd__decap_3
XFILLER_45_281 VPWR VGND VPWR VGND sky130_ef_sc_hd__decap_12
XFILLER_61_741 VPWR VGND VPWR VGND sky130_ef_sc_hd__decap_12
XFILLER_61_785 VPWR VGND VPWR VGND sky130_ef_sc_hd__decap_12
XFILLER_60_273 VGND VGND VPWR VPWR sky130_fd_sc_hd__decap_3
XFILLER_60_251 VGND VGND VPWR VPWR sky130_fd_sc_hd__fill_1
XTAP_TAPCELL_ROW_43_1019 VGND VPWR sky130_fd_sc_hd__tapvpwrvgnd_1
XTAP_TAPCELL_ROW_138_2547 VGND VPWR sky130_fd_sc_hd__tapvpwrvgnd_1
XTAP_TAPCELL_ROW_138_2536 VGND VPWR sky130_fd_sc_hd__tapvpwrvgnd_1
X_1984_ _0911_ _1248_ VGND VGND VPWR VPWR _1249_ sky130_fd_sc_hd__nor2_1
XFILLER_146_301 VGND VGND VPWR VPWR sky130_fd_sc_hd__decap_6
XFILLER_146_345 VPWR VGND VPWR VGND sky130_ef_sc_hd__decap_12
XFILLER_119_559 VGND VGND VPWR VPWR sky130_fd_sc_hd__fill_1
XFILLER_9_193 VPWR VGND VPWR VGND sky130_ef_sc_hd__decap_12
XTAP_TAPCELL_ROW_151_2747 VGND VPWR sky130_fd_sc_hd__tapvpwrvgnd_1
XFILLER_146_389 VPWR VGND VPWR VGND sky130_ef_sc_hd__decap_12
XFILLER_106_209 VPWR VGND VPWR VGND sky130_ef_sc_hd__decap_12
X_2605_ _0330_ _0335_ _0336_ _0187_ VGND VGND VPWR VPWR _0350_ sky130_fd_sc_hd__a31o_1
XFILLER_115_721 VGND VGND VPWR VPWR sky130_fd_sc_hd__decap_6
XTAP_TAPCELL_ROW_58_1262 VGND VPWR sky130_fd_sc_hd__tapvpwrvgnd_1
XFILLER_115_765 VPWR VGND VPWR VGND sky130_ef_sc_hd__decap_12
XFILLER_114_253 VPWR VGND VPWR VGND sky130_ef_sc_hd__decap_12
X_2536_ _0258_ _0283_ VGND VGND VPWR VPWR _0284_ sky130_fd_sc_hd__xor2_1
XFILLER_130_713 VPWR VGND VPWR VGND sky130_ef_sc_hd__decap_12
XFILLER_87_104 VGND VGND VPWR VPWR sky130_fd_sc_hd__decap_8
X_2467_ _0215_ _0212_ _0910_ u_crt.r0\[1\] VGND VGND VPWR VPWR _0028_ sky130_fd_sc_hd__a2bb2o_1
XANTENNA__3250__CLK clknet_3_7__leaf_clk VGND VGND VPWR VPWR sky130_fd_sc_hd__diode_2
XFILLER_130_757 VPWR VGND VPWR VGND sky130_ef_sc_hd__decap_12
XFILLER_87_137 VPWR VGND VPWR VGND sky130_ef_sc_hd__decap_12
XTAP_TAPCELL_ROW_71_1473 VGND VPWR sky130_fd_sc_hd__tapvpwrvgnd_1
XTAP_TAPCELL_ROW_71_1462 VGND VPWR sky130_fd_sc_hd__tapvpwrvgnd_1
XFILLER_69_841 VPWR VGND VPWR VGND sky130_ef_sc_hd__decap_12
X_2398_ _0139_ _0140_ _0142_ VGND VGND VPWR VPWR _0152_ sky130_fd_sc_hd__a21o_1
XFILLER_84_811 VGND VGND VPWR VPWR sky130_fd_sc_hd__fill_1
XFILLER_29_727 VGND VGND VPWR VPWR sky130_fd_sc_hd__fill_1
XFILLER_96_693 VGND VGND VPWR VPWR sky130_fd_sc_hd__decap_6
XFILLER_113_69 VPWR VGND VPWR VGND sky130_ef_sc_hd__decap_12
XFILLER_71_505 VPWR VGND VPWR VGND sky130_ef_sc_hd__decap_12
XFILLER_71_549 VGND VGND VPWR VPWR sky130_fd_sc_hd__fill_1
X_3019_ _0681_ _0682_ VGND VGND VPWR VPWR _0707_ sky130_fd_sc_hd__xnor2_1
XFILLER_24_421 VPWR VGND VPWR VGND sky130_ef_sc_hd__decap_12
XFILLER_52_741 VGND VGND VPWR VPWR sky130_fd_sc_hd__fill_1
XFILLER_52_774 VPWR VGND VPWR VGND sky130_ef_sc_hd__decap_12
XFILLER_12_627 VPWR VGND VPWR VGND sky130_ef_sc_hd__decap_12
XFILLER_11_137 VPWR VGND VPWR VGND sky130_ef_sc_hd__decap_12
XFILLER_149_161 VGND VGND VPWR VPWR sky130_fd_sc_hd__decap_6
XFILLER_138_813 VPWR VGND VPWR VGND sky130_ef_sc_hd__decap_12
XTAP_TAPCELL_ROW_22_677 VGND VPWR sky130_fd_sc_hd__tapvpwrvgnd_1
XFILLER_20_693 VGND VGND VPWR VPWR sky130_fd_sc_hd__decap_6
XTAP_TAPCELL_ROW_22_688 VGND VPWR sky130_fd_sc_hd__tapvpwrvgnd_1
XFILLER_138_77 VGND VGND VPWR VPWR sky130_fd_sc_hd__decap_6
XFILLER_125_529 VPWR VGND VPWR VGND sky130_ef_sc_hd__decap_12
XFILLER_98_15 VPWR VGND VPWR VGND sky130_ef_sc_hd__decap_12
XFILLER_22_77 VGND VGND VPWR VPWR sky130_fd_sc_hd__decap_6
XFILLER_118_581 VGND VGND VPWR VPWR sky130_fd_sc_hd__decap_6
XFILLER_4_837 VPWR VGND VPWR VGND sky130_ef_sc_hd__decap_12
XANTENNA__3249__RESET_B net36 VGND VGND VPWR VPWR sky130_fd_sc_hd__diode_2
XFILLER_133_573 VPWR VGND VPWR VGND sky130_ef_sc_hd__decap_12
XFILLER_79_638 VPWR VGND VPWR VGND sky130_ef_sc_hd__decap_12
XFILLER_120_245 VGND VGND VPWR VPWR sky130_fd_sc_hd__decap_6
XFILLER_120_289 VPWR VGND VPWR VGND sky130_ef_sc_hd__decap_12
XFILLER_59_373 VPWR VGND VPWR VGND sky130_ef_sc_hd__decap_12
XFILLER_47_502 VGND VGND VPWR VPWR sky130_fd_sc_hd__fill_2
XTAP_TAPCELL_ROW_89_1756 VGND VPWR sky130_fd_sc_hd__tapvpwrvgnd_1
XFILLER_75_833 VGND VGND VPWR VPWR sky130_fd_sc_hd__decap_6
XFILLER_74_321 VGND VGND VPWR VPWR sky130_fd_sc_hd__fill_1
XFILLER_19_237 VGND VGND VPWR VPWR sky130_fd_sc_hd__decap_8
XFILLER_90_825 VPWR VGND VPWR VGND sky130_ef_sc_hd__decap_12
XFILLER_75_877 VPWR VGND VPWR VGND sky130_ef_sc_hd__decap_12
XFILLER_28_793 VPWR VGND VPWR VGND sky130_ef_sc_hd__decap_12
XFILLER_90_869 VPWR VGND VPWR VGND sky130_ef_sc_hd__decap_12
XFILLER_15_443 VGND VGND VPWR VPWR sky130_fd_sc_hd__decap_4
XFILLER_27_281 VPWR VGND VPWR VGND sky130_ef_sc_hd__decap_12
XFILLER_43_741 VPWR VGND VPWR VGND sky130_ef_sc_hd__decap_12
XFILLER_42_251 VGND VGND VPWR VPWR sky130_fd_sc_hd__fill_1
XFILLER_43_785 VPWR VGND VPWR VGND sky130_ef_sc_hd__decap_12
XPHY_EDGE_ROW_146_Left_300 VGND VGND VPWR VPWR sky130_fd_sc_hd__decap_3
XTAP_TAPCELL_ROW_100_1934 VGND VPWR sky130_fd_sc_hd__tapvpwrvgnd_1
XFILLER_128_301 VGND VGND VPWR VPWR sky130_fd_sc_hd__decap_6
XFILLER_30_457 VPWR VGND VPWR VGND sky130_ef_sc_hd__decap_12
XTAP_TAPCELL_ROW_41_986 VGND VPWR sky130_fd_sc_hd__tapvpwrvgnd_1
XFILLER_144_805 VGND VGND VPWR VPWR sky130_fd_sc_hd__decap_6
XFILLER_128_345 VPWR VGND VPWR VGND sky130_ef_sc_hd__decap_12
XFILLER_11_671 VGND VGND VPWR VPWR sky130_fd_sc_hd__fill_1
XFILLER_128_389 VPWR VGND VPWR VGND sky130_ef_sc_hd__decap_12
XFILLER_7_653 VPWR VGND VPWR VGND sky130_ef_sc_hd__decap_12
XFILLER_6_141 VPWR VGND VPWR VGND sky130_ef_sc_hd__decap_12
XFILLER_144_849 VPWR VGND VPWR VGND sky130_ef_sc_hd__decap_12
XFILLER_143_337 VPWR VGND VPWR VGND sky130_ef_sc_hd__decap_12
XTAP_TAPCELL_ROW_133_2466 VGND VPWR sky130_fd_sc_hd__tapvpwrvgnd_1
XTAP_TAPCELL_ROW_133_2455 VGND VPWR sky130_fd_sc_hd__tapvpwrvgnd_1
XFILLER_7_697 VPWR VGND VPWR VGND sky130_ef_sc_hd__decap_12
XANTENNA__3273__CLK clknet_3_5__leaf_clk VGND VGND VPWR VPWR sky130_fd_sc_hd__diode_2
XFILLER_152_893 VPWR VGND VPWR VGND sky130_ef_sc_hd__decap_12
XFILLER_112_713 VPWR VGND VPWR VGND sky130_ef_sc_hd__decap_12
X_2321_ _0901_ _1571_ _1572_ VGND VGND VPWR VPWR _1574_ sky130_fd_sc_hd__or3_1
XFILLER_112_757 VPWR VGND VPWR VGND sky130_ef_sc_hd__decap_12
XFILLER_111_223 VGND VGND VPWR VPWR sky130_fd_sc_hd__fill_1
X_2252_ A_reg\[2\] _1508_ VGND VGND VPWR VPWR _1509_ sky130_fd_sc_hd__nand2_1
XFILLER_2_391 VPWR VGND VPWR VGND sky130_ef_sc_hd__decap_12
XTAP_TAPCELL_ROW_53_1181 VGND VPWR sky130_fd_sc_hd__tapvpwrvgnd_1
XFILLER_26_3 VPWR VGND VPWR VGND sky130_ef_sc_hd__decap_12
XANTENNA__2855__A1 B_reg\[5\] VGND VGND VPWR VPWR sky130_fd_sc_hd__diode_2
XFILLER_78_693 VGND VGND VPWR VPWR sky130_fd_sc_hd__decap_6
XFILLER_77_181 VPWR VGND VPWR VGND sky130_ef_sc_hd__decap_12
XFILLER_65_310 VPWR VGND VPWR VGND sky130_ef_sc_hd__decap_12
X_2183_ _1430_ _1436_ _1439_ VGND VGND VPWR VPWR _1440_ sky130_fd_sc_hd__a21o_1
XFILLER_65_343 VGND VGND VPWR VPWR sky130_fd_sc_hd__fill_1
XTAP_TAPCELL_ROW_0_317 VGND VPWR sky130_fd_sc_hd__tapvpwrvgnd_1
XTAP_TAPCELL_ROW_0_328 VGND VPWR sky130_fd_sc_hd__tapvpwrvgnd_1
XFILLER_38_557 VPWR VGND VPWR VGND sky130_ef_sc_hd__decap_12
XFILLER_93_685 VPWR VGND VPWR VGND sky130_ef_sc_hd__decap_12
XFILLER_92_173 VPWR VGND VPWR VGND sky130_ef_sc_hd__decap_12
XTAP_TAPCELL_ROW_0_339 VGND VPWR sky130_fd_sc_hd__tapvpwrvgnd_1
XFILLER_80_357 VGND VGND VPWR VPWR sky130_fd_sc_hd__decap_6
XANTENNA__2743__B _0187_ VGND VGND VPWR VPWR sky130_fd_sc_hd__diode_2
XFILLER_21_446 VGND VGND VPWR VPWR sky130_fd_sc_hd__fill_2
XFILLER_138_109 VPWR VGND VPWR VGND sky130_ef_sc_hd__decap_12
X_1967_ _1231_ VGND VGND VPWR VPWR _1232_ sky130_fd_sc_hd__inv_2
XFILLER_147_665 VGND VGND VPWR VPWR sky130_fd_sc_hd__decap_6
XFILLER_146_153 VPWR VGND VPWR VGND sky130_ef_sc_hd__decap_12
XFILLER_107_529 VGND VGND VPWR VPWR sky130_fd_sc_hd__fill_1
X_1898_ _1163_ _1165_ net37 _1161_ VGND VGND VPWR VPWR _0008_ sky130_fd_sc_hd__a211oi_1
XFILLER_146_197 VPWR VGND VPWR VGND sky130_ef_sc_hd__decap_12
XTAP_TAPCELL_ROW_73_1502 VGND VPWR sky130_fd_sc_hd__tapvpwrvgnd_1
XFILLER_115_573 VPWR VGND VPWR VGND sky130_ef_sc_hd__decap_12
X_2519_ _0222_ _0238_ _0262_ VGND VGND VPWR VPWR _0267_ sky130_fd_sc_hd__or3b_1
XFILLER_102_245 VGND VGND VPWR VPWR sky130_fd_sc_hd__decap_6
XFILLER_88_457 VPWR VGND VPWR VGND sky130_ef_sc_hd__decap_12
XFILLER_130_587 VGND VGND VPWR VPWR sky130_fd_sc_hd__fill_1
XFILLER_102_289 VPWR VGND VPWR VGND sky130_ef_sc_hd__decap_12
XFILLER_57_833 VGND VGND VPWR VPWR sky130_fd_sc_hd__fill_1
XFILLER_56_321 VPWR VGND VPWR VGND sky130_ef_sc_hd__decap_12
XTAP_TAPCELL_ROW_104_2001 VGND VPWR sky130_fd_sc_hd__tapvpwrvgnd_1
XFILLER_57_877 VPWR VGND VPWR VGND sky130_ef_sc_hd__decap_12
XFILLER_56_365 VGND VGND VPWR VPWR sky130_fd_sc_hd__fill_1
XFILLER_29_579 VPWR VGND VPWR VGND sky130_ef_sc_hd__decap_12
XFILLER_83_173 VGND VGND VPWR VPWR sky130_fd_sc_hd__fill_1
XFILLER_72_825 VPWR VGND VPWR VGND sky130_ef_sc_hd__decap_12
XFILLER_56_387 VGND VGND VPWR VPWR sky130_fd_sc_hd__fill_1
XFILLER_17_55 VGND VGND VPWR VPWR sky130_fd_sc_hd__fill_1
XFILLER_72_869 VPWR VGND VPWR VGND sky130_ef_sc_hd__decap_12
XFILLER_71_335 VGND VGND VPWR VPWR sky130_fd_sc_hd__fill_1
XFILLER_25_741 VPWR VGND VPWR VGND sky130_ef_sc_hd__decap_12
XTAP_TAPCELL_ROW_27_758 VGND VPWR sky130_fd_sc_hd__tapvpwrvgnd_1
XTAP_TAPCELL_ROW_27_769 VGND VPWR sky130_fd_sc_hd__tapvpwrvgnd_1
XTAP_TAPCELL_ROW_84_1675 VGND VPWR sky130_fd_sc_hd__tapvpwrvgnd_1
XFILLER_24_251 VGND VGND VPWR VPWR sky130_fd_sc_hd__fill_1
XFILLER_25_785 VPWR VGND VPWR VGND sky130_ef_sc_hd__decap_12
XFILLER_52_582 VGND VGND VPWR VPWR sky130_fd_sc_hd__decap_6
XFILLER_12_413 VGND VGND VPWR VPWR sky130_fd_sc_hd__decap_6
XFILLER_130_3 VPWR VGND VPWR VGND sky130_ef_sc_hd__decap_12
XANTENNA__2940__Y _0628_ VGND VGND VPWR VPWR sky130_fd_sc_hd__diode_2
XFILLER_8_417 VGND VGND VPWR VPWR sky130_fd_sc_hd__decap_3
XFILLER_138_643 VGND VGND VPWR VPWR sky130_fd_sc_hd__fill_1
XANTENNA__3296__CLK clknet_3_2__leaf_clk VGND VGND VPWR VPWR sky130_fd_sc_hd__diode_2
XFILLER_153_613 VGND VGND VPWR VPWR sky130_fd_sc_hd__decap_3
XFILLER_126_805 VGND VGND VPWR VPWR sky130_fd_sc_hd__decap_6
XFILLER_126_849 VPWR VGND VPWR VGND sky130_ef_sc_hd__decap_12
XFILLER_125_337 VPWR VGND VPWR VGND sky130_ef_sc_hd__decap_12
XFILLER_3_111 VGND VGND VPWR VPWR sky130_fd_sc_hd__fill_1
XFILLER_153_657 VPWR VGND VPWR VGND sky130_ef_sc_hd__decap_12
XFILLER_140_307 VGND VGND VPWR VPWR sky130_fd_sc_hd__fill_1
XTAP_TAPCELL_ROW_115_2174 VGND VPWR sky130_fd_sc_hd__tapvpwrvgnd_1
XFILLER_152_189 VGND VGND VPWR VPWR sky130_fd_sc_hd__decap_6
XFILLER_134_893 VPWR VGND VPWR VGND sky130_ef_sc_hd__decap_12
XFILLER_79_424 VPWR VGND VPWR VGND sky130_ef_sc_hd__decap_12
XFILLER_4_678 VPWR VGND VPWR VGND sky130_ef_sc_hd__decap_12
XTAP_TAPCELL_ROW_7_450 VGND VPWR sky130_fd_sc_hd__tapvpwrvgnd_1
XFILLER_94_416 VGND VGND VPWR VPWR sky130_fd_sc_hd__decap_4
XFILLER_94_438 VPWR VGND VPWR VGND sky130_ef_sc_hd__decap_12
XFILLER_66_129 VGND VGND VPWR VPWR sky130_fd_sc_hd__decap_8
XANTENNA__2837__A1 A_reg\[3\] VGND VGND VPWR VPWR sky130_fd_sc_hd__diode_2
XFILLER_48_844 VPWR VGND VPWR VGND sky130_ef_sc_hd__decap_12
XFILLER_75_641 VPWR VGND VPWR VGND sky130_ef_sc_hd__decap_12
XFILLER_48_877 VGND VGND VPWR VPWR sky130_fd_sc_hd__decap_3
XFILLER_35_505 VPWR VGND VPWR VGND sky130_ef_sc_hd__decap_12
XFILLER_47_365 VPWR VGND VPWR VGND sky130_ef_sc_hd__decap_12
XFILLER_75_685 VPWR VGND VPWR VGND sky130_ef_sc_hd__decap_12
XFILLER_62_335 VPWR VGND VPWR VGND sky130_ef_sc_hd__decap_12
XFILLER_90_699 VGND VGND VPWR VPWR sky130_fd_sc_hd__fill_1
XFILLER_15_262 VPWR VGND VPWR VGND sky130_ef_sc_hd__decap_12
X_2870_ u_crt.r1\[1\] _0556_ _0555_ VGND VGND VPWR VPWR _0558_ sky130_fd_sc_hd__a21oi_2
XFILLER_31_777 VGND VGND VPWR VPWR sky130_fd_sc_hd__decap_6
X_1821_ A_reg\[2\] _1091_ VGND VGND VPWR VPWR _1094_ sky130_fd_sc_hd__xnor2_1
XFILLER_30_265 VPWR VGND VPWR VGND sky130_ef_sc_hd__decap_12
XFILLER_144_613 VPWR VGND VPWR VGND sky130_ef_sc_hd__decap_12
XFILLER_129_665 VGND VGND VPWR VPWR sky130_fd_sc_hd__decap_6
XFILLER_128_153 VPWR VGND VPWR VGND sky130_ef_sc_hd__decap_12
X_1752_ _1015_ _1018_ VGND VGND VPWR VPWR _1025_ sky130_fd_sc_hd__and2b_1
XFILLER_128_197 VPWR VGND VPWR VGND sky130_ef_sc_hd__decap_12
X_1683_ _0891_ _0950_ _0953_ _0955_ VGND VGND VPWR VPWR _0959_ sky130_fd_sc_hd__a2bb2o_1
XFILLER_144_657 VPWR VGND VPWR VGND sky130_ef_sc_hd__decap_12
XTAP_TAPCELL_ROW_55_1210 VGND VPWR sky130_fd_sc_hd__tapvpwrvgnd_1
XFILLER_143_167 VGND VGND VPWR VPWR sky130_fd_sc_hd__fill_1
XFILLER_131_329 VGND VGND VPWR VPWR sky130_fd_sc_hd__decap_6
XFILLER_98_755 VGND VGND VPWR VPWR sky130_fd_sc_hd__fill_1
XTAP_TAPCELL_ROW_5_409 VGND VPWR sky130_fd_sc_hd__tapvpwrvgnd_1
XFILLER_112_587 VGND VGND VPWR VPWR sky130_fd_sc_hd__fill_1
XFILLER_97_276 VGND VGND VPWR VPWR sky130_fd_sc_hd__decap_4
XFILLER_85_405 VPWR VGND VPWR VGND sky130_ef_sc_hd__decap_12
X_2304_ _1550_ _1553_ _1556_ VGND VGND VPWR VPWR _1557_ sky130_fd_sc_hd__a21o_1
X_3284_ clknet_3_5__leaf_clk _0067_ net36 VGND VGND VPWR VPWR A_reg\[10\] sky130_fd_sc_hd__dfrtp_4
XTAP_TAPCELL_ROW_146_2668 VGND VPWR sky130_fd_sc_hd__tapvpwrvgnd_1
XFILLER_100_749 VGND VGND VPWR VPWR sky130_fd_sc_hd__decap_6
XFILLER_85_449 VPWR VGND VPWR VGND sky130_ef_sc_hd__decap_12
X_2235_ _1480_ _1486_ _1477_ VGND VGND VPWR VPWR _1492_ sky130_fd_sc_hd__a21oi_1
XFILLER_38_321 VPWR VGND VPWR VGND sky130_ef_sc_hd__decap_12
X_2166_ A_reg\[13\] A_reg\[11\] _1410_ VGND VGND VPWR VPWR _1423_ sky130_fd_sc_hd__and3_1
XFILLER_54_847 VGND VGND VPWR VPWR sky130_fd_sc_hd__decap_4
XFILLER_54_825 VGND VGND VPWR VPWR sky130_fd_sc_hd__decap_3
XFILLER_38_365 VPWR VGND VPWR VGND sky130_ef_sc_hd__decap_12
XFILLER_54_869 VGND VGND VPWR VPWR sky130_fd_sc_hd__decap_8
X_2097_ _1170_ _1355_ _1255_ VGND VGND VPWR VPWR _1356_ sky130_fd_sc_hd__o21a_1
XFILLER_53_335 VGND VGND VPWR VPWR sky130_fd_sc_hd__fill_1
XFILLER_110_15 VPWR VGND VPWR VGND sky130_ef_sc_hd__decap_12
XFILLER_80_176 VPWR VGND VPWR VGND sky130_ef_sc_hd__decap_12
XANTENNA__2473__B _0185_ VGND VGND VPWR VPWR sky130_fd_sc_hd__diode_2
XTAP_TAPCELL_ROW_24_717 VGND VPWR sky130_fd_sc_hd__tapvpwrvgnd_1
XTAP_TAPCELL_ROW_66_1394 VGND VPWR sky130_fd_sc_hd__tapvpwrvgnd_1
XTAP_TAPCELL_ROW_66_1383 VGND VPWR sky130_fd_sc_hd__tapvpwrvgnd_1
XFILLER_139_429 VPWR VGND VPWR VGND sky130_ef_sc_hd__decap_12
XPHY_EDGE_ROW_3_Right_3 VGND VGND VPWR VPWR sky130_fd_sc_hd__decap_3
XFILLER_22_755 VGND VGND VPWR VPWR sky130_fd_sc_hd__fill_1
X_2999_ _0685_ _0686_ VGND VGND VPWR VPWR _0687_ sky130_fd_sc_hd__or2_1
XFILLER_21_265 VPWR VGND VPWR VGND sky130_ef_sc_hd__decap_12
XFILLER_108_805 VGND VGND VPWR VPWR sky130_fd_sc_hd__decap_6
XFILLER_147_473 VPWR VGND VPWR VGND sky130_ef_sc_hd__decap_12
XFILLER_119_57 VPWR VGND VPWR VGND sky130_ef_sc_hd__decap_12
XFILLER_108_849 VPWR VGND VPWR VGND sky130_ef_sc_hd__decap_12
XFILLER_107_337 VPWR VGND VPWR VGND sky130_ef_sc_hd__decap_12
XFILLER_134_189 VGND VGND VPWR VPWR sky130_fd_sc_hd__decap_6
XFILLER_122_307 VGND VGND VPWR VPWR sky130_fd_sc_hd__fill_1
XFILLER_116_893 VPWR VGND VPWR VGND sky130_ef_sc_hd__decap_12
XFILLER_1_615 VGND VGND VPWR VPWR sky130_fd_sc_hd__fill_1
XFILLER_131_841 VPWR VGND VPWR VGND sky130_ef_sc_hd__decap_12
XFILLER_88_232 VGND VGND VPWR VPWR sky130_fd_sc_hd__fill_2
XFILLER_0_125 VPWR VGND VPWR VGND sky130_ef_sc_hd__decap_12
XTAP_TAPCELL_ROW_110_2093 VGND VPWR sky130_fd_sc_hd__tapvpwrvgnd_1
XFILLER_103_576 VPWR VGND VPWR VGND sky130_ef_sc_hd__decap_12
XFILLER_89_777 VGND VGND VPWR VPWR sky130_fd_sc_hd__decap_6
XFILLER_88_265 VPWR VGND VPWR VGND sky130_ef_sc_hd__decap_12
XFILLER_0_169 VPWR VGND VPWR VGND sky130_ef_sc_hd__decap_12
XFILLER_95_49 VGND VGND VPWR VPWR sky130_fd_sc_hd__decap_6
XFILLER_92_909 VGND VGND VPWR VPWR sky130_fd_sc_hd__fill_1
XTAP_TAPCELL_ROW_86_1704 VGND VPWR sky130_fd_sc_hd__tapvpwrvgnd_1
XFILLER_57_641 VPWR VGND VPWR VGND sky130_ef_sc_hd__decap_12
XFILLER_28_65 VPWR VGND VPWR VGND sky130_ef_sc_hd__decap_12
XFILLER_151_55 VGND VGND VPWR VPWR sky130_fd_sc_hd__fill_1
XTAP_TAPCELL_ROW_86_1715 VGND VPWR sky130_fd_sc_hd__tapvpwrvgnd_1
XANTENNA__2295__A2 _0911_ VGND VGND VPWR VPWR sky130_fd_sc_hd__diode_2
XFILLER_57_685 VPWR VGND VPWR VGND sky130_ef_sc_hd__decap_12
XFILLER_17_505 VPWR VGND VPWR VGND sky130_ef_sc_hd__decap_12
XFILLER_56_195 VGND VGND VPWR VPWR sky130_fd_sc_hd__fill_1
XFILLER_44_357 VGND VGND VPWR VPWR sky130_fd_sc_hd__decap_6
XFILLER_72_699 VGND VGND VPWR VPWR sky130_fd_sc_hd__fill_1
XFILLER_32_519 VPWR VGND VPWR VGND sky130_ef_sc_hd__decap_12
XFILLER_44_53 VPWR VGND VPWR VGND sky130_ef_sc_hd__decap_12
XFILLER_44_368 VGND VGND VPWR VPWR sky130_fd_sc_hd__fill_1
XFILLER_12_221 VPWR VGND VPWR VGND sky130_ef_sc_hd__decap_12
XFILLER_13_777 VGND VGND VPWR VPWR sky130_fd_sc_hd__decap_6
XFILLER_44_97 VPWR VGND VPWR VGND sky130_ef_sc_hd__decap_12
XTAP_TAPCELL_ROW_117_2203 VGND VPWR sky130_fd_sc_hd__tapvpwrvgnd_1
XFILLER_60_41 VGND VGND VPWR VPWR sky130_fd_sc_hd__decap_4
XANTENNA__3264__RESET_B net36 VGND VGND VPWR VPWR sky130_fd_sc_hd__diode_2
XFILLER_153_421 VPWR VGND VPWR VGND sky130_ef_sc_hd__decap_12
XFILLER_126_613 VPWR VGND VPWR VGND sky130_ef_sc_hd__decap_12
XTAP_TAPCELL_ROW_97_1877 VGND VPWR sky130_fd_sc_hd__tapvpwrvgnd_1
XFILLER_60_85 VPWR VGND VPWR VGND sky130_ef_sc_hd__decap_12
XTAP_TAPCELL_ROW_130_2414 VGND VPWR sky130_fd_sc_hd__tapvpwrvgnd_1
XFILLER_126_657 VPWR VGND VPWR VGND sky130_ef_sc_hd__decap_12
XTAP_TAPCELL_ROW_97_1888 VGND VPWR sky130_fd_sc_hd__tapvpwrvgnd_1
XTAP_TAPCELL_ROW_10_499 VGND VPWR sky130_fd_sc_hd__tapvpwrvgnd_1
XTAP_TAPCELL_ROW_10_488 VGND VPWR sky130_fd_sc_hd__tapvpwrvgnd_1
XFILLER_125_167 VGND VGND VPWR VPWR sky130_fd_sc_hd__fill_1
XFILLER_113_329 VGND VGND VPWR VPWR sky130_fd_sc_hd__decap_6
XFILLER_5_69 VPWR VGND VPWR VGND sky130_ef_sc_hd__decap_12
XFILLER_4_475 VGND VGND VPWR VPWR sky130_fd_sc_hd__fill_1
XFILLER_79_232 VGND VGND VPWR VPWR sky130_fd_sc_hd__decap_8
XFILLER_79_221 VGND VGND VPWR VPWR sky130_fd_sc_hd__decap_3
XFILLER_69_94 VPWR VGND VPWR VGND sky130_ef_sc_hd__decap_12
XFILLER_67_405 VPWR VGND VPWR VGND sky130_ef_sc_hd__decap_12
XANTENNA__3311__CLK clknet_3_7__leaf_clk VGND VGND VPWR VPWR sky130_fd_sc_hd__diode_2
XFILLER_121_373 VPWR VGND VPWR VGND sky130_ef_sc_hd__decap_12
XFILLER_67_449 VPWR VGND VPWR VGND sky130_ef_sc_hd__decap_12
XFILLER_67_438 VGND VGND VPWR VPWR sky130_fd_sc_hd__decap_8
XTAP_TAPCELL_ROW_128_2387 VGND VPWR sky130_fd_sc_hd__tapvpwrvgnd_1
XTAP_TAPCELL_ROW_128_2376 VGND VPWR sky130_fd_sc_hd__tapvpwrvgnd_1
XFILLER_83_909 VGND VGND VPWR VPWR sky130_fd_sc_hd__fill_1
X_2020_ _1275_ _1281_ _0901_ VGND VGND VPWR VPWR _1282_ sky130_fd_sc_hd__o21a_1
XFILLER_48_641 VGND VGND VPWR VPWR sky130_fd_sc_hd__decap_3
XFILLER_85_93 VPWR VGND VPWR VGND sky130_ef_sc_hd__decap_12
XFILLER_36_836 VPWR VGND VPWR VGND sky130_ef_sc_hd__decap_12
XFILLER_62_121 VGND VGND VPWR VPWR sky130_fd_sc_hd__fill_2
XFILLER_36_869 VPWR VGND VPWR VGND sky130_ef_sc_hd__decap_12
XTAP_TAPCELL_ROW_141_2587 VGND VPWR sky130_fd_sc_hd__tapvpwrvgnd_1
XFILLER_62_165 VPWR VGND VPWR VGND sky130_ef_sc_hd__decap_12
XFILLER_51_839 VGND VGND VPWR VPWR sky130_fd_sc_hd__fill_1
XFILLER_35_357 VPWR VGND VPWR VGND sky130_ef_sc_hd__decap_12
X_2922_ _0589_ _0609_ VGND VGND VPWR VPWR _0610_ sky130_fd_sc_hd__nand2_1
XFILLER_149_727 VGND VGND VPWR VPWR sky130_fd_sc_hd__fill_1
XFILLER_93_3 VPWR VGND VPWR VGND sky130_ef_sc_hd__decap_12
XFILLER_43_390 VGND VGND VPWR VPWR sky130_fd_sc_hd__fill_2
X_2853_ net26 B_reg\[3\] _0383_ VGND VGND VPWR VPWR _0076_ sky130_fd_sc_hd__mux2_1
X_2784_ _0436_ _0519_ VGND VGND VPWR VPWR _0524_ sky130_fd_sc_hd__or2_1
X_1804_ A_reg\[4\] _1071_ _1076_ VGND VGND VPWR VPWR _1077_ sky130_fd_sc_hd__o21ba_1
XFILLER_144_421 VPWR VGND VPWR VGND sky130_ef_sc_hd__decap_12
XFILLER_129_473 VPWR VGND VPWR VGND sky130_ef_sc_hd__decap_12
XFILLER_8_781 VPWR VGND VPWR VGND sky130_ef_sc_hd__decap_12
X_1735_ A_reg\[15\] A_reg\[13\] VGND VGND VPWR VPWR _1008_ sky130_fd_sc_hd__and2b_1
XFILLER_116_189 VGND VGND VPWR VPWR sky130_fd_sc_hd__decap_6
XFILLER_104_307 VGND VGND VPWR VPWR sky130_fd_sc_hd__fill_1
X_1666_ _0932_ _0935_ _0936_ _0934_ _0889_ VGND VGND VPWR VPWR _0942_ sky130_fd_sc_hd__a311oi_1
XFILLER_131_137 VPWR VGND VPWR VGND sky130_ef_sc_hd__decap_12
XFILLER_113_841 VPWR VGND VPWR VGND sky130_ef_sc_hd__decap_12
XANTENNA__2050__A1_N B_reg\[5\] VGND VGND VPWR VPWR sky130_fd_sc_hd__diode_2
XFILLER_58_416 VGND VGND VPWR VPWR sky130_fd_sc_hd__fill_2
XANTENNA__2468__B b_r1\[0\] VGND VGND VPWR VPWR sky130_fd_sc_hd__diode_2
XFILLER_140_693 VGND VGND VPWR VPWR sky130_fd_sc_hd__decap_6
XFILLER_86_769 VPWR VGND VPWR VGND sky130_ef_sc_hd__decap_12
XFILLER_85_257 VPWR VGND VPWR VGND sky130_ef_sc_hd__decap_12
XFILLER_74_909 VGND VGND VPWR VPWR sky130_fd_sc_hd__fill_1
X_3267_ clknet_3_7__leaf_clk _0050_ net36 VGND VGND VPWR VPWR net53 sky130_fd_sc_hd__dfrtp_1
XFILLER_39_641 VPWR VGND VPWR VGND sky130_ef_sc_hd__decap_12
XTAP_TAPCELL_ROW_68_1423 VGND VPWR sky130_fd_sc_hd__tapvpwrvgnd_1
XTAP_TAPCELL_ROW_68_1412 VGND VPWR sky130_fd_sc_hd__tapvpwrvgnd_1
XFILLER_26_313 VGND VGND VPWR VPWR sky130_fd_sc_hd__fill_1
X_2218_ A_reg\[6\] _1463_ _1474_ VGND VGND VPWR VPWR _1475_ sky130_fd_sc_hd__and3_1
X_3198_ _0850_ _0875_ VGND VGND VPWR VPWR _0878_ sky130_fd_sc_hd__nor2_1
X_2149_ B_reg\[0\] _1401_ _1402_ _1403_ VGND VGND VPWR VPWR _1407_ sky130_fd_sc_hd__a31o_1
XFILLER_38_195 VGND VGND VPWR VPWR sky130_fd_sc_hd__fill_1
XFILLER_121_69 VPWR VGND VPWR VGND sky130_ef_sc_hd__decap_12
XFILLER_53_154 VGND VGND VPWR VPWR sky130_fd_sc_hd__decap_3
XTAP_TAPCELL_ROW_81_1634 VGND VPWR sky130_fd_sc_hd__tapvpwrvgnd_1
XTAP_TAPCELL_ROW_81_1623 VGND VPWR sky130_fd_sc_hd__tapvpwrvgnd_1
XFILLER_54_699 VGND VGND VPWR VPWR sky130_fd_sc_hd__fill_1
XFILLER_53_176 VGND VGND VPWR VPWR sky130_fd_sc_hd__fill_1
XFILLER_50_861 VGND VGND VPWR VPWR sky130_fd_sc_hd__decap_6
XFILLER_139_237 VPWR VGND VPWR VGND sky130_ef_sc_hd__decap_12
XFILLER_10_725 VPWR VGND VPWR VGND sky130_ef_sc_hd__decap_12
XPHY_EDGE_ROW_101_Left_255 VGND VGND VPWR VPWR sky130_fd_sc_hd__decap_3
XFILLER_10_769 VPWR VGND VPWR VGND sky130_ef_sc_hd__decap_12
XANTENNA__1828__A A_reg\[1\] VGND VGND VPWR VPWR sky130_fd_sc_hd__diode_2
XFILLER_148_793 VPWR VGND VPWR VGND sky130_ef_sc_hd__decap_12
XFILLER_147_281 VPWR VGND VPWR VGND sky130_ef_sc_hd__decap_12
XFILLER_108_613 VPWR VGND VPWR VGND sky130_ef_sc_hd__decap_12
XFILLER_5_217 VGND VGND VPWR VPWR sky130_fd_sc_hd__decap_6
XFILLER_108_657 VPWR VGND VPWR VGND sky130_ef_sc_hd__decap_12
XTAP_TAPCELL_ROW_79_1596 VGND VPWR sky130_fd_sc_hd__tapvpwrvgnd_1
XFILLER_150_413 VGND VGND VPWR VPWR sky130_fd_sc_hd__decap_6
XTAP_TAPCELL_ROW_112_2122 VGND VPWR sky130_fd_sc_hd__tapvpwrvgnd_1
XFILLER_107_167 VGND VGND VPWR VPWR sky130_fd_sc_hd__fill_1
XFILLER_30_77 VGND VGND VPWR VPWR sky130_fd_sc_hd__decap_6
XFILLER_150_457 VPWR VGND VPWR VGND sky130_ef_sc_hd__decap_12
XFILLER_146_77 VGND VGND VPWR VPWR sky130_fd_sc_hd__decap_6
XTAP_TAPCELL_ROW_92_1796 VGND VPWR sky130_fd_sc_hd__tapvpwrvgnd_1
XFILLER_131_671 VGND VGND VPWR VPWR sky130_fd_sc_hd__fill_1
XFILLER_89_585 VPWR VGND VPWR VGND sky130_ef_sc_hd__decap_12
XFILLER_77_747 VGND VGND VPWR VPWR sky130_fd_sc_hd__fill_1
XFILLER_49_449 VPWR VGND VPWR VGND sky130_ef_sc_hd__decap_12
XPHY_EDGE_ROW_110_Left_264 VGND VGND VPWR VPWR sky130_fd_sc_hd__decap_3
XFILLER_65_909 VGND VGND VPWR VPWR sky130_fd_sc_hd__fill_1
XFILLER_64_419 VGND VGND VPWR VPWR sky130_fd_sc_hd__fill_1
XFILLER_18_825 VPWR VGND VPWR VGND sky130_ef_sc_hd__decap_12
XFILLER_45_611 VGND VGND VPWR VPWR sky130_fd_sc_hd__decap_4
XFILLER_91_249 VPWR VGND VPWR VGND sky130_ef_sc_hd__decap_12
XFILLER_18_869 VPWR VGND VPWR VGND sky130_ef_sc_hd__decap_12
XFILLER_44_121 VPWR VGND VPWR VGND sky130_ef_sc_hd__decap_12
XANTENNA_input13_A A_in[6] VGND VGND VPWR VPWR sky130_fd_sc_hd__diode_2
XFILLER_72_474 VGND VGND VPWR VPWR sky130_fd_sc_hd__fill_2
XTAP_TAPCELL_ROW_123_2295 VGND VPWR sky130_fd_sc_hd__tapvpwrvgnd_1
XFILLER_33_839 VGND VGND VPWR VPWR sky130_fd_sc_hd__fill_1
XFILLER_44_176 VPWR VGND VPWR VGND sky130_ef_sc_hd__decap_12
XFILLER_45_699 VPWR VGND VPWR VGND sky130_ef_sc_hd__decap_12
XFILLER_13_541 VPWR VGND VPWR VGND sky130_ef_sc_hd__decap_12
XTAP_TAPCELL_ROW_15_569 VGND VPWR sky130_fd_sc_hd__tapvpwrvgnd_1
XTAP_TAPCELL_ROW_99_1917 VGND VPWR sky130_fd_sc_hd__tapvpwrvgnd_1
XFILLER_71_51 VGND VGND VPWR VPWR sky130_fd_sc_hd__decap_4
XFILLER_13_585 VPWR VGND VPWR VGND sky130_ef_sc_hd__decap_12
XFILLER_41_894 VGND VGND VPWR VPWR sky130_fd_sc_hd__fill_2
XANTENNA__1738__A A_reg\[13\] VGND VGND VPWR VPWR sky130_fd_sc_hd__diode_2
XFILLER_126_421 VPWR VGND VPWR VGND sky130_ef_sc_hd__decap_12
XFILLER_99_327 VGND VGND VPWR VPWR sky130_fd_sc_hd__decap_8
XFILLER_113_137 VPWR VGND VPWR VGND sky130_ef_sc_hd__decap_12
XFILLER_99_349 VPWR VGND VPWR VGND sky130_ef_sc_hd__decap_12
XFILLER_122_693 VGND VGND VPWR VPWR sky130_fd_sc_hd__decap_6
XFILLER_110_811 VGND VGND VPWR VPWR sky130_fd_sc_hd__fill_1
X_3121_ _0808_ VGND VGND VPWR VPWR _0809_ sky130_fd_sc_hd__inv_2
XTAP_TAPCELL_ROW_143_2616 VGND VPWR sky130_fd_sc_hd__tapvpwrvgnd_1
XFILLER_121_181 VPWR VGND VPWR VGND sky130_ef_sc_hd__decap_12
XFILLER_95_555 VGND VGND VPWR VPWR sky130_fd_sc_hd__decap_4
XFILLER_68_769 VPWR VGND VPWR VGND sky130_ef_sc_hd__decap_12
XTAP_TAPCELL_ROW_143_2627 VGND VPWR sky130_fd_sc_hd__tapvpwrvgnd_1
XFILLER_67_279 VGND VGND VPWR VPWR sky130_fd_sc_hd__fill_1
X_3052_ _0725_ _0726_ VGND VGND VPWR VPWR _0740_ sky130_fd_sc_hd__xnor2_1
X_2003_ _1256_ _1258_ VGND VGND VPWR VPWR _1265_ sky130_fd_sc_hd__nand2b_1
XANTENNA__2508__S _0187_ VGND VGND VPWR VPWR sky130_fd_sc_hd__diode_2
XFILLER_91_783 VGND VGND VPWR VPWR sky130_fd_sc_hd__fill_1
XFILLER_63_474 VGND VGND VPWR VPWR sky130_fd_sc_hd__fill_2
XFILLER_90_271 VPWR VGND VPWR VGND sky130_ef_sc_hd__decap_12
XFILLER_63_485 VGND VGND VPWR VPWR sky130_fd_sc_hd__decap_8
XFILLER_36_699 VGND VGND VPWR VPWR sky130_fd_sc_hd__fill_1
XTAP_TAPCELL_ROW_63_1342 VGND VPWR sky130_fd_sc_hd__tapvpwrvgnd_1
XFILLER_50_135 VGND VGND VPWR VPWR sky130_fd_sc_hd__decap_4
X_2905_ _0563_ _0592_ VGND VGND VPWR VPWR _0593_ sky130_fd_sc_hd__or2_1
XTAP_TAPCELL_ROW_34_878 VGND VPWR sky130_fd_sc_hd__tapvpwrvgnd_1
X_2836_ net9 A_reg\[2\] _0383_ VGND VGND VPWR VPWR _0059_ sky130_fd_sc_hd__mux2_1
XANTENNA__1648__A A_reg\[13\] VGND VGND VPWR VPWR sky130_fd_sc_hd__diode_2
XFILLER_31_393 VPWR VGND VPWR VGND sky130_ef_sc_hd__decap_12
XFILLER_145_741 VPWR VGND VPWR VGND sky130_ef_sc_hd__decap_12
XFILLER_129_281 VPWR VGND VPWR VGND sky130_ef_sc_hd__decap_12
X_2767_ _0483_ _0498_ VGND VGND VPWR VPWR _0507_ sky130_fd_sc_hd__nand2_1
XFILLER_145_785 VPWR VGND VPWR VGND sky130_ef_sc_hd__decap_12
XFILLER_144_251 VGND VGND VPWR VPWR sky130_fd_sc_hd__fill_1
XFILLER_132_413 VGND VGND VPWR VPWR sky130_fd_sc_hd__decap_6
X_2698_ a_r3\[0\] a_r3\[1\] b_r3\[3\] b_r3\[2\] VGND VGND VPWR VPWR _0438_ sky130_fd_sc_hd__and4_1
X_1718_ A_reg\[1\] _0989_ _0992_ _0988_ VGND VGND VPWR VPWR _0994_ sky130_fd_sc_hd__a31o_1
XFILLER_2_209 VPWR VGND VPWR VGND sky130_ef_sc_hd__decap_12
XANTENNA__2479__A a_r1\[0\] VGND VGND VPWR VPWR sky130_fd_sc_hd__diode_2
X_1649_ A_reg\[13\] A_reg\[12\] VGND VGND VPWR VPWR _0925_ sky130_fd_sc_hd__and2_1
XFILLER_132_457 VPWR VGND VPWR VGND sky130_ef_sc_hd__decap_12
XFILLER_113_671 VGND VGND VPWR VPWR sky130_fd_sc_hd__fill_1
XFILLER_101_833 VGND VGND VPWR VPWR sky130_fd_sc_hd__decap_6
XFILLER_86_533 VPWR VGND VPWR VGND sky130_ef_sc_hd__decap_12
XANTENNA_input5_A A_in[13] VGND VGND VPWR VPWR sky130_fd_sc_hd__diode_2
XFILLER_101_877 VPWR VGND VPWR VGND sky130_ef_sc_hd__decap_12
XFILLER_100_321 VPWR VGND VPWR VGND sky130_ef_sc_hd__decap_12
XFILLER_59_758 VPWR VGND VPWR VGND sky130_ef_sc_hd__decap_12
XFILLER_47_909 VGND VGND VPWR VPWR sky130_fd_sc_hd__fill_1
X_3319_ clknet_3_5__leaf_clk _0102_ net36 VGND VGND VPWR VPWR X_crt\[13\] sky130_fd_sc_hd__dfrtp_1
XFILLER_100_387 VPWR VGND VPWR VGND sky130_ef_sc_hd__decap_12
XFILLER_100_365 VGND VGND VPWR VPWR sky130_fd_sc_hd__fill_1
XFILLER_46_419 VGND VGND VPWR VPWR sky130_fd_sc_hd__fill_1
XFILLER_73_249 VPWR VGND VPWR VGND sky130_ef_sc_hd__decap_12
XFILLER_26_121 VPWR VGND VPWR VGND sky130_ef_sc_hd__decap_12
XFILLER_15_839 VGND VGND VPWR VPWR sky130_fd_sc_hd__fill_1
XFILLER_26_165 VPWR VGND VPWR VGND sky130_ef_sc_hd__decap_12
XFILLER_41_113 VPWR VGND VPWR VGND sky130_ef_sc_hd__decap_12
XFILLER_42_625 VGND VGND VPWR VPWR sky130_fd_sc_hd__decap_4
XFILLER_81_293 VPWR VGND VPWR VGND sky130_ef_sc_hd__decap_12
XFILLER_14_349 VPWR VGND VPWR VGND sky130_ef_sc_hd__decap_12
XFILLER_25_55 VGND VGND VPWR VPWR sky130_fd_sc_hd__fill_1
XANTENNA__2661__B a_r3\[1\] VGND VGND VPWR VPWR sky130_fd_sc_hd__diode_2
XTAP_TAPCELL_ROW_12_517 VGND VPWR sky130_fd_sc_hd__tapvpwrvgnd_1
XFILLER_10_533 VPWR VGND VPWR VGND sky130_ef_sc_hd__decap_12
XTAP_TAPCELL_ROW_12_528 VGND VPWR sky130_fd_sc_hd__tapvpwrvgnd_1
XFILLER_108_454 VPWR VGND VPWR VGND sky130_ef_sc_hd__decap_12
XTAP_TAPCELL_ROW_94_1836 VGND VPWR sky130_fd_sc_hd__tapvpwrvgnd_1
XFILLER_150_221 VPWR VGND VPWR VGND sky130_ef_sc_hd__decap_12
XFILLER_135_273 VGND VGND VPWR VPWR sky130_fd_sc_hd__decap_6
XFILLER_97_809 VPWR VGND VPWR VGND sky130_ef_sc_hd__decap_12
XFILLER_151_777 VGND VGND VPWR VPWR sky130_fd_sc_hd__decap_6
XFILLER_150_265 VPWR VGND VPWR VGND sky130_ef_sc_hd__decap_12
XFILLER_104_693 VGND VGND VPWR VPWR sky130_fd_sc_hd__decap_6
XFILLER_2_15 VPWR VGND VPWR VGND sky130_ef_sc_hd__decap_12
XFILLER_103_181 VPWR VGND VPWR VGND sky130_ef_sc_hd__decap_12
XANTENNA__3281__Q A_reg\[7\] VGND VGND VPWR VPWR sky130_fd_sc_hd__diode_2
XTAP_TAPCELL_ROW_125_2335 VGND VPWR sky130_fd_sc_hd__tapvpwrvgnd_1
XTAP_TAPCELL_ROW_125_2324 VGND VPWR sky130_fd_sc_hd__tapvpwrvgnd_1
XFILLER_92_514 VPWR VGND VPWR VGND sky130_ef_sc_hd__decap_12
XFILLER_66_51 VPWR VGND VPWR VGND sky130_ef_sc_hd__decap_12
XFILLER_65_717 VGND VGND VPWR VPWR sky130_fd_sc_hd__decap_8
XFILLER_49_279 VGND VGND VPWR VPWR sky130_fd_sc_hd__fill_1
XFILLER_92_558 VGND VGND VPWR VPWR sky130_fd_sc_hd__decap_4
XFILLER_64_249 VGND VGND VPWR VPWR sky130_fd_sc_hd__decap_3
XFILLER_73_783 VGND VGND VPWR VPWR sky130_fd_sc_hd__fill_1
XFILLER_72_282 VPWR VGND VPWR VGND sky130_ef_sc_hd__decap_12
XFILLER_18_699 VGND VGND VPWR VPWR sky130_fd_sc_hd__fill_1
XFILLER_82_83 VGND VGND VPWR VPWR sky130_fd_sc_hd__fill_1
XFILLER_60_433 VPWR VGND VPWR VGND sky130_ef_sc_hd__decap_12
XFILLER_21_809 VPWR VGND VPWR VGND sky130_ef_sc_hd__decap_12
XTAP_TAPCELL_ROW_103_1987 VGND VPWR sky130_fd_sc_hd__tapvpwrvgnd_1
XTAP_TAPCELL_ROW_103_1976 VGND VPWR sky130_fd_sc_hd__tapvpwrvgnd_1
XFILLER_60_477 VPWR VGND VPWR VGND sky130_ef_sc_hd__decap_12
XFILLER_14_861 VGND VGND VPWR VPWR sky130_fd_sc_hd__decap_6
XTAP_TAPCELL_ROW_31_826 VGND VPWR sky130_fd_sc_hd__tapvpwrvgnd_1
XTAP_TAPCELL_ROW_45_1050 VGND VPWR sky130_fd_sc_hd__tapvpwrvgnd_1
XFILLER_13_393 VPWR VGND VPWR VGND sky130_ef_sc_hd__decap_12
XFILLER_127_741 VPWR VGND VPWR VGND sky130_ef_sc_hd__decap_12
X_2621_ _0326_ _0353_ _0364_ VGND VGND VPWR VPWR _0366_ sky130_fd_sc_hd__a21o_1
XANTENNA__2177__A1 A_reg\[10\] VGND VGND VPWR VPWR sky130_fd_sc_hd__diode_2
XFILLER_127_785 VPWR VGND VPWR VGND sky130_ef_sc_hd__decap_12
XFILLER_126_251 VGND VGND VPWR VPWR sky130_fd_sc_hd__fill_1
X_2552_ _0220_ _0296_ _0297_ VGND VGND VPWR VPWR _0300_ sky130_fd_sc_hd__nand3_1
XFILLER_114_413 VGND VGND VPWR VPWR sky130_fd_sc_hd__decap_6
XFILLER_99_113 VPWR VGND VPWR VGND sky130_ef_sc_hd__decap_12
XFILLER_142_755 VGND VGND VPWR VPWR sky130_fd_sc_hd__fill_1
XFILLER_114_457 VPWR VGND VPWR VGND sky130_ef_sc_hd__decap_12
X_2483_ _0187_ _0229_ _0230_ _0226_ VGND VGND VPWR VPWR _0231_ sky130_fd_sc_hd__o31a_1
XFILLER_68_533 VPWR VGND VPWR VGND sky130_ef_sc_hd__decap_12
XFILLER_29_909 VGND VGND VPWR VPWR sky130_fd_sc_hd__fill_1
XFILLER_95_385 VGND VGND VPWR VPWR sky130_fd_sc_hd__decap_6
X_3104_ _0757_ _0758_ VGND VGND VPWR VPWR _0792_ sky130_fd_sc_hd__xnor2_1
XFILLER_55_249 VGND VGND VPWR VPWR sky130_fd_sc_hd__decap_8
X_3035_ _0622_ _0722_ VGND VGND VPWR VPWR _0723_ sky130_fd_sc_hd__or2_1
XANTENNA__1650__B A_reg\[13\] VGND VGND VPWR VPWR sky130_fd_sc_hd__diode_2
XTAP_TAPCELL_ROW_39_948 VGND VPWR sky130_fd_sc_hd__tapvpwrvgnd_1
XTAP_TAPCELL_ROW_39_959 VGND VPWR sky130_fd_sc_hd__tapvpwrvgnd_1
XFILLER_102_27 VGND VGND VPWR VPWR sky130_fd_sc_hd__fill_1
XFILLER_71_709 VPWR VGND VPWR VGND sky130_ef_sc_hd__decap_12
XFILLER_63_271 VGND VGND VPWR VPWR sky130_fd_sc_hd__decap_8
XFILLER_51_422 VPWR VGND VPWR VGND sky130_ef_sc_hd__decap_12
XFILLER_23_113 VPWR VGND VPWR VGND sky130_ef_sc_hd__decap_12
XFILLER_24_625 VPWR VGND VPWR VGND sky130_ef_sc_hd__decap_12
XFILLER_63_293 VGND VGND VPWR VPWR sky130_fd_sc_hd__fill_2
XFILLER_24_669 VPWR VGND VPWR VGND sky130_ef_sc_hd__decap_12
XFILLER_137_505 VPWR VGND VPWR VGND sky130_ef_sc_hd__decap_12
X_2819_ net45 X_crt\[1\] _0553_ VGND VGND VPWR VPWR _0042_ sky130_fd_sc_hd__mux2_1
XFILLER_11_57 VPWR VGND VPWR VGND sky130_ef_sc_hd__decap_12
XANTENNA__2168__B2 A_reg\[10\] VGND VGND VPWR VPWR sky130_fd_sc_hd__diode_2
XFILLER_132_221 VPWR VGND VPWR VGND sky130_ef_sc_hd__decap_12
XFILLER_127_57 VPWR VGND VPWR VGND sky130_ef_sc_hd__decap_12
XFILLER_117_273 VGND VGND VPWR VPWR sky130_fd_sc_hd__decap_6
XTAP_TAPCELL_ROW_76_1555 VGND VPWR sky130_fd_sc_hd__tapvpwrvgnd_1
XTAP_TAPCELL_ROW_76_1544 VGND VPWR sky130_fd_sc_hd__tapvpwrvgnd_1
XFILLER_133_777 VGND VGND VPWR VPWR sky130_fd_sc_hd__decap_6
XFILLER_79_809 VPWR VGND VPWR VGND sky130_ef_sc_hd__decap_12
XFILLER_132_265 VPWR VGND VPWR VGND sky130_ef_sc_hd__decap_12
XFILLER_101_641 VPWR VGND VPWR VGND sky130_ef_sc_hd__decap_12
XFILLER_87_853 VPWR VGND VPWR VGND sky130_ef_sc_hd__decap_12
XANTENNA_input8_X net8 VGND VGND VPWR VPWR sky130_fd_sc_hd__diode_2
XFILLER_101_685 VPWR VGND VPWR VGND sky130_ef_sc_hd__decap_12
XFILLER_87_897 VPWR VGND VPWR VGND sky130_ef_sc_hd__decap_12
XFILLER_86_363 VGND VGND VPWR VPWR sky130_fd_sc_hd__fill_1
XTAP_TAPCELL_ROW_107_2043 VGND VPWR sky130_fd_sc_hd__tapvpwrvgnd_1
XFILLER_100_195 VGND VGND VPWR VPWR sky130_fd_sc_hd__fill_1
XFILLER_74_525 VGND VGND VPWR VPWR sky130_fd_sc_hd__decap_6
XFILLER_74_569 VPWR VGND VPWR VGND sky130_ef_sc_hd__decap_12
XTAP_TAPCELL_ROW_17_609 VGND VPWR sky130_fd_sc_hd__tapvpwrvgnd_1
XANTENNA__1987__S Encode_EN VGND VGND VPWR VPWR sky130_fd_sc_hd__diode_2
XFILLER_27_496 VGND VGND VPWR VPWR sky130_fd_sc_hd__decap_8
XFILLER_36_65 VPWR VGND VPWR VGND sky130_ef_sc_hd__decap_12
XFILLER_42_411 VGND VGND VPWR VPWR sky130_fd_sc_hd__decap_8
XTAP_TAPCELL_ROW_120_2254 VGND VPWR sky130_fd_sc_hd__tapvpwrvgnd_1
XANTENNA__2672__A a_r3\[1\] VGND VGND VPWR VPWR sky130_fd_sc_hd__diode_2
XFILLER_42_433 VPWR VGND VPWR VGND sky130_ef_sc_hd__decap_12
XFILLER_42_477 VPWR VGND VPWR VGND sky130_ef_sc_hd__decap_12
XFILLER_52_53 VPWR VGND VPWR VGND sky130_ef_sc_hd__decap_12
Xinput18 B_in[10] VGND VGND VPWR VPWR net18 sky130_fd_sc_hd__clkbuf_1
XFILLER_10_341 VGND VGND VPWR VPWR sky130_fd_sc_hd__fill_2
XFILLER_11_853 VPWR VGND VPWR VGND sky130_ef_sc_hd__decap_12
XFILLER_109_741 VPWR VGND VPWR VGND sky130_ef_sc_hd__decap_12
Xinput29 B_in[6] VGND VGND VPWR VPWR net29 sky130_fd_sc_hd__clkbuf_1
XANTENNA__3276__Q A_reg\[2\] VGND VGND VPWR VPWR sky130_fd_sc_hd__diode_2
XFILLER_11_897 VPWR VGND VPWR VGND sky130_ef_sc_hd__decap_12
XFILLER_109_785 VPWR VGND VPWR VGND sky130_ef_sc_hd__decap_12
XFILLER_108_251 VGND VGND VPWR VPWR sky130_fd_sc_hd__fill_1
XFILLER_6_345 VPWR VGND VPWR VGND sky130_ef_sc_hd__decap_12
XANTENNA__1735__B A_reg\[13\] VGND VGND VPWR VPWR sky130_fd_sc_hd__diode_2
XFILLER_151_541 VPWR VGND VPWR VGND sky130_ef_sc_hd__decap_12
XFILLER_124_755 VGND VGND VPWR VPWR sky130_fd_sc_hd__fill_1
XFILLER_97_617 VPWR VGND VPWR VGND sky130_ef_sc_hd__decap_12
XFILLER_151_585 VPWR VGND VPWR VGND sky130_ef_sc_hd__decap_12
XFILLER_111_405 VPWR VGND VPWR VGND sky130_ef_sc_hd__decap_12
XFILLER_111_449 VPWR VGND VPWR VGND sky130_ef_sc_hd__decap_12
XFILLER_77_374 VPWR VGND VPWR VGND sky130_ef_sc_hd__decap_12
XFILLER_37_205 VPWR VGND VPWR VGND sky130_ef_sc_hd__decap_12
XFILLER_92_333 VGND VGND VPWR VPWR sky130_fd_sc_hd__decap_6
XFILLER_65_547 VPWR VGND VPWR VGND sky130_ef_sc_hd__decap_12
XFILLER_93_889 VGND VGND VPWR VPWR sky130_fd_sc_hd__decap_6
XTAP_TAPCELL_ROW_36_907 VGND VPWR sky130_fd_sc_hd__tapvpwrvgnd_1
XFILLER_37_249 VGND VGND VPWR VPWR sky130_fd_sc_hd__decap_8
XFILLER_93_93 VPWR VGND VPWR VGND sky130_ef_sc_hd__decap_12
XFILLER_18_463 VPWR VGND VPWR VGND sky130_ef_sc_hd__decap_12
XFILLER_61_753 VPWR VGND VPWR VGND sky130_ef_sc_hd__decap_12
XFILLER_45_293 VPWR VGND VPWR VGND sky130_ef_sc_hd__decap_12
XFILLER_61_797 VPWR VGND VPWR VGND sky130_ef_sc_hd__decap_12
XFILLER_21_617 VPWR VGND VPWR VGND sky130_ef_sc_hd__decap_12
XTAP_TAPCELL_ROW_138_2537 VGND VPWR sky130_fd_sc_hd__tapvpwrvgnd_1
X_1983_ B_reg\[0\] _1240_ _1247_ VGND VGND VPWR VPWR _1248_ sky130_fd_sc_hd__and3_1
XFILLER_119_505 VPWR VGND VPWR VGND sky130_ef_sc_hd__decap_12
XFILLER_9_161 VGND VGND VPWR VPWR sky130_fd_sc_hd__decap_6
XTAP_TAPCELL_ROW_151_2748 VGND VPWR sky130_fd_sc_hd__tapvpwrvgnd_1
XFILLER_146_357 VGND VGND VPWR VPWR sky130_fd_sc_hd__decap_6
X_2604_ _0330_ _0336_ _0335_ VGND VGND VPWR VPWR _0349_ sky130_fd_sc_hd__a21oi_1
XTAP_TAPCELL_ROW_58_1252 VGND VPWR sky130_fd_sc_hd__tapvpwrvgnd_1
XFILLER_115_777 VGND VGND VPWR VPWR sky130_fd_sc_hd__decap_6
XFILLER_114_221 VPWR VGND VPWR VGND sky130_ef_sc_hd__decap_12
XTAP_TAPCELL_ROW_58_1263 VGND VPWR sky130_fd_sc_hd__tapvpwrvgnd_1
X_2535_ _0281_ _0282_ VGND VGND VPWR VPWR _0283_ sky130_fd_sc_hd__nand2_1
XPHY_EDGE_ROW_143_Right_143 VGND VGND VPWR VPWR sky130_fd_sc_hd__decap_3
XFILLER_130_725 VPWR VGND VPWR VGND sky130_ef_sc_hd__decap_12
XFILLER_114_265 VPWR VGND VPWR VGND sky130_ef_sc_hd__decap_12
X_2466_ _0191_ _0213_ _0211_ VGND VGND VPWR VPWR _0215_ sky130_fd_sc_hd__a21boi_1
XFILLER_130_769 VPWR VGND VPWR VGND sky130_ef_sc_hd__decap_12
XFILLER_87_149 VPWR VGND VPWR VGND sky130_ef_sc_hd__decap_12
XTAP_TAPCELL_ROW_71_1463 VGND VPWR sky130_fd_sc_hd__tapvpwrvgnd_1
XFILLER_69_853 VPWR VGND VPWR VGND sky130_ef_sc_hd__decap_12
X_2397_ _0146_ _0147_ _0150_ VGND VGND VPWR VPWR _0151_ sky130_fd_sc_hd__a21o_1
XTAP_TAPCELL_ROW_71_1474 VGND VPWR sky130_fd_sc_hd__tapvpwrvgnd_1
XFILLER_69_897 VPWR VGND VPWR VGND sky130_ef_sc_hd__decap_12
XFILLER_68_363 VGND VGND VPWR VPWR sky130_fd_sc_hd__fill_1
XFILLER_113_15 VPWR VGND VPWR VGND sky130_ef_sc_hd__decap_12
XFILLER_84_867 VGND VGND VPWR VPWR sky130_fd_sc_hd__fill_1
X_3018_ _0700_ _0703_ _0705_ VGND VGND VPWR VPWR _0706_ sky130_fd_sc_hd__a21bo_1
XFILLER_71_517 VPWR VGND VPWR VGND sky130_ef_sc_hd__decap_12
XFILLER_37_783 VGND VGND VPWR VPWR sky130_fd_sc_hd__fill_1
XFILLER_24_433 VPWR VGND VPWR VGND sky130_ef_sc_hd__decap_12
XFILLER_40_904 VGND VGND VPWR VPWR sky130_fd_sc_hd__decap_3
XFILLER_52_786 VPWR VGND VPWR VGND sky130_ef_sc_hd__decap_12
XFILLER_11_105 VGND VGND VPWR VPWR sky130_fd_sc_hd__decap_6
XFILLER_24_477 VPWR VGND VPWR VGND sky130_ef_sc_hd__decap_12
XFILLER_12_639 VGND VGND VPWR VPWR sky130_fd_sc_hd__decap_4
XFILLER_138_825 VPWR VGND VPWR VGND sky130_ef_sc_hd__decap_12
XFILLER_11_149 VPWR VGND VPWR VGND sky130_ef_sc_hd__decap_12
XFILLER_138_869 VPWR VGND VPWR VGND sky130_ef_sc_hd__decap_12
XFILLER_137_335 VGND VGND VPWR VPWR sky130_fd_sc_hd__fill_1
XTAP_TAPCELL_ROW_22_678 VGND VPWR sky130_fd_sc_hd__tapvpwrvgnd_1
XTAP_TAPCELL_ROW_22_689 VGND VPWR sky130_fd_sc_hd__tapvpwrvgnd_1
XFILLER_4_805 VGND VGND VPWR VPWR sky130_fd_sc_hd__decap_6
XFILLER_98_27 VGND VGND VPWR VPWR sky130_fd_sc_hd__fill_1
XFILLER_4_849 VPWR VGND VPWR VGND sky130_ef_sc_hd__decap_12
XFILLER_133_541 VPWR VGND VPWR VGND sky130_ef_sc_hd__decap_12
XFILLER_106_755 VGND VGND VPWR VPWR sky130_fd_sc_hd__fill_1
XFILLER_79_606 VGND VGND VPWR VPWR sky130_fd_sc_hd__decap_8
XFILLER_3_337 VGND VGND VPWR VPWR sky130_fd_sc_hd__decap_3
XFILLER_133_585 VPWR VGND VPWR VGND sky130_ef_sc_hd__decap_12
XFILLER_79_617 VGND VGND VPWR VPWR sky130_fd_sc_hd__decap_6
XPHY_EDGE_ROW_110_Right_110 VGND VGND VPWR VPWR sky130_fd_sc_hd__decap_3
XANTENNA__2667__A OpSel_reg\[0\] VGND VGND VPWR VPWR sky130_fd_sc_hd__diode_2
XANTENNA__3289__RESET_B net36 VGND VGND VPWR VPWR sky130_fd_sc_hd__diode_2
XANTENNA__3218__RESET_B net36 VGND VGND VPWR VPWR sky130_fd_sc_hd__diode_2
XFILLER_19_205 VPWR VGND VPWR VGND sky130_ef_sc_hd__decap_12
XTAP_TAPCELL_ROW_89_1757 VGND VPWR sky130_fd_sc_hd__tapvpwrvgnd_1
XFILLER_59_385 VGND VGND VPWR VPWR sky130_fd_sc_hd__fill_1
XFILLER_75_889 VGND VGND VPWR VPWR sky130_fd_sc_hd__decap_6
XFILLER_35_709 VPWR VGND VPWR VGND sky130_ef_sc_hd__decap_12
XFILLER_90_837 VPWR VGND VPWR VGND sky130_ef_sc_hd__decap_12
XFILLER_74_377 VGND VGND VPWR VPWR sky130_fd_sc_hd__decap_3
XTAP_TAPCELL_ROW_2_370 VGND VPWR sky130_fd_sc_hd__tapvpwrvgnd_1
XFILLER_103_81 VPWR VGND VPWR VGND sky130_ef_sc_hd__decap_12
XFILLER_63_41 VPWR VGND VPWR VGND sky130_ef_sc_hd__decap_12
XFILLER_27_293 VPWR VGND VPWR VGND sky130_ef_sc_hd__decap_12
XFILLER_43_753 VPWR VGND VPWR VGND sky130_ef_sc_hd__decap_12
XFILLER_70_550 VGND VGND VPWR VPWR sky130_fd_sc_hd__decap_8
XFILLER_63_85 VPWR VGND VPWR VGND sky130_ef_sc_hd__decap_12
XTAP_TAPCELL_ROW_100_1935 VGND VPWR sky130_fd_sc_hd__tapvpwrvgnd_1
XTAP_TAPCELL_ROW_100_1924 VGND VPWR sky130_fd_sc_hd__tapvpwrvgnd_1
XFILLER_70_583 VGND VGND VPWR VPWR sky130_fd_sc_hd__decap_4
XFILLER_43_797 VPWR VGND VPWR VGND sky130_ef_sc_hd__decap_12
XFILLER_30_469 VGND VGND VPWR VPWR sky130_fd_sc_hd__decap_6
XTAP_TAPCELL_ROW_41_987 VGND VPWR sky130_fd_sc_hd__tapvpwrvgnd_1
XFILLER_143_305 VPWR VGND VPWR VGND sky130_ef_sc_hd__decap_12
XFILLER_128_357 VGND VGND VPWR VPWR sky130_fd_sc_hd__decap_6
XFILLER_7_665 VGND VGND VPWR VPWR sky130_fd_sc_hd__decap_6
XFILLER_6_153 VPWR VGND VPWR VGND sky130_ef_sc_hd__decap_12
XTAP_TAPCELL_ROW_133_2467 VGND VPWR sky130_fd_sc_hd__tapvpwrvgnd_1
XTAP_TAPCELL_ROW_133_2456 VGND VPWR sky130_fd_sc_hd__tapvpwrvgnd_1
XFILLER_152_861 VGND VGND VPWR VPWR sky130_fd_sc_hd__decap_6
XFILLER_143_349 VPWR VGND VPWR VGND sky130_ef_sc_hd__decap_12
XFILLER_6_197 VPWR VGND VPWR VGND sky130_ef_sc_hd__decap_12
XFILLER_112_725 VPWR VGND VPWR VGND sky130_ef_sc_hd__decap_12
X_2320_ _1571_ _1572_ VGND VGND VPWR VPWR _1573_ sky130_fd_sc_hd__nor2_1
XFILLER_151_393 VPWR VGND VPWR VGND sky130_ef_sc_hd__decap_12
XFILLER_112_769 VPWR VGND VPWR VGND sky130_ef_sc_hd__decap_12
XFILLER_100_909 VGND VGND VPWR VPWR sky130_fd_sc_hd__fill_1
X_2251_ A_reg\[3\] _1507_ VGND VGND VPWR VPWR _1508_ sky130_fd_sc_hd__xnor2_1
XFILLER_111_279 VGND VGND VPWR VPWR sky130_fd_sc_hd__fill_1
XFILLER_84_108 VPWR VGND VPWR VGND sky130_ef_sc_hd__decap_12
XFILLER_66_801 VGND VGND VPWR VPWR sky130_fd_sc_hd__decap_8
XTAP_TAPCELL_ROW_53_1182 VGND VPWR sky130_fd_sc_hd__tapvpwrvgnd_1
XFILLER_65_322 VPWR VGND VPWR VGND sky130_ef_sc_hd__decap_12
X_2182_ _1424_ _1425_ _1438_ VGND VGND VPWR VPWR _1439_ sky130_fd_sc_hd__a21oi_1
XFILLER_19_3 VPWR VGND VPWR VGND sky130_ef_sc_hd__decap_12
XFILLER_92_141 VPWR VGND VPWR VGND sky130_ef_sc_hd__decap_12
XFILLER_77_193 VPWR VGND VPWR VGND sky130_ef_sc_hd__decap_12
XFILLER_66_867 VGND VGND VPWR VPWR sky130_fd_sc_hd__fill_1
XTAP_TAPCELL_ROW_0_318 VGND VPWR sky130_fd_sc_hd__tapvpwrvgnd_1
XFILLER_38_569 VPWR VGND VPWR VGND sky130_ef_sc_hd__decap_12
XFILLER_93_697 VPWR VGND VPWR VGND sky130_ef_sc_hd__decap_12
XFILLER_92_185 VGND VGND VPWR VPWR sky130_fd_sc_hd__decap_8
XTAP_TAPCELL_ROW_0_329 VGND VPWR sky130_fd_sc_hd__tapvpwrvgnd_1
XFILLER_19_783 VGND VGND VPWR VPWR sky130_fd_sc_hd__fill_1
XFILLER_34_797 VGND VGND VPWR VPWR sky130_fd_sc_hd__fill_1
X_1966_ _0907_ _1230_ VGND VGND VPWR VPWR _1231_ sky130_fd_sc_hd__nor2_1
XFILLER_146_121 VPWR VGND VPWR VGND sky130_ef_sc_hd__decap_12
XFILLER_119_335 VGND VGND VPWR VPWR sky130_fd_sc_hd__fill_1
XFILLER_146_165 VPWR VGND VPWR VGND sky130_ef_sc_hd__decap_12
X_1897_ CU_state_dbg\[1\] _1164_ _0884_ VGND VGND VPWR VPWR _1165_ sky130_fd_sc_hd__o21ai_1
XFILLER_135_839 VGND VGND VPWR VPWR sky130_fd_sc_hd__fill_1
XFILLER_108_15 VPWR VGND VPWR VGND sky130_ef_sc_hd__decap_12
XFILLER_115_541 VPWR VGND VPWR VGND sky130_ef_sc_hd__decap_12
XTAP_TAPCELL_ROW_73_1503 VGND VPWR sky130_fd_sc_hd__tapvpwrvgnd_1
XFILLER_115_585 VPWR VGND VPWR VGND sky130_ef_sc_hd__decap_12
X_2518_ a_r1\[2\] b_r1\[2\] _0223_ _0262_ _0265_ VGND VGND VPWR VPWR _0266_ sky130_fd_sc_hd__a311o_1
XFILLER_130_533 VPWR VGND VPWR VGND sky130_ef_sc_hd__decap_12
XFILLER_88_469 VGND VGND VPWR VPWR sky130_fd_sc_hd__decap_6
X_2449_ a_r0\[1\] b_r0\[1\] a_r0\[0\] b_r0\[0\] VGND VGND VPWR VPWR _0199_ sky130_fd_sc_hd__o211a_1
XFILLER_29_503 VGND VGND VPWR VPWR sky130_fd_sc_hd__fill_1
XANTENNA__3311__RESET_B net36 VGND VGND VPWR VPWR sky130_fd_sc_hd__diode_2
XFILLER_57_889 VGND VGND VPWR VPWR sky130_fd_sc_hd__decap_6
XFILLER_56_333 VPWR VGND VPWR VGND sky130_ef_sc_hd__decap_12
XFILLER_17_709 VPWR VGND VPWR VGND sky130_ef_sc_hd__decap_12
XTAP_TAPCELL_ROW_104_2002 VGND VPWR sky130_fd_sc_hd__tapvpwrvgnd_1
XFILLER_72_837 VPWR VGND VPWR VGND sky130_ef_sc_hd__decap_12
XFILLER_25_753 VPWR VGND VPWR VGND sky130_ef_sc_hd__decap_12
XTAP_TAPCELL_ROW_27_759 VGND VPWR sky130_fd_sc_hd__tapvpwrvgnd_1
XTAP_TAPCELL_ROW_84_1676 VGND VPWR sky130_fd_sc_hd__tapvpwrvgnd_1
XFILLER_80_881 VPWR VGND VPWR VGND sky130_ef_sc_hd__decap_12
XFILLER_40_701 VPWR VGND VPWR VGND sky130_ef_sc_hd__decap_12
XFILLER_25_797 VPWR VGND VPWR VGND sky130_ef_sc_hd__decap_12
XFILLER_33_55 VGND VGND VPWR VPWR sky130_fd_sc_hd__fill_1
XFILLER_149_55 VGND VGND VPWR VPWR sky130_fd_sc_hd__fill_1
XFILLER_125_305 VPWR VGND VPWR VGND sky130_ef_sc_hd__decap_12
XFILLER_123_3 VPWR VGND VPWR VGND sky130_ef_sc_hd__decap_12
XFILLER_138_699 VGND VGND VPWR VPWR sky130_fd_sc_hd__fill_1
XTAP_TAPCELL_ROW_115_2164 VGND VPWR sky130_fd_sc_hd__tapvpwrvgnd_1
XFILLER_153_669 VGND VGND VPWR VPWR sky130_fd_sc_hd__decap_3
XFILLER_141_809 VPWR VGND VPWR VGND sky130_ef_sc_hd__decap_12
XFILLER_134_861 VGND VGND VPWR VPWR sky130_fd_sc_hd__decap_6
XFILLER_125_349 VPWR VGND VPWR VGND sky130_ef_sc_hd__decap_12
XTAP_TAPCELL_ROW_115_2175 VGND VPWR sky130_fd_sc_hd__tapvpwrvgnd_1
XFILLER_3_167 VGND VGND VPWR VPWR sky130_fd_sc_hd__fill_1
XFILLER_133_393 VPWR VGND VPWR VGND sky130_ef_sc_hd__decap_12
XFILLER_79_436 VPWR VGND VPWR VGND sky130_ef_sc_hd__decap_12
XTAP_TAPCELL_ROW_7_451 VGND VPWR sky130_fd_sc_hd__tapvpwrvgnd_1
XANTENNA__1742__C1 A_reg\[11\] VGND VGND VPWR VPWR sky130_fd_sc_hd__diode_2
XTAP_TAPCELL_ROW_7_440 VGND VPWR sky130_fd_sc_hd__tapvpwrvgnd_1
XFILLER_0_841 VPWR VGND VPWR VGND sky130_ef_sc_hd__decap_12
XFILLER_58_85 VPWR VGND VPWR VGND sky130_ef_sc_hd__decap_12
XFILLER_75_653 VGND VGND VPWR VPWR sky130_fd_sc_hd__fill_2
XFILLER_74_141 VPWR VGND VPWR VGND sky130_ef_sc_hd__decap_12
XFILLER_48_856 VPWR VGND VPWR VGND sky130_ef_sc_hd__decap_12
XFILLER_75_697 VGND VGND VPWR VPWR sky130_fd_sc_hd__decap_6
XFILLER_35_517 VPWR VGND VPWR VGND sky130_ef_sc_hd__decap_12
XFILLER_47_377 VPWR VGND VPWR VGND sky130_ef_sc_hd__decap_12
XFILLER_90_645 VPWR VGND VPWR VGND sky130_ef_sc_hd__decap_12
XFILLER_74_73 VGND VGND VPWR VPWR sky130_fd_sc_hd__fill_2
XFILLER_62_347 VPWR VGND VPWR VGND sky130_ef_sc_hd__decap_12
XFILLER_43_561 VPWR VGND VPWR VGND sky130_ef_sc_hd__decap_12
XFILLER_149_909 VGND VGND VPWR VPWR sky130_fd_sc_hd__fill_1
XFILLER_15_274 VGND VGND VPWR VPWR sky130_fd_sc_hd__decap_6
XFILLER_148_419 VGND VGND VPWR VPWR sky130_fd_sc_hd__fill_1
XANTENNA__3240__CLK clknet_3_4__leaf_clk VGND VGND VPWR VPWR sky130_fd_sc_hd__diode_2
X_1820_ _1086_ _1090_ _1092_ _1085_ VGND VGND VPWR VPWR _1093_ sky130_fd_sc_hd__a22o_1
XFILLER_128_121 VPWR VGND VPWR VGND sky130_ef_sc_hd__decap_12
XFILLER_30_277 VPWR VGND VPWR VGND sky130_ef_sc_hd__decap_12
X_1751_ _0888_ _1019_ _1014_ VGND VGND VPWR VPWR _1024_ sky130_fd_sc_hd__a21boi_1
XFILLER_7_440 VGND VGND VPWR VPWR sky130_fd_sc_hd__decap_8
XFILLER_144_625 VPWR VGND VPWR VGND sky130_ef_sc_hd__decap_12
XFILLER_143_113 VPWR VGND VPWR VGND sky130_ef_sc_hd__decap_12
XFILLER_128_165 VPWR VGND VPWR VGND sky130_ef_sc_hd__decap_12
XFILLER_117_839 VGND VGND VPWR VPWR sky130_fd_sc_hd__fill_1
X_1682_ A_reg\[6\] _0953_ _0956_ VGND VGND VPWR VPWR _0958_ sky130_fd_sc_hd__and3_1
XFILLER_144_669 VPWR VGND VPWR VGND sky130_ef_sc_hd__decap_12
XFILLER_99_81 VPWR VGND VPWR VGND sky130_ef_sc_hd__decap_12
XFILLER_98_701 VPWR VGND VPWR VGND sky130_ef_sc_hd__decap_12
XTAP_TAPCELL_ROW_55_1211 VGND VPWR sky130_fd_sc_hd__tapvpwrvgnd_1
XFILLER_112_533 VPWR VGND VPWR VGND sky130_ef_sc_hd__decap_12
X_2303_ B_reg\[15\] _1174_ B_reg\[14\] VGND VGND VPWR VPWR _1556_ sky130_fd_sc_hd__a21bo_1
XFILLER_85_417 VPWR VGND VPWR VGND sky130_ef_sc_hd__decap_12
X_3283_ clknet_3_1__leaf_clk _0066_ net36 VGND VGND VPWR VPWR A_reg\[9\] sky130_fd_sc_hd__dfrtp_4
XFILLER_97_288 VGND VGND VPWR VPWR sky130_fd_sc_hd__decap_6
XANTENNA__2289__A0 a_r3\[1\] VGND VGND VPWR VPWR sky130_fd_sc_hd__diode_2
XANTENNA__1642__C A_reg\[13\] VGND VGND VPWR VPWR sky130_fd_sc_hd__diode_2
X_2234_ A_reg\[4\] _1487_ _1489_ _1490_ VGND VGND VPWR VPWR _1491_ sky130_fd_sc_hd__a211o_1
XTAP_TAPCELL_ROW_146_2669 VGND VPWR sky130_fd_sc_hd__tapvpwrvgnd_1
XFILLER_54_804 VGND VGND VPWR VPWR sky130_fd_sc_hd__decap_8
X_2165_ _1413_ _1415_ VGND VGND VPWR VPWR _1422_ sky130_fd_sc_hd__nand2_1
XFILLER_38_333 VGND VGND VPWR VPWR sky130_fd_sc_hd__decap_8
XFILLER_38_377 VPWR VGND VPWR VGND sky130_ef_sc_hd__decap_12
XFILLER_80_111 VPWR VGND VPWR VGND sky130_ef_sc_hd__decap_12
X_2096_ B_reg\[13\] _1177_ VGND VGND VPWR VPWR _1355_ sky130_fd_sc_hd__nand2_1
XFILLER_80_166 VGND VGND VPWR VPWR sky130_fd_sc_hd__fill_2
XFILLER_0_81 VGND VGND VPWR VPWR sky130_fd_sc_hd__decap_3
XFILLER_22_701 VPWR VGND VPWR VGND sky130_ef_sc_hd__decap_12
XTAP_TAPCELL_ROW_24_718 VGND VPWR sky130_fd_sc_hd__tapvpwrvgnd_1
XFILLER_110_27 VGND VGND VPWR VPWR sky130_fd_sc_hd__fill_1
XFILLER_80_188 VGND VGND VPWR VPWR sky130_fd_sc_hd__decap_4
XTAP_TAPCELL_ROW_66_1395 VGND VPWR sky130_fd_sc_hd__tapvpwrvgnd_1
XTAP_TAPCELL_ROW_66_1384 VGND VPWR sky130_fd_sc_hd__tapvpwrvgnd_1
XFILLER_61_391 VGND VGND VPWR VPWR sky130_fd_sc_hd__fill_1
X_2998_ _0667_ _0668_ VGND VGND VPWR VPWR _0686_ sky130_fd_sc_hd__xnor2_1
XFILLER_21_277 VGND VGND VPWR VPWR sky130_fd_sc_hd__decap_3
XFILLER_147_441 VGND VGND VPWR VPWR sky130_fd_sc_hd__decap_6
X_1949_ _0904_ _1211_ VGND VGND VPWR VPWR _1214_ sky130_fd_sc_hd__and2_1
XFILLER_147_485 VPWR VGND VPWR VGND sky130_ef_sc_hd__decap_12
XFILLER_119_69 VPWR VGND VPWR VGND sky130_ef_sc_hd__decap_12
XFILLER_107_305 VPWR VGND VPWR VGND sky130_ef_sc_hd__decap_12
XFILLER_123_809 VPWR VGND VPWR VGND sky130_ef_sc_hd__decap_12
XFILLER_107_349 VPWR VGND VPWR VGND sky130_ef_sc_hd__decap_12
XFILLER_116_861 VGND VGND VPWR VPWR sky130_fd_sc_hd__decap_6
XFILLER_131_853 VPWR VGND VPWR VGND sky130_ef_sc_hd__decap_12
XFILLER_115_393 VPWR VGND VPWR VGND sky130_ef_sc_hd__decap_12
XFILLER_135_57 VPWR VGND VPWR VGND sky130_ef_sc_hd__decap_12
XFILLER_130_363 VGND VGND VPWR VPWR sky130_fd_sc_hd__fill_1
XTAP_TAPCELL_ROW_110_2094 VGND VPWR sky130_fd_sc_hd__tapvpwrvgnd_1
XFILLER_0_137 VGND VGND VPWR VPWR sky130_fd_sc_hd__decap_3
XFILLER_131_897 VPWR VGND VPWR VGND sky130_ef_sc_hd__decap_12
XFILLER_103_588 VPWR VGND VPWR VGND sky130_ef_sc_hd__decap_12
XFILLER_88_277 VGND VGND VPWR VPWR sky130_fd_sc_hd__fill_2
XTAP_TAPCELL_ROW_86_1705 VGND VPWR sky130_fd_sc_hd__tapvpwrvgnd_1
XFILLER_57_653 VPWR VGND VPWR VGND sky130_ef_sc_hd__decap_12
XFILLER_72_601 VPWR VGND VPWR VGND sky130_ef_sc_hd__decap_12
XFILLER_56_141 VPWR VGND VPWR VGND sky130_ef_sc_hd__decap_12
XFILLER_17_517 VPWR VGND VPWR VGND sky130_ef_sc_hd__decap_12
XFILLER_28_77 VGND VGND VPWR VPWR sky130_fd_sc_hd__decap_6
XFILLER_72_645 VPWR VGND VPWR VGND sky130_ef_sc_hd__decap_12
XFILLER_71_111 VGND VGND VPWR VPWR sky130_fd_sc_hd__fill_1
XFILLER_71_144 VPWR VGND VPWR VGND sky130_ef_sc_hd__decap_12
XANTENNA__3263__CLK clknet_3_7__leaf_clk VGND VGND VPWR VPWR sky130_fd_sc_hd__diode_2
XFILLER_25_561 VPWR VGND VPWR VGND sky130_ef_sc_hd__decap_12
XFILLER_44_65 VPWR VGND VPWR VGND sky130_ef_sc_hd__decap_12
XFILLER_9_727 VGND VGND VPWR VPWR sky130_fd_sc_hd__fill_1
XFILLER_12_233 VPWR VGND VPWR VGND sky130_ef_sc_hd__decap_12
XTAP_TAPCELL_ROW_117_2204 VGND VPWR sky130_fd_sc_hd__tapvpwrvgnd_1
XFILLER_60_20 VGND VGND VPWR VPWR sky130_fd_sc_hd__decap_8
XFILLER_126_625 VPWR VGND VPWR VGND sky130_ef_sc_hd__decap_12
XFILLER_125_113 VPWR VGND VPWR VGND sky130_ef_sc_hd__decap_12
XFILLER_60_97 VPWR VGND VPWR VGND sky130_ef_sc_hd__decap_12
XFILLER_153_433 VPWR VGND VPWR VGND sky130_ef_sc_hd__decap_12
XTAP_TAPCELL_ROW_130_2415 VGND VPWR sky130_fd_sc_hd__tapvpwrvgnd_1
XTAP_TAPCELL_ROW_130_2404 VGND VPWR sky130_fd_sc_hd__tapvpwrvgnd_1
XFILLER_126_669 VPWR VGND VPWR VGND sky130_ef_sc_hd__decap_12
XFILLER_99_509 VGND VGND VPWR VPWR sky130_fd_sc_hd__fill_1
XTAP_TAPCELL_ROW_97_1889 VGND VPWR sky130_fd_sc_hd__tapvpwrvgnd_1
XTAP_TAPCELL_ROW_97_1878 VGND VPWR sky130_fd_sc_hd__tapvpwrvgnd_1
XTAP_TAPCELL_ROW_10_489 VGND VPWR sky130_fd_sc_hd__tapvpwrvgnd_1
XFILLER_5_15 VPWR VGND VPWR VGND sky130_ef_sc_hd__decap_12
XFILLER_4_421 VPWR VGND VPWR VGND sky130_ef_sc_hd__decap_12
XANTENNA__3284__Q A_reg\[10\] VGND VGND VPWR VPWR sky130_fd_sc_hd__diode_2
XFILLER_153_477 VPWR VGND VPWR VGND sky130_ef_sc_hd__decap_12
XFILLER_141_617 VPWR VGND VPWR VGND sky130_ef_sc_hd__decap_12
XANTENNA__3233__RESET_B net36 VGND VGND VPWR VPWR sky130_fd_sc_hd__diode_2
XFILLER_121_385 VGND VGND VPWR VPWR sky130_fd_sc_hd__decap_6
XFILLER_67_417 VGND VGND VPWR VPWR sky130_fd_sc_hd__fill_2
XANTENNA__1730__A2 _0911_ VGND VGND VPWR VPWR sky130_fd_sc_hd__diode_2
XTAP_TAPCELL_ROW_50_1130 VGND VPWR sky130_fd_sc_hd__tapvpwrvgnd_1
XTAP_TAPCELL_ROW_128_2377 VGND VPWR sky130_fd_sc_hd__tapvpwrvgnd_1
XPHY_EDGE_ROW_13_Right_13 VGND VGND VPWR VPWR sky130_fd_sc_hd__decap_3
XFILLER_75_461 VPWR VGND VPWR VGND sky130_ef_sc_hd__decap_12
XFILLER_36_848 VPWR VGND VPWR VGND sky130_ef_sc_hd__decap_12
XTAP_TAPCELL_ROW_141_2588 VGND VPWR sky130_fd_sc_hd__tapvpwrvgnd_1
XFILLER_90_475 VGND VGND VPWR VPWR sky130_fd_sc_hd__fill_1
XFILLER_35_369 VPWR VGND VPWR VGND sky130_ef_sc_hd__decap_12
X_2921_ _0574_ _0582_ _0608_ VGND VGND VPWR VPWR _0609_ sky130_fd_sc_hd__o21a_1
XFILLER_62_177 VGND VGND VPWR VPWR sky130_fd_sc_hd__decap_8
XFILLER_44_881 VPWR VGND VPWR VGND sky130_ef_sc_hd__decap_12
XTAP_TAPCELL_ROW_48_1092 VGND VPWR sky130_fd_sc_hd__tapvpwrvgnd_1
XFILLER_31_542 VGND VGND VPWR VPWR sky130_fd_sc_hd__fill_1
X_2852_ net25 B_reg\[2\] _0383_ VGND VGND VPWR VPWR _0075_ sky130_fd_sc_hd__mux2_1
XFILLER_86_3 VPWR VGND VPWR VGND sky130_ef_sc_hd__decap_12
XFILLER_129_441 VGND VGND VPWR VPWR sky130_fd_sc_hd__decap_6
X_2783_ _0436_ _0519_ VGND VGND VPWR VPWR _0523_ sky130_fd_sc_hd__nand2_1
XPHY_EDGE_ROW_22_Right_22 VGND VGND VPWR VPWR sky130_fd_sc_hd__decap_3
X_1803_ _1073_ _1075_ VGND VGND VPWR VPWR _1076_ sky130_fd_sc_hd__and2_1
XFILLER_129_485 VPWR VGND VPWR VGND sky130_ef_sc_hd__decap_12
X_1734_ _0887_ A_reg\[13\] A_reg\[14\] VGND VGND VPWR VPWR _1007_ sky130_fd_sc_hd__o21ai_1
XFILLER_144_433 VPWR VGND VPWR VGND sky130_ef_sc_hd__decap_12
XFILLER_105_809 VPWR VGND VPWR VGND sky130_ef_sc_hd__decap_12
XFILLER_8_793 VPWR VGND VPWR VGND sky130_ef_sc_hd__decap_12
XFILLER_7_281 VPWR VGND VPWR VGND sky130_ef_sc_hd__decap_12
XFILLER_144_477 VPWR VGND VPWR VGND sky130_ef_sc_hd__decap_12
XFILLER_131_105 VGND VGND VPWR VPWR sky130_fd_sc_hd__decap_6
X_1665_ _0921_ _0929_ _0931_ VGND VGND VPWR VPWR _0941_ sky130_fd_sc_hd__o21a_1
XFILLER_131_149 VPWR VGND VPWR VGND sky130_ef_sc_hd__decap_12
XFILLER_113_853 VPWR VGND VPWR VGND sky130_ef_sc_hd__decap_12
XFILLER_98_575 VPWR VGND VPWR VGND sky130_ef_sc_hd__decap_12
XFILLER_113_897 VPWR VGND VPWR VGND sky130_ef_sc_hd__decap_12
XFILLER_112_363 VGND VGND VPWR VPWR sky130_fd_sc_hd__fill_1
XFILLER_85_225 VPWR VGND VPWR VGND sky130_ef_sc_hd__decap_12
X_3266_ clknet_3_7__leaf_clk _0049_ net36 VGND VGND VPWR VPWR net52 sky130_fd_sc_hd__dfrtp_1
XPHY_EDGE_ROW_31_Right_31 VGND VGND VPWR VPWR sky130_fd_sc_hd__decap_3
X_2217_ _1466_ _1471_ _1473_ VGND VGND VPWR VPWR _1474_ sky130_fd_sc_hd__a21bo_1
XFILLER_39_653 VPWR VGND VPWR VGND sky130_ef_sc_hd__decap_12
XFILLER_94_781 VPWR VGND VPWR VGND sky130_ef_sc_hd__decap_12
XFILLER_85_269 VGND VGND VPWR VPWR sky130_fd_sc_hd__decap_8
XTAP_TAPCELL_ROW_68_1424 VGND VPWR sky130_fd_sc_hd__tapvpwrvgnd_1
XTAP_TAPCELL_ROW_68_1413 VGND VPWR sky130_fd_sc_hd__tapvpwrvgnd_1
XFILLER_54_601 VGND VGND VPWR VPWR sky130_fd_sc_hd__fill_1
XANTENNA__3286__CLK clknet_3_5__leaf_clk VGND VGND VPWR VPWR sky130_fd_sc_hd__diode_2
X_3197_ X_crt\[7\] _0877_ CRT_Start VGND VGND VPWR VPWR _0096_ sky130_fd_sc_hd__mux2_1
XFILLER_38_141 VPWR VGND VPWR VGND sky130_ef_sc_hd__decap_12
XFILLER_121_15 VPWR VGND VPWR VGND sky130_ef_sc_hd__decap_12
X_2148_ b_r0\[0\] _0911_ _1404_ _1406_ VGND VGND VPWR VPWR _0017_ sky130_fd_sc_hd__a22o_1
XFILLER_54_645 VPWR VGND VPWR VGND sky130_ef_sc_hd__decap_12
XFILLER_53_111 VGND VGND VPWR VPWR sky130_fd_sc_hd__fill_1
X_2079_ _1338_ _1340_ VGND VGND VPWR VPWR _1341_ sky130_fd_sc_hd__or2_1
XFILLER_54_667 VGND VGND VPWR VPWR sky130_fd_sc_hd__decap_8
XFILLER_53_166 VGND VGND VPWR VPWR sky130_fd_sc_hd__fill_2
XANTENNA__2434__B1 _0910_ VGND VGND VPWR VPWR sky130_fd_sc_hd__diode_2
XTAP_TAPCELL_ROW_81_1635 VGND VPWR sky130_fd_sc_hd__tapvpwrvgnd_1
XTAP_TAPCELL_ROW_81_1624 VGND VPWR sky130_fd_sc_hd__tapvpwrvgnd_1
XFILLER_139_205 VPWR VGND VPWR VGND sky130_ef_sc_hd__decap_12
XFILLER_22_531 VGND VGND VPWR VPWR sky130_fd_sc_hd__fill_1
XPHY_EDGE_ROW_40_Right_40 VGND VGND VPWR VPWR sky130_fd_sc_hd__decap_3
XFILLER_139_249 VPWR VGND VPWR VGND sky130_ef_sc_hd__decap_12
XFILLER_10_737 VPWR VGND VPWR VGND sky130_ef_sc_hd__decap_12
XFILLER_108_625 VPWR VGND VPWR VGND sky130_ef_sc_hd__decap_12
XFILLER_147_293 VPWR VGND VPWR VGND sky130_ef_sc_hd__decap_12
XFILLER_108_669 VPWR VGND VPWR VGND sky130_ef_sc_hd__decap_12
XFILLER_107_113 VPWR VGND VPWR VGND sky130_ef_sc_hd__decap_12
XFILLER_123_617 VPWR VGND VPWR VGND sky130_ef_sc_hd__decap_12
XTAP_TAPCELL_ROW_112_2123 VGND VPWR sky130_fd_sc_hd__tapvpwrvgnd_1
XTAP_TAPCELL_ROW_79_1597 VGND VPWR sky130_fd_sc_hd__tapvpwrvgnd_1
XFILLER_150_469 VGND VGND VPWR VPWR sky130_fd_sc_hd__decap_6
XTAP_TAPCELL_ROW_92_1797 VGND VPWR sky130_fd_sc_hd__tapvpwrvgnd_1
XFILLER_89_597 VPWR VGND VPWR VGND sky130_ef_sc_hd__decap_12
XFILLER_57_461 VPWR VGND VPWR VGND sky130_ef_sc_hd__decap_12
XFILLER_55_20 VPWR VGND VPWR VGND sky130_ef_sc_hd__decap_12
XFILLER_18_837 VPWR VGND VPWR VGND sky130_ef_sc_hd__decap_12
XFILLER_33_807 VPWR VGND VPWR VGND sky130_ef_sc_hd__decap_12
XFILLER_44_133 VGND VGND VPWR VPWR sky130_fd_sc_hd__decap_6
XTAP_TAPCELL_ROW_123_2296 VGND VPWR sky130_fd_sc_hd__tapvpwrvgnd_1
XFILLER_72_497 VGND VGND VPWR VPWR sky130_fd_sc_hd__decap_8
XFILLER_26_881 VPWR VGND VPWR VGND sky130_ef_sc_hd__decap_12
XFILLER_32_306 VGND VGND VPWR VPWR sky130_fd_sc_hd__fill_2
XFILLER_44_188 VGND VGND VPWR VPWR sky130_fd_sc_hd__decap_8
XFILLER_111_81 VPWR VGND VPWR VGND sky130_ef_sc_hd__decap_12
XFILLER_13_553 VGND VGND VPWR VPWR sky130_fd_sc_hd__decap_6
XFILLER_25_391 VGND VGND VPWR VPWR sky130_fd_sc_hd__fill_1
XTAP_TAPCELL_ROW_99_1918 VGND VPWR sky130_fd_sc_hd__tapvpwrvgnd_1
XFILLER_13_597 VPWR VGND VPWR VGND sky130_ef_sc_hd__decap_12
XFILLER_40_394 VGND VGND VPWR VPWR sky130_fd_sc_hd__fill_1
XFILLER_139_783 VGND VGND VPWR VPWR sky130_fd_sc_hd__fill_1
XFILLER_126_433 VPWR VGND VPWR VGND sky130_ef_sc_hd__decap_12
XFILLER_5_741 VPWR VGND VPWR VGND sky130_ef_sc_hd__decap_12
XFILLER_126_477 VPWR VGND VPWR VGND sky130_ef_sc_hd__decap_12
XFILLER_141_447 VGND VGND VPWR VPWR sky130_fd_sc_hd__fill_1
XFILLER_113_105 VGND VGND VPWR VPWR sky130_fd_sc_hd__decap_6
XFILLER_5_785 VPWR VGND VPWR VGND sky130_ef_sc_hd__decap_12
XFILLER_113_149 VPWR VGND VPWR VGND sky130_ef_sc_hd__decap_12
XFILLER_67_225 VPWR VGND VPWR VGND sky130_ef_sc_hd__decap_12
XFILLER_67_203 VPWR VGND VPWR VGND sky130_ef_sc_hd__decap_12
X_3120_ _0793_ _0807_ VGND VGND VPWR VPWR _0808_ sky130_fd_sc_hd__xnor2_1
XFILLER_121_193 VPWR VGND VPWR VGND sky130_ef_sc_hd__decap_12
XFILLER_110_867 VGND VGND VPWR VPWR sky130_fd_sc_hd__fill_1
XTAP_TAPCELL_ROW_143_2617 VGND VPWR sky130_fd_sc_hd__tapvpwrvgnd_1
XFILLER_83_729 VPWR VGND VPWR VGND sky130_ef_sc_hd__decap_12
XFILLER_48_472 VGND VGND VPWR VPWR sky130_fd_sc_hd__decap_4
XFILLER_36_601 VPWR VGND VPWR VGND sky130_ef_sc_hd__decap_12
X_3051_ _0737_ _0738_ VGND VGND VPWR VPWR _0739_ sky130_fd_sc_hd__nand2b_1
X_2002_ B_reg\[11\] _1260_ _1261_ _1262_ VGND VGND VPWR VPWR _1264_ sky130_fd_sc_hd__a2bb2o_1
XFILLER_35_111 VGND VGND VPWR VPWR sky130_fd_sc_hd__fill_1
XFILLER_36_645 VPWR VGND VPWR VGND sky130_ef_sc_hd__decap_12
XFILLER_90_283 VPWR VGND VPWR VGND sky130_ef_sc_hd__decap_12
XFILLER_51_615 VGND VGND VPWR VPWR sky130_fd_sc_hd__fill_1
XFILLER_50_103 VGND VGND VPWR VPWR sky130_fd_sc_hd__decap_6
XFILLER_149_503 VGND VGND VPWR VPWR sky130_fd_sc_hd__fill_1
XTAP_TAPCELL_ROW_63_1343 VGND VPWR sky130_fd_sc_hd__tapvpwrvgnd_1
XTAP_TAPCELL_ROW_63_1332 VGND VPWR sky130_fd_sc_hd__tapvpwrvgnd_1
XTAP_TAPCELL_ROW_34_868 VGND VPWR sky130_fd_sc_hd__tapvpwrvgnd_1
X_2904_ _0581_ _0590_ _0591_ VGND VGND VPWR VPWR _0592_ sky130_fd_sc_hd__o21ai_2
XANTENNA_clkbuf_0_clk_X clknet_0_clk VGND VGND VPWR VPWR sky130_fd_sc_hd__diode_2
XFILLER_31_361 VPWR VGND VPWR VGND sky130_ef_sc_hd__decap_12
XTAP_TAPCELL_ROW_34_879 VGND VPWR sky130_fd_sc_hd__tapvpwrvgnd_1
XFILLER_137_709 VPWR VGND VPWR VGND sky130_ef_sc_hd__decap_12
X_2835_ net8 A_reg\[1\] _0383_ VGND VGND VPWR VPWR _0058_ sky130_fd_sc_hd__mux2_1
XFILLER_145_753 VPWR VGND VPWR VGND sky130_ef_sc_hd__decap_12
XFILLER_129_293 VPWR VGND VPWR VGND sky130_ef_sc_hd__decap_12
X_2766_ _0502_ _0505_ VGND VGND VPWR VPWR _0506_ sky130_fd_sc_hd__nand2_1
XFILLER_105_617 VPWR VGND VPWR VGND sky130_ef_sc_hd__decap_12
X_2697_ a_r3\[1\] b_r3\[3\] VGND VGND VPWR VPWR _0437_ sky130_fd_sc_hd__nand2_1
X_1717_ A_reg\[1\] _0989_ _0992_ VGND VGND VPWR VPWR _0993_ sky130_fd_sc_hd__and3_1
XFILLER_145_797 VPWR VGND VPWR VGND sky130_ef_sc_hd__decap_12
XFILLER_116_15 VPWR VGND VPWR VGND sky130_ef_sc_hd__decap_12
X_1648_ A_reg\[13\] _0923_ VGND VGND VPWR VPWR _0924_ sky130_fd_sc_hd__nand2_1
XFILLER_132_469 VGND VGND VPWR VPWR sky130_fd_sc_hd__decap_6
XFILLER_99_895 VGND VGND VPWR VPWR sky130_fd_sc_hd__fill_1
X_3318_ clknet_3_5__leaf_clk _0101_ net36 VGND VGND VPWR VPWR X_crt\[12\] sky130_fd_sc_hd__dfrtp_1
XFILLER_100_333 VPWR VGND VPWR VGND sky130_ef_sc_hd__decap_12
XFILLER_86_545 VPWR VGND VPWR VGND sky130_ef_sc_hd__decap_12
XFILLER_101_889 VGND VGND VPWR VPWR sky130_fd_sc_hd__decap_6
XFILLER_86_589 VGND VGND VPWR VPWR sky130_fd_sc_hd__decap_8
X_3249_ clknet_3_6__leaf_clk _0034_ net36 VGND VGND VPWR VPWR u_crt.r2\[2\] sky130_fd_sc_hd__dfrtp_1
XFILLER_39_461 VPWR VGND VPWR VGND sky130_ef_sc_hd__decap_12
XFILLER_100_399 VGND VGND VPWR VPWR sky130_fd_sc_hd__decap_8
XFILLER_92_29 VPWR VGND VPWR VGND sky130_ef_sc_hd__decap_12
XFILLER_26_133 VGND VGND VPWR VPWR sky130_fd_sc_hd__decap_6
XFILLER_81_261 VPWR VGND VPWR VGND sky130_ef_sc_hd__decap_12
XFILLER_54_475 VGND VGND VPWR VPWR sky130_fd_sc_hd__fill_1
XFILLER_26_177 VPWR VGND VPWR VGND sky130_ef_sc_hd__decap_12
XFILLER_42_637 VGND VGND VPWR VPWR sky130_fd_sc_hd__decap_6
XFILLER_41_125 VPWR VGND VPWR VGND sky130_ef_sc_hd__decap_12
XFILLER_42_659 VPWR VGND VPWR VGND sky130_ef_sc_hd__decap_12
XFILLER_10_501 VPWR VGND VPWR VGND sky130_ef_sc_hd__decap_12
XTAP_TAPCELL_ROW_12_518 VGND VPWR sky130_fd_sc_hd__tapvpwrvgnd_1
XFILLER_41_169 VPWR VGND VPWR VGND sky130_ef_sc_hd__decap_12
XANTENNA__3301__CLK clknet_3_0__leaf_clk VGND VGND VPWR VPWR sky130_fd_sc_hd__diode_2
XFILLER_50_681 VPWR VGND VPWR VGND sky130_ef_sc_hd__decap_12
XTAP_TAPCELL_ROW_12_529 VGND VPWR sky130_fd_sc_hd__tapvpwrvgnd_1
XFILLER_23_895 VGND VGND VPWR VPWR sky130_fd_sc_hd__fill_1
XFILLER_10_545 VPWR VGND VPWR VGND sky130_ef_sc_hd__decap_12
XFILLER_41_55 VGND VGND VPWR VPWR sky130_fd_sc_hd__fill_1
XFILLER_10_589 VPWR VGND VPWR VGND sky130_ef_sc_hd__decap_12
XFILLER_6_549 VGND VGND VPWR VPWR sky130_fd_sc_hd__fill_1
XFILLER_108_477 VPWR VGND VPWR VGND sky130_ef_sc_hd__decap_12
XFILLER_108_466 VGND VGND VPWR VPWR sky130_fd_sc_hd__decap_8
XTAP_TAPCELL_ROW_94_1837 VGND VPWR sky130_fd_sc_hd__tapvpwrvgnd_1
XFILLER_150_233 VPWR VGND VPWR VGND sky130_ef_sc_hd__decap_12
XFILLER_123_447 VGND VGND VPWR VPWR sky130_fd_sc_hd__fill_1
XFILLER_111_609 VGND VGND VPWR VPWR sky130_fd_sc_hd__decap_6
XFILLER_2_755 VGND VGND VPWR VPWR sky130_fd_sc_hd__fill_1
XFILLER_150_277 VPWR VGND VPWR VGND sky130_ef_sc_hd__decap_12
XFILLER_89_361 VGND VGND VPWR VPWR sky130_fd_sc_hd__decap_3
XFILLER_103_193 VPWR VGND VPWR VGND sky130_ef_sc_hd__decap_12
XFILLER_49_225 VPWR VGND VPWR VGND sky130_ef_sc_hd__decap_12
XFILLER_2_27 VGND VGND VPWR VPWR sky130_fd_sc_hd__fill_1
XTAP_TAPCELL_ROW_125_2325 VGND VPWR sky130_fd_sc_hd__tapvpwrvgnd_1
XFILLER_66_63 VPWR VGND VPWR VGND sky130_ef_sc_hd__decap_12
XFILLER_65_729 VPWR VGND VPWR VGND sky130_ef_sc_hd__decap_12
XFILLER_18_601 VPWR VGND VPWR VGND sky130_ef_sc_hd__decap_12
XTAP_TAPCELL_ROW_125_2336 VGND VPWR sky130_fd_sc_hd__tapvpwrvgnd_1
XFILLER_92_526 VGND VGND VPWR VPWR sky130_fd_sc_hd__decap_4
XFILLER_58_781 VPWR VGND VPWR VGND sky130_ef_sc_hd__decap_12
XFILLER_17_111 VGND VGND VPWR VPWR sky130_fd_sc_hd__fill_1
XFILLER_18_645 VPWR VGND VPWR VGND sky130_ef_sc_hd__decap_12
XFILLER_60_401 VPWR VGND VPWR VGND sky130_ef_sc_hd__decap_12
XFILLER_72_294 VPWR VGND VPWR VGND sky130_ef_sc_hd__decap_12
XFILLER_60_445 VPWR VGND VPWR VGND sky130_ef_sc_hd__decap_12
XTAP_TAPCELL_ROW_103_1977 VGND VPWR sky130_fd_sc_hd__tapvpwrvgnd_1
XFILLER_60_489 VPWR VGND VPWR VGND sky130_ef_sc_hd__decap_12
XFILLER_20_309 VPWR VGND VPWR VGND sky130_ef_sc_hd__decap_12
XTAP_TAPCELL_ROW_31_827 VGND VPWR sky130_fd_sc_hd__tapvpwrvgnd_1
XFILLER_41_670 VGND VGND VPWR VPWR sky130_fd_sc_hd__fill_2
XTAP_TAPCELL_ROW_45_1051 VGND VPWR sky130_fd_sc_hd__tapvpwrvgnd_1
XFILLER_119_709 VPWR VGND VPWR VGND sky130_ef_sc_hd__decap_12
X_2620_ _0346_ _0358_ _0364_ VGND VGND VPWR VPWR _0365_ sky130_fd_sc_hd__nand3_1
XFILLER_127_753 VPWR VGND VPWR VGND sky130_ef_sc_hd__decap_12
XPHY_EDGE_ROW_124_Right_124 VGND VGND VPWR VPWR sky130_fd_sc_hd__decap_3
XTAP_TAPCELL_ROW_153_2790 VGND VPWR sky130_fd_sc_hd__tapvpwrvgnd_1
XFILLER_142_701 VPWR VGND VPWR VGND sky130_ef_sc_hd__decap_12
X_2551_ _0296_ _0297_ _0220_ VGND VGND VPWR VPWR _0299_ sky130_fd_sc_hd__a21o_1
XFILLER_127_797 VPWR VGND VPWR VGND sky130_ef_sc_hd__decap_12
XFILLER_99_125 VPWR VGND VPWR VGND sky130_ef_sc_hd__decap_12
X_2482_ _0216_ _0228_ VGND VGND VPWR VPWR _0230_ sky130_fd_sc_hd__and2_1
XFILLER_114_469 VGND VGND VPWR VPWR sky130_fd_sc_hd__decap_6
XFILLER_99_169 VPWR VGND VPWR VGND sky130_ef_sc_hd__decap_12
XFILLER_49_3 VGND VGND VPWR VPWR sky130_fd_sc_hd__decap_8
XFILLER_68_501 VPWR VGND VPWR VGND sky130_ef_sc_hd__decap_12
XFILLER_68_545 VPWR VGND VPWR VGND sky130_ef_sc_hd__decap_12
XFILLER_68_589 VPWR VGND VPWR VGND sky130_ef_sc_hd__decap_12
X_3103_ _0775_ _0777_ VGND VGND VPWR VPWR _0791_ sky130_fd_sc_hd__nand2_1
X_3034_ _0706_ _0707_ VGND VGND VPWR VPWR _0722_ sky130_fd_sc_hd__xnor2_1
XTAP_TAPCELL_ROW_39_949 VGND VPWR sky130_fd_sc_hd__tapvpwrvgnd_1
XFILLER_83_559 VGND VGND VPWR VPWR sky130_fd_sc_hd__fill_1
XTAP_TAPCELL_ROW_19_640 VGND VPWR sky130_fd_sc_hd__tapvpwrvgnd_1
XFILLER_24_637 VGND VGND VPWR VPWR sky130_fd_sc_hd__decap_6
XFILLER_51_434 VPWR VGND VPWR VGND sky130_ef_sc_hd__decap_12
XFILLER_23_125 VPWR VGND VPWR VGND sky130_ef_sc_hd__decap_12
XANTENNA__1860__A1 A_reg\[8\] VGND VGND VPWR VPWR sky130_fd_sc_hd__diode_2
XFILLER_51_489 VPWR VGND VPWR VGND sky130_ef_sc_hd__decap_12
XANTENNA__1659__A A_reg\[10\] VGND VGND VPWR VPWR sky130_fd_sc_hd__diode_2
XFILLER_23_169 VPWR VGND VPWR VGND sky130_ef_sc_hd__decap_12
XFILLER_32_681 VPWR VGND VPWR VGND sky130_ef_sc_hd__decap_12
XFILLER_137_517 VPWR VGND VPWR VGND sky130_ef_sc_hd__decap_12
X_2818_ net38 X_crt\[0\] _0553_ VGND VGND VPWR VPWR _0041_ sky130_fd_sc_hd__mux2_1
XFILLER_145_561 VPWR VGND VPWR VGND sky130_ef_sc_hd__decap_12
X_2749_ _0487_ _0488_ VGND VGND VPWR VPWR _0489_ sky130_fd_sc_hd__nand2_1
XTAP_TAPCELL_ROW_76_1545 VGND VPWR sky130_fd_sc_hd__tapvpwrvgnd_1
XFILLER_11_69 VPWR VGND VPWR VGND sky130_ef_sc_hd__decap_12
XFILLER_132_233 VPWR VGND VPWR VGND sky130_ef_sc_hd__decap_12
XFILLER_127_69 VPWR VGND VPWR VGND sky130_ef_sc_hd__decap_12
XFILLER_105_447 VGND VGND VPWR VPWR sky130_fd_sc_hd__fill_1
XFILLER_78_309 VPWR VGND VPWR VGND sky130_ef_sc_hd__decap_12
XFILLER_132_277 VPWR VGND VPWR VGND sky130_ef_sc_hd__decap_12
XFILLER_87_821 VPWR VGND VPWR VGND sky130_ef_sc_hd__decap_12
XFILLER_87_865 VPWR VGND VPWR VGND sky130_ef_sc_hd__decap_12
XFILLER_143_57 VPWR VGND VPWR VGND sky130_ef_sc_hd__decap_12
XFILLER_101_653 VPWR VGND VPWR VGND sky130_ef_sc_hd__decap_12
XFILLER_100_141 VPWR VGND VPWR VGND sky130_ef_sc_hd__decap_12
XFILLER_47_729 VGND VGND VPWR VPWR sky130_fd_sc_hd__decap_4
XTAP_TAPCELL_ROW_107_2044 VGND VPWR sky130_fd_sc_hd__tapvpwrvgnd_1
XFILLER_101_697 VPWR VGND VPWR VGND sky130_ef_sc_hd__decap_12
XFILLER_46_228 VGND VGND VPWR VPWR sky130_fd_sc_hd__fill_1
XFILLER_55_762 VGND VGND VPWR VPWR sky130_fd_sc_hd__fill_2
XANTENNA__2953__A _0604_ VGND VGND VPWR VPWR sky130_fd_sc_hd__diode_2
XPHY_EDGE_ROW_6_Left_160 VGND VGND VPWR VPWR sky130_fd_sc_hd__decap_3
XFILLER_15_615 VGND VGND VPWR VPWR sky130_fd_sc_hd__fill_1
XFILLER_36_77 VGND VGND VPWR VPWR sky130_fd_sc_hd__decap_6
XFILLER_153_3 VPWR VGND VPWR VGND sky130_ef_sc_hd__decap_12
XTAP_TAPCELL_ROW_120_2255 VGND VPWR sky130_fd_sc_hd__tapvpwrvgnd_1
XTAP_TAPCELL_ROW_120_2244 VGND VPWR sky130_fd_sc_hd__tapvpwrvgnd_1
XFILLER_42_445 VPWR VGND VPWR VGND sky130_ef_sc_hd__decap_12
XFILLER_42_489 VPWR VGND VPWR VGND sky130_ef_sc_hd__decap_12
XFILLER_52_65 VGND VGND VPWR VPWR sky130_fd_sc_hd__decap_3
XFILLER_11_821 VPWR VGND VPWR VGND sky130_ef_sc_hd__decap_12
Xinput19 B_in[11] VGND VGND VPWR VPWR net19 sky130_fd_sc_hd__clkbuf_1
XFILLER_52_98 VGND VGND VPWR VPWR sky130_fd_sc_hd__decap_6
XFILLER_6_302 VGND VGND VPWR VPWR sky130_fd_sc_hd__decap_6
XFILLER_11_865 VPWR VGND VPWR VGND sky130_ef_sc_hd__decap_12
XFILLER_124_701 VPWR VGND VPWR VGND sky130_ef_sc_hd__decap_12
XFILLER_109_753 VPWR VGND VPWR VGND sky130_ef_sc_hd__decap_12
XFILLER_6_357 VGND VGND VPWR VPWR sky130_fd_sc_hd__decap_6
XFILLER_109_797 VPWR VGND VPWR VGND sky130_ef_sc_hd__decap_12
XFILLER_151_553 VGND VGND VPWR VPWR sky130_fd_sc_hd__decap_6
XANTENNA__3292__Q B_reg\[2\] VGND VGND VPWR VPWR sky130_fd_sc_hd__diode_2
XFILLER_151_597 VPWR VGND VPWR VGND sky130_ef_sc_hd__decap_12
XFILLER_111_417 VPWR VGND VPWR VGND sky130_ef_sc_hd__decap_12
XFILLER_97_629 VPWR VGND VPWR VGND sky130_ef_sc_hd__decap_12
XFILLER_2_574 VPWR VGND VPWR VGND sky130_ef_sc_hd__decap_12
XFILLER_96_139 VGND VGND VPWR VPWR sky130_fd_sc_hd__fill_1
XFILLER_92_301 VGND VGND VPWR VPWR sky130_fd_sc_hd__decap_6
XFILLER_77_386 VGND VGND VPWR VPWR sky130_fd_sc_hd__decap_6
XFILLER_37_217 VGND VGND VPWR VPWR sky130_fd_sc_hd__decap_6
XFILLER_92_367 VPWR VGND VPWR VGND sky130_ef_sc_hd__decap_12
XFILLER_93_50 VGND VGND VPWR VPWR sky130_fd_sc_hd__decap_6
XFILLER_65_559 VGND VGND VPWR VPWR sky130_fd_sc_hd__fill_1
XANTENNA_output37_A net37 VGND VGND VPWR VPWR sky130_fd_sc_hd__diode_2
XTAP_TAPCELL_ROW_36_908 VGND VPWR sky130_fd_sc_hd__tapvpwrvgnd_1
XFILLER_52_209 VPWR VGND VPWR VGND sky130_ef_sc_hd__decap_12
XANTENNA__2095__A1 _1354_ VGND VGND VPWR VPWR sky130_fd_sc_hd__diode_2
XFILLER_18_475 VGND VGND VPWR VPWR sky130_fd_sc_hd__fill_1
XFILLER_45_250 VPWR VGND VPWR VGND sky130_ef_sc_hd__decap_12
XFILLER_61_765 VPWR VGND VPWR VGND sky130_ef_sc_hd__decap_12
XFILLER_60_253 VPWR VGND VPWR VGND sky130_ef_sc_hd__decap_12
XFILLER_21_629 VPWR VGND VPWR VGND sky130_ef_sc_hd__decap_12
XTAP_TAPCELL_ROW_138_2538 VGND VPWR sky130_fd_sc_hd__tapvpwrvgnd_1
X_1982_ _0909_ _1243_ VGND VGND VPWR VPWR _1247_ sky130_fd_sc_hd__xnor2_1
XFILLER_14_681 VPWR VGND VPWR VGND sky130_ef_sc_hd__decap_12
XFILLER_20_139 VGND VGND VPWR VPWR sky130_fd_sc_hd__fill_1
XFILLER_119_517 VPWR VGND VPWR VGND sky130_ef_sc_hd__decap_12
XTAP_TAPCELL_ROW_151_2749 VGND VPWR sky130_fd_sc_hd__tapvpwrvgnd_1
XFILLER_127_561 VPWR VGND VPWR VGND sky130_ef_sc_hd__decap_12
X_2603_ _0319_ _0320_ VGND VGND VPWR VPWR _0348_ sky130_fd_sc_hd__nor2_1
XTAP_TAPCELL_ROW_58_1253 VGND VPWR sky130_fd_sc_hd__tapvpwrvgnd_1
X_2534_ _0268_ _0277_ VGND VGND VPWR VPWR _0282_ sky130_fd_sc_hd__or2_1
XFILLER_142_531 VGND VGND VPWR VPWR sky130_fd_sc_hd__fill_1
XFILLER_114_233 VPWR VGND VPWR VGND sky130_ef_sc_hd__decap_12
XTAP_TAPCELL_ROW_58_1264 VGND VPWR sky130_fd_sc_hd__tapvpwrvgnd_1
XFILLER_130_737 VPWR VGND VPWR VGND sky130_ef_sc_hd__decap_12
XFILLER_114_277 VPWR VGND VPWR VGND sky130_ef_sc_hd__decap_12
X_2465_ _0212_ _0214_ u_crt.r0\[0\] _0910_ VGND VGND VPWR VPWR _0027_ sky130_fd_sc_hd__a2bb2o_1
XFILLER_69_821 VPWR VGND VPWR VGND sky130_ef_sc_hd__decap_12
X_2396_ _0140_ _0149_ VGND VGND VPWR VPWR _0150_ sky130_fd_sc_hd__xnor2_1
XTAP_TAPCELL_ROW_71_1464 VGND VPWR sky130_fd_sc_hd__tapvpwrvgnd_1
XFILLER_84_813 VPWR VGND VPWR VGND sky130_ef_sc_hd__decap_12
XTAP_TAPCELL_ROW_71_1475 VGND VPWR sky130_fd_sc_hd__tapvpwrvgnd_1
XFILLER_69_865 VPWR VGND VPWR VGND sky130_ef_sc_hd__decap_12
XFILLER_3_81 VPWR VGND VPWR VGND sky130_ef_sc_hd__decap_12
XFILLER_29_729 VPWR VGND VPWR VGND sky130_ef_sc_hd__decap_12
XFILLER_113_27 VPWR VGND VPWR VGND sky130_ef_sc_hd__decap_12
XFILLER_95_161 VGND VGND VPWR VPWR sky130_fd_sc_hd__decap_6
XFILLER_56_559 VPWR VGND VPWR VGND sky130_ef_sc_hd__decap_12
X_3017_ _0563_ _0574_ VGND VGND VPWR VPWR _0705_ sky130_fd_sc_hd__xor2_1
XFILLER_71_529 VGND VGND VPWR VPWR sky130_fd_sc_hd__fill_1
XFILLER_24_401 VGND VGND VPWR VPWR sky130_fd_sc_hd__fill_1
XFILLER_36_250 VGND VGND VPWR VPWR sky130_fd_sc_hd__fill_2
XFILLER_51_220 VGND VGND VPWR VPWR sky130_fd_sc_hd__decap_4
XFILLER_24_445 VPWR VGND VPWR VGND sky130_ef_sc_hd__decap_12
XFILLER_52_798 VPWR VGND VPWR VGND sky130_ef_sc_hd__decap_12
XFILLER_24_489 VPWR VGND VPWR VGND sky130_ef_sc_hd__decap_12
XFILLER_138_837 VPWR VGND VPWR VGND sky130_ef_sc_hd__decap_12
XANTENNA_clkbuf_3_2__f_clk_A clknet_0_clk VGND VGND VPWR VPWR sky130_fd_sc_hd__diode_2
XTAP_TAPCELL_ROW_22_679 VGND VPWR sky130_fd_sc_hd__tapvpwrvgnd_1
XFILLER_106_701 VPWR VGND VPWR VGND sky130_ef_sc_hd__decap_12
XFILLER_146_881 VPWR VGND VPWR VGND sky130_ef_sc_hd__decap_12
XFILLER_3_327 VGND VGND VPWR VPWR sky130_fd_sc_hd__decap_8
XFILLER_3_316 VGND VGND VPWR VPWR sky130_fd_sc_hd__fill_2
XFILLER_3_305 VGND VGND VPWR VPWR sky130_fd_sc_hd__decap_4
XFILLER_145_391 VGND VGND VPWR VPWR sky130_fd_sc_hd__fill_1
XFILLER_133_553 VGND VGND VPWR VPWR sky130_fd_sc_hd__decap_6
XFILLER_133_597 VPWR VGND VPWR VGND sky130_ef_sc_hd__decap_12
XFILLER_87_673 VPWR VGND VPWR VGND sky130_ef_sc_hd__decap_12
XFILLER_74_301 VGND VGND VPWR VPWR sky130_fd_sc_hd__decap_6
XFILLER_19_217 VGND VGND VPWR VPWR sky130_fd_sc_hd__decap_6
XFILLER_90_805 VGND VGND VPWR VPWR sky130_fd_sc_hd__decap_6
XTAP_TAPCELL_ROW_89_1758 VGND VPWR sky130_fd_sc_hd__tapvpwrvgnd_1
XFILLER_90_849 VPWR VGND VPWR VGND sky130_ef_sc_hd__decap_12
XANTENNA__3258__RESET_B net36 VGND VGND VPWR VPWR sky130_fd_sc_hd__diode_2
XTAP_TAPCELL_ROW_2_371 VGND VPWR sky130_fd_sc_hd__tapvpwrvgnd_1
XTAP_TAPCELL_ROW_2_360 VGND VPWR sky130_fd_sc_hd__tapvpwrvgnd_1
XFILLER_34_209 VGND VGND VPWR VPWR sky130_fd_sc_hd__fill_2
XFILLER_103_93 VPWR VGND VPWR VGND sky130_ef_sc_hd__decap_12
XFILLER_55_581 VPWR VGND VPWR VGND sky130_ef_sc_hd__decap_12
XFILLER_43_721 VGND VGND VPWR VPWR sky130_fd_sc_hd__decap_6
XPHY_EDGE_ROW_69_Right_69 VGND VGND VPWR VPWR sky130_fd_sc_hd__decap_3
XFILLER_63_53 VGND VGND VPWR VPWR sky130_fd_sc_hd__decap_3
XFILLER_42_253 VPWR VGND VPWR VGND sky130_ef_sc_hd__decap_12
XFILLER_43_765 VGND VGND VPWR VPWR sky130_fd_sc_hd__decap_4
XTAP_TAPCELL_ROW_100_1936 VGND VPWR sky130_fd_sc_hd__tapvpwrvgnd_1
XTAP_TAPCELL_ROW_100_1925 VGND VPWR sky130_fd_sc_hd__tapvpwrvgnd_1
XFILLER_63_97 VPWR VGND VPWR VGND sky130_ef_sc_hd__decap_12
XFILLER_8_15 VPWR VGND VPWR VGND sky130_ef_sc_hd__decap_12
XTAP_TAPCELL_ROW_42_1010 VGND VPWR sky130_fd_sc_hd__tapvpwrvgnd_1
XANTENNA__3287__Q A_reg\[13\] VGND VGND VPWR VPWR sky130_fd_sc_hd__diode_2
XFILLER_11_673 VPWR VGND VPWR VGND sky130_ef_sc_hd__decap_12
XTAP_TAPCELL_ROW_41_988 VGND VPWR sky130_fd_sc_hd__tapvpwrvgnd_1
XFILLER_6_121 VPWR VGND VPWR VGND sky130_ef_sc_hd__decap_12
XFILLER_143_317 VPWR VGND VPWR VGND sky130_ef_sc_hd__decap_12
XTAP_TAPCELL_ROW_133_2457 VGND VPWR sky130_fd_sc_hd__tapvpwrvgnd_1
XFILLER_109_561 VPWR VGND VPWR VGND sky130_ef_sc_hd__decap_12
XFILLER_6_165 VPWR VGND VPWR VGND sky130_ef_sc_hd__decap_12
XFILLER_124_531 VGND VGND VPWR VPWR sky130_fd_sc_hd__fill_1
XFILLER_98_905 VGND VGND VPWR VPWR sky130_fd_sc_hd__decap_4
XPHY_EDGE_ROW_78_Right_78 VGND VGND VPWR VPWR sky130_fd_sc_hd__decap_3
XFILLER_151_361 VPWR VGND VPWR VGND sky130_ef_sc_hd__decap_12
XFILLER_69_106 VGND VGND VPWR VPWR sky130_fd_sc_hd__decap_6
XFILLER_112_737 VPWR VGND VPWR VGND sky130_ef_sc_hd__decap_12
XFILLER_111_225 VPWR VGND VPWR VGND sky130_ef_sc_hd__decap_12
XFILLER_97_437 VGND VGND VPWR VPWR sky130_fd_sc_hd__decap_3
X_2250_ _1499_ _1504_ _1506_ VGND VGND VPWR VPWR _1507_ sky130_fd_sc_hd__a21oi_2
XFILLER_78_662 VGND VGND VPWR VPWR sky130_fd_sc_hd__fill_1
XFILLER_66_813 VPWR VGND VPWR VGND sky130_ef_sc_hd__decap_12
XTAP_TAPCELL_ROW_53_1183 VGND VPWR sky130_fd_sc_hd__tapvpwrvgnd_1
XTAP_TAPCELL_ROW_53_1172 VGND VPWR sky130_fd_sc_hd__tapvpwrvgnd_1
XFILLER_38_504 VPWR VGND VPWR VGND sky130_ef_sc_hd__decap_12
XFILLER_120_781 VPWR VGND VPWR VGND sky130_ef_sc_hd__decap_12
XFILLER_93_621 VPWR VGND VPWR VGND sky130_ef_sc_hd__decap_12
XPHY_EDGE_ROW_69_Left_223 VGND VGND VPWR VPWR sky130_fd_sc_hd__decap_3
XFILLER_65_301 VGND VGND VPWR VPWR sky130_fd_sc_hd__fill_2
X_2181_ _1425_ _1427_ _1424_ VGND VGND VPWR VPWR _1438_ sky130_fd_sc_hd__a21oi_1
XFILLER_65_334 VGND VGND VPWR VPWR sky130_fd_sc_hd__fill_2
XTAP_TAPCELL_ROW_0_308 VGND VPWR sky130_fd_sc_hd__tapvpwrvgnd_1
XFILLER_92_153 VPWR VGND VPWR VGND sky130_ef_sc_hd__decap_12
XTAP_TAPCELL_ROW_0_319 VGND VPWR sky130_fd_sc_hd__tapvpwrvgnd_1
XFILLER_92_197 VPWR VGND VPWR VGND sky130_ef_sc_hd__decap_12
XPHY_EDGE_ROW_87_Right_87 VGND VGND VPWR VPWR sky130_fd_sc_hd__decap_3
XTAP_TAPCELL_ROW_29_790 VGND VPWR sky130_fd_sc_hd__tapvpwrvgnd_1
XFILLER_22_905 VGND VGND VPWR VPWR sky130_fd_sc_hd__decap_4
XANTENNA__3201__B _0912_ VGND VGND VPWR VPWR sky130_fd_sc_hd__diode_2
X_1965_ _1223_ _1229_ _1227_ VGND VGND VPWR VPWR _1230_ sky130_fd_sc_hd__a21oi_1
XPHY_EDGE_ROW_78_Left_232 VGND VGND VPWR VPWR sky130_fd_sc_hd__decap_3
XFILLER_146_133 VGND VGND VPWR VPWR sky130_fd_sc_hd__decap_6
X_1896_ net35 CRT_Done CU_state_dbg\[2\] VGND VGND VPWR VPWR _1164_ sky130_fd_sc_hd__mux2_1
XFILLER_146_177 VPWR VGND VPWR VGND sky130_ef_sc_hd__decap_12
XFILLER_128_881 VPWR VGND VPWR VGND sky130_ef_sc_hd__decap_12
XPHY_EDGE_ROW_96_Right_96 VGND VGND VPWR VPWR sky130_fd_sc_hd__decap_3
XFILLER_127_391 VGND VGND VPWR VPWR sky130_fd_sc_hd__fill_1
XFILLER_108_27 VGND VGND VPWR VPWR sky130_fd_sc_hd__fill_1
XTAP_TAPCELL_ROW_73_1504 VGND VPWR sky130_fd_sc_hd__tapvpwrvgnd_1
XFILLER_1_809 VPWR VGND VPWR VGND sky130_ef_sc_hd__decap_12
XFILLER_143_895 VGND VGND VPWR VPWR sky130_fd_sc_hd__fill_1
XFILLER_130_501 VPWR VGND VPWR VGND sky130_ef_sc_hd__decap_12
XFILLER_115_553 VGND VGND VPWR VPWR sky130_fd_sc_hd__decap_6
X_2517_ _0224_ _0254_ _0264_ VGND VGND VPWR VPWR _0265_ sky130_fd_sc_hd__and3_1
XFILLER_130_545 VPWR VGND VPWR VGND sky130_ef_sc_hd__decap_12
XFILLER_115_597 VPWR VGND VPWR VGND sky130_ef_sc_hd__decap_12
X_2448_ a_r0\[1\] b_r0\[1\] VGND VGND VPWR VPWR _0198_ sky130_fd_sc_hd__nand2_1
XFILLER_124_15 VPWR VGND VPWR VGND sky130_ef_sc_hd__decap_12
XPHY_EDGE_ROW_87_Left_241 VGND VGND VPWR VPWR sky130_fd_sc_hd__decap_3
XFILLER_130_589 VPWR VGND VPWR VGND sky130_ef_sc_hd__decap_12
X_2379_ _0126_ _0127_ _0129_ _0131_ VGND VGND VPWR VPWR _0133_ sky130_fd_sc_hd__a22o_1
XFILLER_69_673 VPWR VGND VPWR VGND sky130_ef_sc_hd__decap_12
XFILLER_84_643 VGND VGND VPWR VPWR sky130_fd_sc_hd__fill_1
XFILLER_68_183 VGND VGND VPWR VPWR sky130_fd_sc_hd__fill_1
XFILLER_56_345 VPWR VGND VPWR VGND sky130_ef_sc_hd__decap_12
XFILLER_29_559 VGND VGND VPWR VPWR sky130_fd_sc_hd__fill_1
XTAP_TAPCELL_ROW_104_2003 VGND VPWR sky130_fd_sc_hd__tapvpwrvgnd_1
XFILLER_16_209 VPWR VGND VPWR VGND sky130_ef_sc_hd__decap_12
XFILLER_72_849 VPWR VGND VPWR VGND sky130_ef_sc_hd__decap_12
XFILLER_71_337 VPWR VGND VPWR VGND sky130_ef_sc_hd__decap_12
XFILLER_17_57 VPWR VGND VPWR VGND sky130_ef_sc_hd__decap_12
XFILLER_25_721 VGND VGND VPWR VPWR sky130_fd_sc_hd__decap_6
XTAP_TAPCELL_ROW_84_1677 VGND VPWR sky130_fd_sc_hd__tapvpwrvgnd_1
XFILLER_24_253 VPWR VGND VPWR VGND sky130_ef_sc_hd__decap_12
XFILLER_25_765 VPWR VGND VPWR VGND sky130_ef_sc_hd__decap_12
XPHY_EDGE_ROW_96_Left_250 VGND VGND VPWR VPWR sky130_fd_sc_hd__decap_3
XFILLER_80_893 VPWR VGND VPWR VGND sky130_ef_sc_hd__decap_12
XFILLER_9_909 VGND VGND VPWR VPWR sky130_fd_sc_hd__fill_1
XFILLER_40_713 VPWR VGND VPWR VGND sky130_ef_sc_hd__decap_12
XFILLER_138_601 VPWR VGND VPWR VGND sky130_ef_sc_hd__decap_12
XFILLER_40_757 VGND VGND VPWR VPWR sky130_fd_sc_hd__decap_8
XFILLER_138_645 VPWR VGND VPWR VGND sky130_ef_sc_hd__decap_12
XFILLER_137_111 VGND VGND VPWR VPWR sky130_fd_sc_hd__fill_1
XANTENNA__1847__A A_reg\[11\] VGND VGND VPWR VPWR sky130_fd_sc_hd__diode_2
XFILLER_125_317 VPWR VGND VPWR VGND sky130_ef_sc_hd__decap_12
XFILLER_116_3 VPWR VGND VPWR VGND sky130_ef_sc_hd__decap_12
XTAP_TAPCELL_ROW_115_2176 VGND VPWR sky130_fd_sc_hd__tapvpwrvgnd_1
XTAP_TAPCELL_ROW_115_2165 VGND VPWR sky130_fd_sc_hd__tapvpwrvgnd_1
XFILLER_106_531 VGND VGND VPWR VPWR sky130_fd_sc_hd__fill_1
XFILLER_3_113 VPWR VGND VPWR VGND sky130_ef_sc_hd__decap_12
XFILLER_140_309 VPWR VGND VPWR VGND sky130_ef_sc_hd__decap_12
XFILLER_133_361 VPWR VGND VPWR VGND sky130_ef_sc_hd__decap_12
XANTENNA__2678__A OpSel_reg\[0\] VGND VGND VPWR VPWR sky130_fd_sc_hd__diode_2
XTAP_TAPCELL_ROW_7_441 VGND VPWR sky130_fd_sc_hd__tapvpwrvgnd_1
XFILLER_0_853 VPWR VGND VPWR VGND sky130_ef_sc_hd__decap_12
XFILLER_102_781 VPWR VGND VPWR VGND sky130_ef_sc_hd__decap_12
XFILLER_59_150 VPWR VGND VPWR VGND sky130_ef_sc_hd__decap_12
XFILLER_58_97 VPWR VGND VPWR VGND sky130_ef_sc_hd__decap_12
XFILLER_48_813 VGND VGND VPWR VPWR sky130_fd_sc_hd__decap_6
XFILLER_0_897 VPWR VGND VPWR VGND sky130_ef_sc_hd__decap_12
XANTENNA_input36_A rst_n VGND VGND VPWR VPWR sky130_fd_sc_hd__diode_2
XFILLER_74_153 VPWR VGND VPWR VGND sky130_ef_sc_hd__decap_12
XFILLER_74_41 VPWR VGND VPWR VGND sky130_ef_sc_hd__decap_12
XFILLER_35_529 VPWR VGND VPWR VGND sky130_ef_sc_hd__decap_12
XFILLER_47_389 VGND VGND VPWR VPWR sky130_fd_sc_hd__decap_3
XFILLER_90_657 VPWR VGND VPWR VGND sky130_ef_sc_hd__decap_12
XFILLER_74_197 VPWR VGND VPWR VGND sky130_ef_sc_hd__decap_12
XFILLER_28_581 VGND VGND VPWR VPWR sky130_fd_sc_hd__decap_6
XFILLER_62_359 VGND VGND VPWR VPWR sky130_fd_sc_hd__decap_4
XFILLER_43_540 VPWR VGND VPWR VGND sky130_ef_sc_hd__decap_12
XFILLER_43_573 VPWR VGND VPWR VGND sky130_ef_sc_hd__decap_12
XFILLER_30_223 VPWR VGND VPWR VGND sky130_ef_sc_hd__decap_12
X_1750_ A_reg\[10\] _1022_ VGND VGND VPWR VPWR _1023_ sky130_fd_sc_hd__or2_1
XFILLER_30_289 VPWR VGND VPWR VGND sky130_ef_sc_hd__decap_12
XFILLER_128_133 VGND VGND VPWR VPWR sky130_fd_sc_hd__decap_6
XFILLER_11_481 VPWR VGND VPWR VGND sky130_ef_sc_hd__decap_12
XFILLER_144_637 VGND VGND VPWR VPWR sky130_fd_sc_hd__decap_6
XFILLER_128_177 VPWR VGND VPWR VGND sky130_ef_sc_hd__decap_12
X_1681_ _0892_ _0952_ _0955_ VGND VGND VPWR VPWR _0957_ sky130_fd_sc_hd__a21o_1
XFILLER_143_125 VPWR VGND VPWR VGND sky130_ef_sc_hd__decap_12
XFILLER_109_391 VGND VGND VPWR VPWR sky130_fd_sc_hd__fill_1
XFILLER_143_169 VPWR VGND VPWR VGND sky130_ef_sc_hd__decap_12
XFILLER_112_501 VGND VGND VPWR VPWR sky130_fd_sc_hd__fill_1
XFILLER_99_93 VPWR VGND VPWR VGND sky130_ef_sc_hd__decap_12
XFILLER_98_713 VPWR VGND VPWR VGND sky130_ef_sc_hd__decap_12
XTAP_TAPCELL_ROW_55_1212 VGND VPWR sky130_fd_sc_hd__tapvpwrvgnd_1
XFILLER_152_681 VPWR VGND VPWR VGND sky130_ef_sc_hd__decap_12
XFILLER_125_895 VGND VGND VPWR VPWR sky130_fd_sc_hd__fill_1
XFILLER_98_757 VPWR VGND VPWR VGND sky130_ef_sc_hd__decap_12
X_2302_ _1177_ _1174_ VGND VGND VPWR VPWR _1555_ sky130_fd_sc_hd__nand2b_1
XFILLER_31_3 VPWR VGND VPWR VGND sky130_ef_sc_hd__decap_12
XFILLER_112_545 VPWR VGND VPWR VGND sky130_ef_sc_hd__decap_12
X_3282_ clknet_3_1__leaf_clk _0065_ net36 VGND VGND VPWR VPWR A_reg\[8\] sky130_fd_sc_hd__dfrtp_4
XFILLER_112_589 VPWR VGND VPWR VGND sky130_ef_sc_hd__decap_12
XFILLER_85_429 VPWR VGND VPWR VGND sky130_ef_sc_hd__decap_12
X_2233_ A_reg\[5\] _1486_ _1479_ VGND VGND VPWR VPWR _1490_ sky130_fd_sc_hd__a21oi_1
XFILLER_66_643 VGND VGND VPWR VPWR sky130_fd_sc_hd__fill_1
X_2164_ A_reg\[10\] _1420_ VGND VGND VPWR VPWR _1421_ sky130_fd_sc_hd__nand2_1
XFILLER_38_389 VPWR VGND VPWR VGND sky130_ef_sc_hd__decap_12
XFILLER_80_123 VGND VGND VPWR VPWR sky130_fd_sc_hd__decap_4
XFILLER_53_337 VGND VGND VPWR VPWR sky130_fd_sc_hd__decap_8
X_2095_ b_r1\[2\] _1354_ Encode_EN VGND VGND VPWR VPWR _0016_ sky130_fd_sc_hd__mux2_1
XFILLER_62_871 VGND VGND VPWR VPWR sky130_fd_sc_hd__decap_8
XTAP_TAPCELL_ROW_24_708 VGND VPWR sky130_fd_sc_hd__tapvpwrvgnd_1
XTAP_TAPCELL_ROW_66_1385 VGND VPWR sky130_fd_sc_hd__tapvpwrvgnd_1
XFILLER_22_713 VPWR VGND VPWR VGND sky130_ef_sc_hd__decap_12
XTAP_TAPCELL_ROW_24_719 VGND VPWR sky130_fd_sc_hd__tapvpwrvgnd_1
XFILLER_21_223 VGND VGND VPWR VPWR sky130_fd_sc_hd__fill_1
XFILLER_22_757 VPWR VGND VPWR VGND sky130_ef_sc_hd__decap_12
XFILLER_119_111 VGND VGND VPWR VPWR sky130_fd_sc_hd__fill_1
X_2997_ _0683_ _0684_ VGND VGND VPWR VPWR _0685_ sky130_fd_sc_hd__or2_1
XFILLER_119_15 VPWR VGND VPWR VGND sky130_ef_sc_hd__decap_12
X_1948_ _1212_ VGND VGND VPWR VPWR _1213_ sky130_fd_sc_hd__inv_2
XFILLER_147_497 VGND VGND VPWR VPWR sky130_fd_sc_hd__decap_6
XFILLER_135_615 VGND VGND VPWR VPWR sky130_fd_sc_hd__fill_1
XFILLER_107_317 VPWR VGND VPWR VGND sky130_ef_sc_hd__decap_12
X_1879_ _0895_ _1148_ VGND VGND VPWR VPWR _1149_ sky130_fd_sc_hd__nor2_1
XFILLER_122_309 VPWR VGND VPWR VGND sky130_ef_sc_hd__decap_12
XFILLER_115_361 VPWR VGND VPWR VGND sky130_ef_sc_hd__decap_12
XFILLER_1_617 VPWR VGND VPWR VGND sky130_ef_sc_hd__decap_12
XFILLER_131_821 VPWR VGND VPWR VGND sky130_ef_sc_hd__decap_12
XFILLER_135_69 VPWR VGND VPWR VGND sky130_ef_sc_hd__decap_12
XFILLER_131_865 VPWR VGND VPWR VGND sky130_ef_sc_hd__decap_12
XTAP_TAPCELL_ROW_110_2084 VGND VPWR sky130_fd_sc_hd__tapvpwrvgnd_1
XTAP_TAPCELL_ROW_4_400 VGND VPWR sky130_fd_sc_hd__tapvpwrvgnd_1
XTAP_TAPCELL_ROW_110_2095 VGND VPWR sky130_fd_sc_hd__tapvpwrvgnd_1
XFILLER_48_109 VPWR VGND VPWR VGND sky130_ef_sc_hd__decap_12
XFILLER_29_301 VGND VGND VPWR VPWR sky130_fd_sc_hd__fill_2
XFILLER_151_57 VPWR VGND VPWR VGND sky130_ef_sc_hd__decap_12
XTAP_TAPCELL_ROW_86_1706 VGND VPWR sky130_fd_sc_hd__tapvpwrvgnd_1
XFILLER_72_613 VPWR VGND VPWR VGND sky130_ef_sc_hd__decap_12
XFILLER_57_665 VGND VGND VPWR VPWR sky130_fd_sc_hd__decap_6
XFILLER_56_153 VPWR VGND VPWR VGND sky130_ef_sc_hd__decap_12
XFILLER_17_529 VPWR VGND VPWR VGND sky130_ef_sc_hd__decap_12
XFILLER_72_657 VPWR VGND VPWR VGND sky130_ef_sc_hd__decap_12
XFILLER_56_197 VPWR VGND VPWR VGND sky130_ef_sc_hd__decap_12
XFILLER_71_156 VPWR VGND VPWR VGND sky130_ef_sc_hd__decap_12
XFILLER_25_573 VPWR VGND VPWR VGND sky130_ef_sc_hd__decap_12
XFILLER_44_77 VGND VGND VPWR VPWR sky130_fd_sc_hd__decap_6
XFILLER_12_245 VGND VGND VPWR VPWR sky130_fd_sc_hd__decap_6
XTAP_TAPCELL_ROW_117_2205 VGND VPWR sky130_fd_sc_hd__tapvpwrvgnd_1
XFILLER_40_587 VGND VGND VPWR VPWR sky130_fd_sc_hd__fill_1
XFILLER_100_83 VGND VGND VPWR VPWR sky130_fd_sc_hd__fill_1
XFILLER_138_475 VGND VGND VPWR VPWR sky130_fd_sc_hd__fill_1
XFILLER_126_637 VGND VGND VPWR VPWR sky130_fd_sc_hd__decap_6
XFILLER_153_445 VGND VGND VPWR VPWR sky130_fd_sc_hd__decap_3
XTAP_TAPCELL_ROW_130_2416 VGND VPWR sky130_fd_sc_hd__tapvpwrvgnd_1
XTAP_TAPCELL_ROW_130_2405 VGND VPWR sky130_fd_sc_hd__tapvpwrvgnd_1
XFILLER_125_125 VPWR VGND VPWR VGND sky130_ef_sc_hd__decap_12
XTAP_TAPCELL_ROW_97_1879 VGND VPWR sky130_fd_sc_hd__tapvpwrvgnd_1
XFILLER_5_27 VPWR VGND VPWR VGND sky130_ef_sc_hd__decap_12
XFILLER_4_433 VPWR VGND VPWR VGND sky130_ef_sc_hd__decap_12
XFILLER_153_489 VPWR VGND VPWR VGND sky130_ef_sc_hd__decap_12
XFILLER_141_629 VPWR VGND VPWR VGND sky130_ef_sc_hd__decap_12
XFILLER_125_169 VPWR VGND VPWR VGND sky130_ef_sc_hd__decap_12
XFILLER_109_81 VPWR VGND VPWR VGND sky130_ef_sc_hd__decap_12
XFILLER_4_477 VGND VGND VPWR VPWR sky130_fd_sc_hd__decap_4
XFILLER_140_139 VGND VGND VPWR VPWR sky130_fd_sc_hd__fill_1
XFILLER_134_681 VPWR VGND VPWR VGND sky130_ef_sc_hd__decap_12
XFILLER_107_895 VGND VGND VPWR VPWR sky130_fd_sc_hd__fill_1
XANTENNA__3180__A2 CRT_Start VGND VGND VPWR VPWR sky130_fd_sc_hd__diode_2
XFILLER_95_727 VGND VGND VPWR VPWR sky130_fd_sc_hd__fill_1
XFILLER_79_278 VGND VGND VPWR VPWR sky130_fd_sc_hd__fill_2
XTAP_TAPCELL_ROW_50_1131 VGND VPWR sky130_fd_sc_hd__tapvpwrvgnd_1
XANTENNA__3273__RESET_B net36 VGND VGND VPWR VPWR sky130_fd_sc_hd__diode_2
XTAP_TAPCELL_ROW_128_2378 VGND VPWR sky130_fd_sc_hd__tapvpwrvgnd_1
XFILLER_75_473 VPWR VGND VPWR VGND sky130_ef_sc_hd__decap_12
XFILLER_36_805 VGND VGND VPWR VPWR sky130_fd_sc_hd__decap_6
XFILLER_90_421 VPWR VGND VPWR VGND sky130_ef_sc_hd__decap_12
XFILLER_35_337 VPWR VGND VPWR VGND sky130_ef_sc_hd__decap_12
XANTENNA_clkload1_A clknet_3_1__leaf_clk VGND VGND VPWR VPWR sky130_fd_sc_hd__diode_2
XTAP_TAPCELL_ROW_141_2589 VGND VPWR sky130_fd_sc_hd__tapvpwrvgnd_1
X_2920_ _0574_ _0580_ VGND VGND VPWR VPWR _0608_ sky130_fd_sc_hd__nand2_1
XANTENNA__2871__A _0554_ VGND VGND VPWR VPWR sky130_fd_sc_hd__diode_2
XFILLER_50_307 VGND VGND VPWR VPWR sky130_fd_sc_hd__fill_1
XFILLER_44_893 VPWR VGND VPWR VGND sky130_ef_sc_hd__decap_12
XFILLER_149_729 VPWR VGND VPWR VGND sky130_ef_sc_hd__decap_12
XTAP_TAPCELL_ROW_48_1093 VGND VPWR sky130_fd_sc_hd__tapvpwrvgnd_1
X_2851_ net24 B_reg\[1\] _0383_ VGND VGND VPWR VPWR _0074_ sky130_fd_sc_hd__mux2_1
XFILLER_31_576 VPWR VGND VPWR VGND sky130_ef_sc_hd__decap_12
X_2782_ _0516_ _0521_ _0517_ VGND VGND VPWR VPWR _0522_ sky130_fd_sc_hd__o21ba_1
X_1802_ _1074_ _1068_ _1063_ VGND VGND VPWR VPWR _1075_ sky130_fd_sc_hd__mux2_1
XFILLER_144_401 VPWR VGND VPWR VGND sky130_ef_sc_hd__decap_12
XFILLER_117_615 VGND VGND VPWR VPWR sky130_fd_sc_hd__fill_1
X_1733_ a_r2\[2\] _0911_ _1000_ _1006_ VGND VGND VPWR VPWR _0002_ sky130_fd_sc_hd__a22o_1
XFILLER_144_445 VPWR VGND VPWR VGND sky130_ef_sc_hd__decap_12
XFILLER_129_497 VGND VGND VPWR VPWR sky130_fd_sc_hd__decap_6
XFILLER_7_293 VPWR VGND VPWR VGND sky130_ef_sc_hd__decap_12
XFILLER_144_489 VPWR VGND VPWR VGND sky130_ef_sc_hd__decap_12
XFILLER_104_309 VPWR VGND VPWR VGND sky130_ef_sc_hd__decap_12
X_1664_ _0939_ VGND VGND VPWR VPWR _0940_ sky130_fd_sc_hd__inv_2
XFILLER_113_821 VPWR VGND VPWR VGND sky130_ef_sc_hd__decap_12
XFILLER_113_865 VPWR VGND VPWR VGND sky130_ef_sc_hd__decap_12
XFILLER_98_587 VGND VGND VPWR VPWR sky130_fd_sc_hd__fill_1
X_3265_ clknet_3_7__leaf_clk _0048_ net36 VGND VGND VPWR VPWR net51 sky130_fd_sc_hd__dfrtp_1
XFILLER_85_248 VGND VGND VPWR VPWR sky130_fd_sc_hd__fill_2
XFILLER_85_237 VGND VGND VPWR VPWR sky130_fd_sc_hd__fill_2
X_2216_ _1459_ _1461_ _1472_ VGND VGND VPWR VPWR _1473_ sky130_fd_sc_hd__a21o_1
XTAP_TAPCELL_ROW_68_1414 VGND VPWR sky130_fd_sc_hd__tapvpwrvgnd_1
X_3196_ _0848_ _0876_ VGND VGND VPWR VPWR _0877_ sky130_fd_sc_hd__xnor2_1
XFILLER_38_153 VPWR VGND VPWR VGND sky130_ef_sc_hd__decap_12
XFILLER_39_665 VGND VGND VPWR VPWR sky130_fd_sc_hd__decap_6
XFILLER_94_793 VPWR VGND VPWR VGND sky130_ef_sc_hd__decap_12
XFILLER_93_281 VPWR VGND VPWR VGND sky130_ef_sc_hd__decap_12
X_2147_ _0897_ _1405_ VGND VGND VPWR VPWR _1406_ sky130_fd_sc_hd__xnor2_1
XTAP_TAPCELL_ROW_68_1425 VGND VPWR sky130_fd_sc_hd__tapvpwrvgnd_1
XFILLER_38_197 VPWR VGND VPWR VGND sky130_ef_sc_hd__decap_12
XFILLER_121_27 VPWR VGND VPWR VGND sky130_ef_sc_hd__decap_12
X_2078_ B_reg\[1\] _1339_ VGND VGND VPWR VPWR _1340_ sky130_fd_sc_hd__nor2_1
XFILLER_54_657 VGND VGND VPWR VPWR sky130_fd_sc_hd__decap_4
XPHY_EDGE_ROW_138_Right_138 VGND VGND VPWR VPWR sky130_fd_sc_hd__decap_3
XANTENNA__2434__A1 OpSel_reg\[0\] VGND VGND VPWR VPWR sky130_fd_sc_hd__diode_2
XTAP_TAPCELL_ROW_81_1625 VGND VPWR sky130_fd_sc_hd__tapvpwrvgnd_1
XFILLER_139_217 VGND VGND VPWR VPWR sky130_fd_sc_hd__decap_6
XFILLER_22_587 VGND VGND VPWR VPWR sky130_fd_sc_hd__fill_1
XFILLER_10_749 VGND VGND VPWR VPWR sky130_fd_sc_hd__decap_6
XFILLER_147_261 VPWR VGND VPWR VGND sky130_ef_sc_hd__decap_12
XFILLER_108_637 VGND VGND VPWR VPWR sky130_fd_sc_hd__decap_6
XFILLER_107_125 VPWR VGND VPWR VGND sky130_ef_sc_hd__decap_12
XFILLER_123_629 VPWR VGND VPWR VGND sky130_ef_sc_hd__decap_12
XTAP_TAPCELL_ROW_112_2124 VGND VPWR sky130_fd_sc_hd__tapvpwrvgnd_1
XFILLER_107_169 VPWR VGND VPWR VGND sky130_ef_sc_hd__decap_12
XTAP_TAPCELL_ROW_79_1598 VGND VPWR sky130_fd_sc_hd__tapvpwrvgnd_1
XPHY_EDGE_ROW_15_Left_169 VGND VGND VPWR VPWR sky130_fd_sc_hd__decap_3
XFILLER_122_139 VGND VGND VPWR VPWR sky130_fd_sc_hd__fill_1
XFILLER_116_681 VPWR VGND VPWR VGND sky130_ef_sc_hd__decap_12
XTAP_TAPCELL_ROW_92_1798 VGND VPWR sky130_fd_sc_hd__tapvpwrvgnd_1
XFILLER_1_447 VGND VGND VPWR VPWR sky130_fd_sc_hd__fill_1
XFILLER_131_673 VPWR VGND VPWR VGND sky130_ef_sc_hd__decap_12
XANTENNA__2956__A _0628_ VGND VGND VPWR VPWR sky130_fd_sc_hd__diode_2
XFILLER_39_55 VGND VGND VPWR VPWR sky130_fd_sc_hd__fill_1
XANTENNA__3230__CLK clknet_3_3__leaf_clk VGND VGND VPWR VPWR sky130_fd_sc_hd__diode_2
XFILLER_18_805 VGND VGND VPWR VPWR sky130_fd_sc_hd__decap_6
XANTENNA__2673__A1 a_r3\[1\] VGND VGND VPWR VPWR sky130_fd_sc_hd__diode_2
XFILLER_72_421 VGND VGND VPWR VPWR sky130_fd_sc_hd__decap_8
XFILLER_57_473 VPWR VGND VPWR VGND sky130_ef_sc_hd__decap_12
XFILLER_55_32 VPWR VGND VPWR VGND sky130_ef_sc_hd__decap_12
XFILLER_17_337 VPWR VGND VPWR VGND sky130_ef_sc_hd__decap_12
XFILLER_18_849 VPWR VGND VPWR VGND sky130_ef_sc_hd__decap_12
XPHY_EDGE_ROW_24_Left_178 VGND VGND VPWR VPWR sky130_fd_sc_hd__decap_3
XFILLER_33_819 VPWR VGND VPWR VGND sky130_ef_sc_hd__decap_12
XTAP_TAPCELL_ROW_123_2297 VGND VPWR sky130_fd_sc_hd__tapvpwrvgnd_1
XPHY_EDGE_ROW_105_Right_105 VGND VGND VPWR VPWR sky130_fd_sc_hd__decap_3
XANTENNA__2425__A1 Encode_EN VGND VGND VPWR VPWR sky130_fd_sc_hd__diode_2
XFILLER_26_893 VPWR VGND VPWR VGND sky130_ef_sc_hd__decap_12
XFILLER_41_841 VPWR VGND VPWR VGND sky130_ef_sc_hd__decap_12
XFILLER_111_93 VPWR VGND VPWR VGND sky130_ef_sc_hd__decap_12
XTAP_TAPCELL_ROW_99_1919 VGND VPWR sky130_fd_sc_hd__tapvpwrvgnd_1
XTAP_TAPCELL_ROW_99_1908 VGND VPWR sky130_fd_sc_hd__tapvpwrvgnd_1
XFILLER_40_351 VPWR VGND VPWR VGND sky130_ef_sc_hd__decap_12
XFILLER_126_401 VPWR VGND VPWR VGND sky130_ef_sc_hd__decap_12
XANTENNA__3295__Q B_reg\[5\] VGND VGND VPWR VPWR sky130_fd_sc_hd__diode_2
XFILLER_126_445 VPWR VGND VPWR VGND sky130_ef_sc_hd__decap_12
XPHY_EDGE_ROW_33_Left_187 VGND VGND VPWR VPWR sky130_fd_sc_hd__decap_3
XFILLER_153_253 VPWR VGND VPWR VGND sky130_ef_sc_hd__decap_12
XFILLER_142_905 VGND VGND VPWR VPWR sky130_fd_sc_hd__decap_4
XFILLER_5_753 VPWR VGND VPWR VGND sky130_ef_sc_hd__decap_12
XFILLER_126_489 VPWR VGND VPWR VGND sky130_ef_sc_hd__decap_12
XFILLER_5_797 VPWR VGND VPWR VGND sky130_ef_sc_hd__decap_12
XFILLER_4_296 VPWR VGND VPWR VGND sky130_ef_sc_hd__decap_12
XFILLER_121_161 VGND VGND VPWR VPWR sky130_fd_sc_hd__decap_6
XFILLER_110_813 VPWR VGND VPWR VGND sky130_ef_sc_hd__decap_12
XFILLER_67_215 VGND VGND VPWR VPWR sky130_fd_sc_hd__decap_8
XFILLER_96_83 VGND VGND VPWR VPWR sky130_fd_sc_hd__fill_1
XFILLER_67_237 VPWR VGND VPWR VGND sky130_ef_sc_hd__decap_12
X_3050_ _0723_ _0724_ VGND VGND VPWR VPWR _0738_ sky130_fd_sc_hd__xor2_1
XANTENNA__1770__A A_reg\[9\] VGND VGND VPWR VPWR sky130_fd_sc_hd__diode_2
XTAP_TAPCELL_ROW_143_2618 VGND VPWR sky130_fd_sc_hd__tapvpwrvgnd_1
X_2001_ _1261_ _1262_ VGND VGND VPWR VPWR _1263_ sky130_fd_sc_hd__nand2_1
XPHY_EDGE_ROW_42_Left_196 VGND VGND VPWR VPWR sky130_fd_sc_hd__decap_3
XFILLER_75_281 VPWR VGND VPWR VGND sky130_ef_sc_hd__decap_12
XFILLER_36_613 VPWR VGND VPWR VGND sky130_ef_sc_hd__decap_12
XFILLER_91_741 VPWR VGND VPWR VGND sky130_ef_sc_hd__decap_12
XFILLER_63_454 VPWR VGND VPWR VGND sky130_ef_sc_hd__decap_12
XFILLER_36_657 VPWR VGND VPWR VGND sky130_ef_sc_hd__decap_12
XFILLER_91_785 VPWR VGND VPWR VGND sky130_ef_sc_hd__decap_12
XFILLER_35_167 VGND VGND VPWR VPWR sky130_fd_sc_hd__fill_1
XFILLER_90_295 VPWR VGND VPWR VGND sky130_ef_sc_hd__decap_12
XTAP_TAPCELL_ROW_63_1344 VGND VPWR sky130_fd_sc_hd__tapvpwrvgnd_1
XTAP_TAPCELL_ROW_63_1333 VGND VPWR sky130_fd_sc_hd__tapvpwrvgnd_1
X_2903_ _0574_ _0581_ VGND VGND VPWR VPWR _0591_ sky130_fd_sc_hd__nand2_1
XTAP_TAPCELL_ROW_34_869 VGND VPWR sky130_fd_sc_hd__tapvpwrvgnd_1
XFILLER_149_559 VGND VGND VPWR VPWR sky130_fd_sc_hd__fill_1
XTAP_TAPCELL_ROW_14_560 VGND VPWR sky130_fd_sc_hd__tapvpwrvgnd_1
X_2834_ net1 A_reg\[0\] _0383_ VGND VGND VPWR VPWR _0057_ sky130_fd_sc_hd__mux2_1
XFILLER_31_373 VGND VGND VPWR VPWR sky130_fd_sc_hd__fill_1
XFILLER_136_209 VPWR VGND VPWR VGND sky130_ef_sc_hd__decap_12
XFILLER_129_261 VPWR VGND VPWR VGND sky130_ef_sc_hd__decap_12
XFILLER_145_721 VGND VGND VPWR VPWR sky130_fd_sc_hd__decap_6
X_2765_ _0461_ _0504_ VGND VGND VPWR VPWR _0505_ sky130_fd_sc_hd__or2_1
XFILLER_145_765 VPWR VGND VPWR VGND sky130_ef_sc_hd__decap_12
XFILLER_144_253 VPWR VGND VPWR VGND sky130_ef_sc_hd__decap_12
X_2696_ _0433_ _0435_ _0421_ VGND VGND VPWR VPWR _0436_ sky130_fd_sc_hd__and3b_1
X_1716_ A_reg\[1\] _0984_ _0989_ _0991_ VGND VGND VPWR VPWR _0992_ sky130_fd_sc_hd__a31o_1
XFILLER_105_629 VPWR VGND VPWR VGND sky130_ef_sc_hd__decap_12
XANTENNA__3253__CLK clknet_3_6__leaf_clk VGND VGND VPWR VPWR sky130_fd_sc_hd__diode_2
X_1647_ A_reg\[14\] A_reg\[15\] VGND VGND VPWR VPWR _0923_ sky130_fd_sc_hd__nand2b_1
XFILLER_116_27 VGND VGND VPWR VPWR sky130_fd_sc_hd__fill_1
XFILLER_104_139 VGND VGND VPWR VPWR sky130_fd_sc_hd__fill_1
XFILLER_99_841 VPWR VGND VPWR VGND sky130_ef_sc_hd__decap_12
XFILLER_113_673 VPWR VGND VPWR VGND sky130_ef_sc_hd__decap_12
XFILLER_100_301 VGND VGND VPWR VPWR sky130_fd_sc_hd__decap_6
XFILLER_98_362 VGND VGND VPWR VPWR sky130_fd_sc_hd__fill_2
X_3317_ clknet_3_5__leaf_clk _0100_ net36 VGND VGND VPWR VPWR X_crt\[11\] sky130_fd_sc_hd__dfrtp_1
XFILLER_86_557 VPWR VGND VPWR VGND sky130_ef_sc_hd__decap_12
XFILLER_132_15 VPWR VGND VPWR VGND sky130_ef_sc_hd__decap_12
XFILLER_100_345 VPWR VGND VPWR VGND sky130_ef_sc_hd__decap_12
X_3248_ clknet_3_6__leaf_clk _0033_ net36 VGND VGND VPWR VPWR u_crt.r2\[1\] sky130_fd_sc_hd__dfrtp_4
XFILLER_67_771 VPWR VGND VPWR VGND sky130_ef_sc_hd__decap_12
XFILLER_54_421 VPWR VGND VPWR VGND sky130_ef_sc_hd__decap_12
XFILLER_54_410 VGND VGND VPWR VPWR sky130_fd_sc_hd__decap_8
XFILLER_39_473 VPWR VGND VPWR VGND sky130_ef_sc_hd__decap_12
X_3179_ _0835_ _0863_ _0912_ VGND VGND VPWR VPWR _0865_ sky130_fd_sc_hd__a21o_1
XFILLER_81_273 VGND VGND VPWR VPWR sky130_fd_sc_hd__decap_6
XFILLER_14_307 VGND VGND VPWR VPWR sky130_fd_sc_hd__fill_1
XFILLER_26_189 VGND VGND VPWR VPWR sky130_fd_sc_hd__decap_6
XFILLER_23_841 VPWR VGND VPWR VGND sky130_ef_sc_hd__decap_12
XFILLER_25_57 VPWR VGND VPWR VGND sky130_ef_sc_hd__decap_12
XFILLER_41_137 VPWR VGND VPWR VGND sky130_ef_sc_hd__decap_12
XFILLER_50_693 VGND VGND VPWR VPWR sky130_fd_sc_hd__decap_6
XFILLER_10_513 VPWR VGND VPWR VGND sky130_ef_sc_hd__decap_12
XTAP_TAPCELL_ROW_12_519 VGND VPWR sky130_fd_sc_hd__tapvpwrvgnd_1
XFILLER_10_557 VPWR VGND VPWR VGND sky130_ef_sc_hd__decap_12
XFILLER_148_581 VGND VGND VPWR VPWR sky130_fd_sc_hd__decap_6
XFILLER_124_905 VGND VGND VPWR VPWR sky130_fd_sc_hd__decap_4
XTAP_TAPCELL_ROW_94_1838 VGND VPWR sky130_fd_sc_hd__tapvpwrvgnd_1
XFILLER_108_489 VPWR VGND VPWR VGND sky130_ef_sc_hd__decap_12
XFILLER_2_701 VPWR VGND VPWR VGND sky130_ef_sc_hd__decap_12
XFILLER_150_245 VGND VGND VPWR VPWR sky130_fd_sc_hd__decap_6
XFILLER_9_3 VPWR VGND VPWR VGND sky130_ef_sc_hd__decap_12
XFILLER_150_289 VPWR VGND VPWR VGND sky130_ef_sc_hd__decap_12
XFILLER_110_109 VPWR VGND VPWR VGND sky130_ef_sc_hd__decap_12
XFILLER_103_161 VGND VGND VPWR VPWR sky130_fd_sc_hd__decap_6
XFILLER_89_395 VPWR VGND VPWR VGND sky130_ef_sc_hd__decap_12
XFILLER_49_237 VPWR VGND VPWR VGND sky130_ef_sc_hd__decap_12
XTAP_TAPCELL_ROW_125_2326 VGND VPWR sky130_fd_sc_hd__tapvpwrvgnd_1
XTAP_TAPCELL_ROW_125_2337 VGND VPWR sky130_fd_sc_hd__tapvpwrvgnd_1
XFILLER_66_75 VGND VGND VPWR VPWR sky130_fd_sc_hd__fill_1
XFILLER_58_793 VPWR VGND VPWR VGND sky130_ef_sc_hd__decap_12
XFILLER_57_281 VPWR VGND VPWR VGND sky130_ef_sc_hd__decap_12
XFILLER_18_613 VPWR VGND VPWR VGND sky130_ef_sc_hd__decap_12
XFILLER_73_741 VPWR VGND VPWR VGND sky130_ef_sc_hd__decap_12
XFILLER_18_657 VPWR VGND VPWR VGND sky130_ef_sc_hd__decap_12
XFILLER_45_443 VGND VGND VPWR VPWR sky130_fd_sc_hd__decap_4
XFILLER_73_785 VPWR VGND VPWR VGND sky130_ef_sc_hd__decap_12
XFILLER_72_251 VGND VGND VPWR VPWR sky130_fd_sc_hd__fill_1
XFILLER_60_413 VGND VGND VPWR VPWR sky130_fd_sc_hd__decap_6
XFILLER_17_167 VGND VGND VPWR VPWR sky130_fd_sc_hd__fill_1
XTAP_TAPCELL_ROW_103_1978 VGND VPWR sky130_fd_sc_hd__tapvpwrvgnd_1
XFILLER_82_85 VGND VGND VPWR VPWR sky130_fd_sc_hd__fill_2
XFILLER_60_457 VPWR VGND VPWR VGND sky130_ef_sc_hd__decap_12
XTAP_TAPCELL_ROW_45_1052 VGND VPWR sky130_fd_sc_hd__tapvpwrvgnd_1
XFILLER_13_384 VGND VGND VPWR VPWR sky130_fd_sc_hd__fill_1
XTAP_TAPCELL_ROW_31_828 VGND VPWR sky130_fd_sc_hd__tapvpwrvgnd_1
XFILLER_118_209 VPWR VGND VPWR VGND sky130_ef_sc_hd__decap_12
XFILLER_127_721 VGND VGND VPWR VPWR sky130_fd_sc_hd__decap_6
XANTENNA__3276__CLK clknet_3_0__leaf_clk VGND VGND VPWR VPWR sky130_fd_sc_hd__diode_2
XTAP_TAPCELL_ROW_153_2791 VGND VPWR sky130_fd_sc_hd__tapvpwrvgnd_1
XTAP_TAPCELL_ROW_153_2780 VGND VPWR sky130_fd_sc_hd__tapvpwrvgnd_1
XFILLER_127_765 VPWR VGND VPWR VGND sky130_ef_sc_hd__decap_12
XFILLER_126_253 VPWR VGND VPWR VGND sky130_ef_sc_hd__decap_12
X_2550_ _0297_ VGND VGND VPWR VPWR _0298_ sky130_fd_sc_hd__inv_2
XFILLER_142_713 VPWR VGND VPWR VGND sky130_ef_sc_hd__decap_12
X_2481_ _0216_ _0228_ VGND VGND VPWR VPWR _0229_ sky130_fd_sc_hd__nor2_1
XFILLER_5_561 VPWR VGND VPWR VGND sky130_ef_sc_hd__decap_12
XFILLER_142_757 VPWR VGND VPWR VGND sky130_ef_sc_hd__decap_12
XFILLER_141_223 VGND VGND VPWR VPWR sky130_fd_sc_hd__fill_1
XFILLER_99_137 VPWR VGND VPWR VGND sky130_ef_sc_hd__decap_12
XFILLER_96_811 VGND VGND VPWR VPWR sky130_fd_sc_hd__fill_1
XFILLER_68_513 VPWR VGND VPWR VGND sky130_ef_sc_hd__decap_12
XFILLER_110_643 VGND VGND VPWR VPWR sky130_fd_sc_hd__fill_1
XFILLER_68_557 VPWR VGND VPWR VGND sky130_ef_sc_hd__decap_12
XPHY_EDGE_ROW_50_Left_204 VGND VGND VPWR VPWR sky130_fd_sc_hd__decap_3
XFILLER_83_505 VPWR VGND VPWR VGND sky130_ef_sc_hd__decap_12
X_3102_ _0760_ _0789_ VGND VGND VPWR VPWR _0790_ sky130_fd_sc_hd__nand2_2
XANTENNA__3204__B _0912_ VGND VGND VPWR VPWR sky130_fd_sc_hd__diode_2
X_3033_ _0718_ _0719_ VGND VGND VPWR VPWR _0721_ sky130_fd_sc_hd__xnor2_1
XFILLER_49_771 VGND VGND VPWR VPWR sky130_fd_sc_hd__fill_1
XFILLER_64_763 VPWR VGND VPWR VGND sky130_ef_sc_hd__decap_12
XTAP_TAPCELL_ROW_19_630 VGND VPWR sky130_fd_sc_hd__tapvpwrvgnd_1
XTAP_TAPCELL_ROW_19_641 VGND VPWR sky130_fd_sc_hd__tapvpwrvgnd_1
XFILLER_102_29 VPWR VGND VPWR VGND sky130_ef_sc_hd__decap_12
XFILLER_51_446 VGND VGND VPWR VPWR sky130_fd_sc_hd__fill_2
XFILLER_23_137 VPWR VGND VPWR VGND sky130_ef_sc_hd__decap_12
XFILLER_51_468 VPWR VGND VPWR VGND sky130_ef_sc_hd__decap_12
XFILLER_20_811 VGND VGND VPWR VPWR sky130_fd_sc_hd__fill_1
XFILLER_32_693 VGND VGND VPWR VPWR sky130_fd_sc_hd__decap_6
XFILLER_137_529 VPWR VGND VPWR VGND sky130_ef_sc_hd__decap_12
XFILLER_31_181 VPWR VGND VPWR VGND sky130_ef_sc_hd__decap_12
XFILLER_11_15 VPWR VGND VPWR VGND sky130_ef_sc_hd__decap_12
X_2817_ CU_state_dbg\[1\] CU_state_dbg\[0\] CU_state_dbg\[2\] VGND VGND VPWR VPWR
+ _0553_ sky130_fd_sc_hd__and3b_4
XFILLER_127_15 VPWR VGND VPWR VGND sky130_ef_sc_hd__decap_12
X_2748_ _0451_ _0486_ VGND VGND VPWR VPWR _0488_ sky130_fd_sc_hd__nand2_1
XFILLER_106_905 VGND VGND VPWR VPWR sky130_fd_sc_hd__decap_4
XANTENNA__3305__RESET_B net36 VGND VGND VPWR VPWR sky130_fd_sc_hd__diode_2
XFILLER_145_573 VPWR VGND VPWR VGND sky130_ef_sc_hd__decap_12
XTAP_TAPCELL_ROW_76_1546 VGND VPWR sky130_fd_sc_hd__tapvpwrvgnd_1
XFILLER_132_245 VGND VGND VPWR VPWR sky130_fd_sc_hd__decap_6
X_2679_ _0417_ _0418_ VGND VGND VPWR VPWR _0419_ sky130_fd_sc_hd__and2b_1
XFILLER_99_671 VGND VGND VPWR VPWR sky130_fd_sc_hd__fill_1
XFILLER_132_289 VPWR VGND VPWR VGND sky130_ef_sc_hd__decap_12
XFILLER_101_610 VGND VGND VPWR VPWR sky130_fd_sc_hd__decap_6
XFILLER_87_833 VGND VGND VPWR VPWR sky130_fd_sc_hd__decap_6
XFILLER_143_69 VPWR VGND VPWR VGND sky130_ef_sc_hd__decap_12
XFILLER_101_665 VGND VGND VPWR VPWR sky130_fd_sc_hd__decap_6
XFILLER_87_877 VPWR VGND VPWR VGND sky130_ef_sc_hd__decap_12
XFILLER_86_365 VPWR VGND VPWR VGND sky130_ef_sc_hd__decap_12
XFILLER_59_579 VPWR VGND VPWR VGND sky130_ef_sc_hd__decap_12
XFILLER_59_557 VGND VGND VPWR VPWR sky130_fd_sc_hd__fill_1
XTAP_TAPCELL_ROW_107_2045 VGND VPWR sky130_fd_sc_hd__tapvpwrvgnd_1
XFILLER_100_153 VPWR VGND VPWR VGND sky130_ef_sc_hd__decap_12
XFILLER_100_197 VGND VGND VPWR VPWR sky130_fd_sc_hd__decap_4
XFILLER_55_741 VPWR VGND VPWR VGND sky130_ef_sc_hd__decap_12
XFILLER_39_281 VPWR VGND VPWR VGND sky130_ef_sc_hd__decap_12
XFILLER_55_785 VPWR VGND VPWR VGND sky130_ef_sc_hd__decap_12
XTAP_TAPCELL_ROW_120_2256 VGND VPWR sky130_fd_sc_hd__tapvpwrvgnd_1
XTAP_TAPCELL_ROW_120_2245 VGND VPWR sky130_fd_sc_hd__tapvpwrvgnd_1
XFILLER_42_457 VPWR VGND VPWR VGND sky130_ef_sc_hd__decap_12
XFILLER_146_3 VPWR VGND VPWR VGND sky130_ef_sc_hd__decap_12
XANTENNA__3299__CLK clknet_3_2__leaf_clk VGND VGND VPWR VPWR sky130_fd_sc_hd__diode_2
XFILLER_11_833 VGND VGND VPWR VPWR sky130_fd_sc_hd__decap_6
XFILLER_23_671 VGND VGND VPWR VPWR sky130_fd_sc_hd__fill_1
XFILLER_10_321 VPWR VGND VPWR VGND sky130_ef_sc_hd__decap_12
XFILLER_109_721 VGND VGND VPWR VPWR sky130_fd_sc_hd__decap_6
XFILLER_10_365 VPWR VGND VPWR VGND sky130_ef_sc_hd__decap_12
XFILLER_10_354 VGND VGND VPWR VPWR sky130_fd_sc_hd__decap_8
XFILLER_11_877 VPWR VGND VPWR VGND sky130_ef_sc_hd__decap_12
XFILLER_109_765 VPWR VGND VPWR VGND sky130_ef_sc_hd__decap_12
XFILLER_108_253 VPWR VGND VPWR VGND sky130_ef_sc_hd__decap_12
XFILLER_124_713 VPWR VGND VPWR VGND sky130_ef_sc_hd__decap_12
XPHY_EDGE_ROW_107_Left_261 VGND VGND VPWR VPWR sky130_fd_sc_hd__decap_3
XFILLER_124_757 VPWR VGND VPWR VGND sky130_ef_sc_hd__decap_12
XFILLER_123_223 VGND VGND VPWR VPWR sky130_fd_sc_hd__fill_1
XFILLER_117_81 VPWR VGND VPWR VGND sky130_ef_sc_hd__decap_12
XFILLER_78_811 VGND VGND VPWR VPWR sky130_fd_sc_hd__fill_1
XFILLER_111_429 VPWR VGND VPWR VGND sky130_ef_sc_hd__decap_12
XFILLER_89_181 VPWR VGND VPWR VGND sky130_ef_sc_hd__decap_12
XFILLER_2_586 VGND VGND VPWR VPWR sky130_fd_sc_hd__fill_2
XFILLER_77_365 VGND VGND VPWR VPWR sky130_fd_sc_hd__fill_1
XFILLER_65_505 VPWR VGND VPWR VGND sky130_ef_sc_hd__decap_12
XFILLER_80_508 VPWR VGND VPWR VGND sky130_ef_sc_hd__decap_12
XFILLER_18_421 VGND VGND VPWR VPWR sky130_fd_sc_hd__decap_3
XTAP_TAPCELL_ROW_36_909 VGND VPWR sky130_fd_sc_hd__tapvpwrvgnd_1
XPHY_EDGE_ROW_116_Left_270 VGND VGND VPWR VPWR sky130_fd_sc_hd__decap_3
XFILLER_92_379 VPWR VGND VPWR VGND sky130_ef_sc_hd__decap_12
XFILLER_45_262 VGND VGND VPWR VPWR sky130_fd_sc_hd__decap_8
XFILLER_61_722 VGND VGND VPWR VPWR sky130_fd_sc_hd__decap_6
XFILLER_60_221 VPWR VGND VPWR VGND sky130_ef_sc_hd__decap_12
XFILLER_61_777 VGND VGND VPWR VPWR sky130_fd_sc_hd__decap_6
XFILLER_60_265 VGND VGND VPWR VPWR sky130_fd_sc_hd__decap_8
XTAP_TAPCELL_ROW_138_2539 VGND VPWR sky130_fd_sc_hd__tapvpwrvgnd_1
X_1981_ _1234_ _1245_ VGND VGND VPWR VPWR _1246_ sky130_fd_sc_hd__xor2_1
XFILLER_14_693 VGND VGND VPWR VPWR sky130_fd_sc_hd__decap_6
XFILLER_13_181 VPWR VGND VPWR VGND sky130_ef_sc_hd__decap_12
XFILLER_119_529 VPWR VGND VPWR VGND sky130_ef_sc_hd__decap_12
X_2602_ _0306_ _0340_ _0341_ VGND VGND VPWR VPWR _0347_ sky130_fd_sc_hd__or3_1
XFILLER_61_3 VPWR VGND VPWR VGND sky130_ef_sc_hd__decap_12
XFILLER_127_573 VPWR VGND VPWR VGND sky130_ef_sc_hd__decap_12
XFILLER_6_881 VPWR VGND VPWR VGND sky130_ef_sc_hd__decap_12
X_2533_ _0258_ _0279_ _0277_ _0268_ VGND VGND VPWR VPWR _0281_ sky130_fd_sc_hd__o211ai_1
XFILLER_114_245 VGND VGND VPWR VPWR sky130_fd_sc_hd__decap_6
XTAP_TAPCELL_ROW_58_1265 VGND VPWR sky130_fd_sc_hd__tapvpwrvgnd_1
XTAP_TAPCELL_ROW_58_1254 VGND VPWR sky130_fd_sc_hd__tapvpwrvgnd_1
XFILLER_142_587 VGND VGND VPWR VPWR sky130_fd_sc_hd__fill_1
X_2464_ _0191_ _0213_ VGND VGND VPWR VPWR _0214_ sky130_fd_sc_hd__xnor2_1
XFILLER_130_749 VGND VGND VPWR VPWR sky130_fd_sc_hd__decap_6
XFILLER_114_289 VPWR VGND VPWR VGND sky130_ef_sc_hd__decap_12
X_2395_ _0141_ _0142_ _0139_ VGND VGND VPWR VPWR _0149_ sky130_fd_sc_hd__a21bo_1
XANTENNA__2858__A1 B_reg\[8\] VGND VGND VPWR VPWR sky130_fd_sc_hd__diode_2
XFILLER_69_833 VGND VGND VPWR VPWR sky130_fd_sc_hd__decap_6
XFILLER_68_321 VGND VGND VPWR VPWR sky130_fd_sc_hd__decap_4
XTAP_TAPCELL_ROW_71_1465 VGND VPWR sky130_fd_sc_hd__tapvpwrvgnd_1
XFILLER_69_877 VPWR VGND VPWR VGND sky130_ef_sc_hd__decap_12
XFILLER_68_365 VPWR VGND VPWR VGND sky130_ef_sc_hd__decap_12
XFILLER_110_462 VGND VGND VPWR VPWR sky130_fd_sc_hd__fill_2
XFILLER_95_173 VGND VGND VPWR VPWR sky130_fd_sc_hd__fill_1
XFILLER_84_825 VPWR VGND VPWR VGND sky130_ef_sc_hd__decap_12
XFILLER_83_313 VGND VGND VPWR VPWR sky130_fd_sc_hd__fill_2
XFILLER_3_93 VPWR VGND VPWR VGND sky130_ef_sc_hd__decap_12
XFILLER_113_39 VPWR VGND VPWR VGND sky130_ef_sc_hd__decap_12
XFILLER_84_869 VPWR VGND VPWR VGND sky130_ef_sc_hd__decap_12
XFILLER_37_741 VPWR VGND VPWR VGND sky130_ef_sc_hd__decap_12
X_3016_ _0700_ _0703_ VGND VGND VPWR VPWR _0704_ sky130_fd_sc_hd__nand2_1
XFILLER_37_785 VPWR VGND VPWR VGND sky130_ef_sc_hd__decap_12
XFILLER_52_755 VGND VGND VPWR VPWR sky130_fd_sc_hd__fill_1
XFILLER_24_457 VPWR VGND VPWR VGND sky130_ef_sc_hd__decap_12
XFILLER_138_805 VGND VGND VPWR VPWR sky130_fd_sc_hd__decap_6
XFILLER_138_849 VPWR VGND VPWR VGND sky130_ef_sc_hd__decap_12
XFILLER_137_337 VPWR VGND VPWR VGND sky130_ef_sc_hd__decap_12
XFILLER_152_307 VGND VGND VPWR VPWR sky130_fd_sc_hd__fill_1
XFILLER_146_893 VPWR VGND VPWR VGND sky130_ef_sc_hd__decap_12
XFILLER_106_713 VPWR VGND VPWR VGND sky130_ef_sc_hd__decap_12
XFILLER_98_29 VPWR VGND VPWR VGND sky130_ef_sc_hd__decap_12
XFILLER_106_757 VPWR VGND VPWR VGND sky130_ef_sc_hd__decap_12
XFILLER_105_223 VGND VGND VPWR VPWR sky130_fd_sc_hd__fill_1
XFILLER_121_727 VGND VGND VPWR VPWR sky130_fd_sc_hd__fill_1
XANTENNA__2849__A1 A_reg\[15\] VGND VGND VPWR VPWR sky130_fd_sc_hd__diode_2
XFILLER_101_440 VGND VGND VPWR VPWR sky130_fd_sc_hd__decap_8
XFILLER_87_641 VGND VGND VPWR VPWR sky130_fd_sc_hd__decap_8
XTAP_TAPCELL_ROW_89_1748 VGND VPWR sky130_fd_sc_hd__tapvpwrvgnd_1
XFILLER_87_685 VPWR VGND VPWR VGND sky130_ef_sc_hd__decap_12
XFILLER_86_173 VGND VGND VPWR VPWR sky130_fd_sc_hd__decap_3
XFILLER_47_55 VGND VGND VPWR VPWR sky130_fd_sc_hd__fill_1
XTAP_TAPCELL_ROW_89_1759 VGND VPWR sky130_fd_sc_hd__tapvpwrvgnd_1
XFILLER_86_184 VPWR VGND VPWR VGND sky130_ef_sc_hd__decap_12
XTAP_TAPCELL_ROW_2_361 VGND VPWR sky130_fd_sc_hd__tapvpwrvgnd_1
XFILLER_55_593 VPWR VGND VPWR VGND sky130_ef_sc_hd__decap_12
XFILLER_43_777 VGND VGND VPWR VPWR sky130_fd_sc_hd__decap_6
XTAP_TAPCELL_ROW_100_1926 VGND VPWR sky130_fd_sc_hd__tapvpwrvgnd_1
XANTENNA__3298__RESET_B net36 VGND VGND VPWR VPWR sky130_fd_sc_hd__diode_2
XTAP_TAPCELL_ROW_42_1000 VGND VPWR sky130_fd_sc_hd__tapvpwrvgnd_1
XFILLER_42_265 VPWR VGND VPWR VGND sky130_ef_sc_hd__decap_12
XTAP_TAPCELL_ROW_42_1011 VGND VPWR sky130_fd_sc_hd__tapvpwrvgnd_1
XTAP_TAPCELL_ROW_100_1937 VGND VPWR sky130_fd_sc_hd__tapvpwrvgnd_1
XANTENNA__3227__RESET_B net36 VGND VGND VPWR VPWR sky130_fd_sc_hd__diode_2
XFILLER_8_27 VGND VGND VPWR VPWR sky130_fd_sc_hd__fill_1
XFILLER_11_641 VPWR VGND VPWR VGND sky130_ef_sc_hd__decap_12
XFILLER_11_685 VPWR VGND VPWR VGND sky130_ef_sc_hd__decap_12
XTAP_TAPCELL_ROW_41_989 VGND VPWR sky130_fd_sc_hd__tapvpwrvgnd_1
XFILLER_10_195 VGND VGND VPWR VPWR sky130_fd_sc_hd__fill_1
XFILLER_6_133 VGND VGND VPWR VPWR sky130_fd_sc_hd__decap_6
XFILLER_143_329 VGND VGND VPWR VPWR sky130_fd_sc_hd__decap_6
XTAP_TAPCELL_ROW_133_2458 VGND VPWR sky130_fd_sc_hd__tapvpwrvgnd_1
XFILLER_109_573 VPWR VGND VPWR VGND sky130_ef_sc_hd__decap_12
XFILLER_6_177 VPWR VGND VPWR VGND sky130_ef_sc_hd__decap_12
XANTENNA__3314__CLK clknet_3_7__leaf_clk VGND VGND VPWR VPWR sky130_fd_sc_hd__diode_2
XFILLER_151_373 VPWR VGND VPWR VGND sky130_ef_sc_hd__decap_12
XFILLER_124_587 VGND VGND VPWR VPWR sky130_fd_sc_hd__fill_1
XFILLER_112_749 VGND VGND VPWR VPWR sky130_fd_sc_hd__decap_6
XFILLER_111_237 VPWR VGND VPWR VGND sky130_ef_sc_hd__decap_12
XFILLER_97_449 VPWR VGND VPWR VGND sky130_ef_sc_hd__decap_12
XFILLER_97_427 VGND VGND VPWR VPWR sky130_fd_sc_hd__decap_4
XFILLER_3_895 VGND VGND VPWR VPWR sky130_fd_sc_hd__fill_1
XTAP_TAPCELL_ROW_53_1173 VGND VPWR sky130_fd_sc_hd__tapvpwrvgnd_1
X_2180_ _1430_ _1436_ VGND VGND VPWR VPWR _1437_ sky130_fd_sc_hd__nand2_1
XFILLER_120_793 VPWR VGND VPWR VGND sky130_ef_sc_hd__decap_12
XFILLER_66_825 VPWR VGND VPWR VGND sky130_ef_sc_hd__decap_12
XTAP_TAPCELL_ROW_53_1184 VGND VPWR sky130_fd_sc_hd__tapvpwrvgnd_1
XFILLER_38_516 VPWR VGND VPWR VGND sky130_ef_sc_hd__decap_12
XFILLER_93_633 VPWR VGND VPWR VGND sky130_ef_sc_hd__decap_12
XFILLER_92_132 VGND VGND VPWR VPWR sky130_fd_sc_hd__decap_8
XFILLER_66_869 VPWR VGND VPWR VGND sky130_ef_sc_hd__decap_12
XTAP_TAPCELL_ROW_0_309 VGND VPWR sky130_fd_sc_hd__tapvpwrvgnd_1
XFILLER_19_741 VPWR VGND VPWR VGND sky130_ef_sc_hd__decap_12
XFILLER_92_165 VGND VGND VPWR VPWR sky130_fd_sc_hd__fill_1
XFILLER_81_839 VGND VGND VPWR VPWR sky130_fd_sc_hd__fill_1
XFILLER_18_251 VGND VGND VPWR VPWR sky130_fd_sc_hd__fill_1
XFILLER_19_785 VPWR VGND VPWR VGND sky130_ef_sc_hd__decap_12
XTAP_TAPCELL_ROW_29_791 VGND VPWR sky130_fd_sc_hd__tapvpwrvgnd_1
XFILLER_61_541 VPWR VGND VPWR VGND sky130_ef_sc_hd__decap_12
XFILLER_34_755 VGND VGND VPWR VPWR sky130_fd_sc_hd__fill_1
XFILLER_61_585 VPWR VGND VPWR VGND sky130_ef_sc_hd__decap_12
XFILLER_21_405 VGND VGND VPWR VPWR sky130_fd_sc_hd__decap_8
X_1964_ B_reg\[4\] _1222_ _1225_ VGND VGND VPWR VPWR _1229_ sky130_fd_sc_hd__o21a_1
XFILLER_21_449 VPWR VGND VPWR VGND sky130_ef_sc_hd__decap_12
XFILLER_119_337 VPWR VGND VPWR VGND sky130_ef_sc_hd__decap_12
X_1895_ _1161_ _1162_ VGND VGND VPWR VPWR _1163_ sky130_fd_sc_hd__nor2_1
XFILLER_146_189 VGND VGND VPWR VPWR sky130_fd_sc_hd__decap_6
XFILLER_134_307 VGND VGND VPWR VPWR sky130_fd_sc_hd__fill_1
XFILLER_128_893 VPWR VGND VPWR VGND sky130_ef_sc_hd__decap_12
XANTENNA__2528__B1 _0188_ VGND VGND VPWR VPWR sky130_fd_sc_hd__diode_2
XFILLER_143_841 VPWR VGND VPWR VGND sky130_ef_sc_hd__decap_12
XTAP_TAPCELL_ROW_73_1505 VGND VPWR sky130_fd_sc_hd__tapvpwrvgnd_1
XFILLER_0_309 VPWR VGND VPWR VGND sky130_ef_sc_hd__decap_12
X_2516_ _0262_ _0263_ VGND VGND VPWR VPWR _0264_ sky130_fd_sc_hd__nor2_1
XFILLER_130_513 VPWR VGND VPWR VGND sky130_ef_sc_hd__decap_12
XFILLER_103_727 VGND VGND VPWR VPWR sky130_fd_sc_hd__fill_1
XFILLER_88_427 VGND VGND VPWR VPWR sky130_fd_sc_hd__fill_1
X_2447_ _0195_ _0196_ VGND VGND VPWR VPWR _0197_ sky130_fd_sc_hd__nor2_1
XFILLER_130_557 VPWR VGND VPWR VGND sky130_ef_sc_hd__decap_12
XFILLER_124_27 VGND VGND VPWR VPWR sky130_fd_sc_hd__fill_1
X_2378_ _0126_ _0127_ _0131_ VGND VGND VPWR VPWR _0132_ sky130_fd_sc_hd__a21o_1
XFILLER_84_611 VPWR VGND VPWR VGND sky130_ef_sc_hd__decap_12
XFILLER_69_685 VPWR VGND VPWR VGND sky130_ef_sc_hd__decap_12
XFILLER_29_505 VPWR VGND VPWR VGND sky130_ef_sc_hd__decap_12
XFILLER_68_195 VGND VGND VPWR VPWR sky130_fd_sc_hd__fill_1
XFILLER_140_15 VPWR VGND VPWR VGND sky130_ef_sc_hd__decap_12
XFILLER_84_699 VGND VGND VPWR VPWR sky130_fd_sc_hd__fill_1
XFILLER_71_305 VPWR VGND VPWR VGND sky130_ef_sc_hd__decap_12
XFILLER_56_357 VGND VGND VPWR VPWR sky130_fd_sc_hd__decap_6
XFILLER_71_349 VPWR VGND VPWR VGND sky130_ef_sc_hd__decap_12
XFILLER_17_69 VPWR VGND VPWR VGND sky130_ef_sc_hd__decap_12
XTAP_TAPCELL_ROW_84_1678 VGND VPWR sky130_fd_sc_hd__tapvpwrvgnd_1
XFILLER_80_861 VGND VGND VPWR VPWR sky130_fd_sc_hd__decap_6
XFILLER_52_530 VGND VGND VPWR VPWR sky130_fd_sc_hd__fill_2
XFILLER_24_221 VPWR VGND VPWR VGND sky130_ef_sc_hd__decap_12
XFILLER_24_243 VGND VGND VPWR VPWR sky130_fd_sc_hd__decap_8
XFILLER_25_777 VGND VGND VPWR VPWR sky130_fd_sc_hd__decap_6
XFILLER_24_265 VPWR VGND VPWR VGND sky130_ef_sc_hd__decap_12
XFILLER_40_725 VGND VGND VPWR VPWR sky130_fd_sc_hd__decap_4
XANTENNA__3320__RESET_B net36 VGND VGND VPWR VPWR sky130_fd_sc_hd__diode_2
XFILLER_33_57 VPWR VGND VPWR VGND sky130_ef_sc_hd__decap_12
XFILLER_149_57 VPWR VGND VPWR VGND sky130_ef_sc_hd__decap_12
XFILLER_138_613 VPWR VGND VPWR VGND sky130_ef_sc_hd__decap_12
XFILLER_138_657 VPWR VGND VPWR VGND sky130_ef_sc_hd__decap_12
XANTENNA__2024__A B_reg\[8\] VGND VGND VPWR VPWR sky130_fd_sc_hd__diode_2
XFILLER_137_167 VGND VGND VPWR VPWR sky130_fd_sc_hd__fill_1
XFILLER_125_329 VGND VGND VPWR VPWR sky130_fd_sc_hd__decap_6
XFILLER_4_626 VGND VGND VPWR VPWR sky130_fd_sc_hd__fill_1
XTAP_TAPCELL_ROW_115_2177 VGND VPWR sky130_fd_sc_hd__tapvpwrvgnd_1
XTAP_TAPCELL_ROW_115_2166 VGND VPWR sky130_fd_sc_hd__tapvpwrvgnd_1
XFILLER_109_3 VPWR VGND VPWR VGND sky130_ef_sc_hd__decap_12
XFILLER_3_125 VPWR VGND VPWR VGND sky130_ef_sc_hd__decap_12
XFILLER_3_169 VPWR VGND VPWR VGND sky130_ef_sc_hd__decap_12
XFILLER_133_373 VPWR VGND VPWR VGND sky130_ef_sc_hd__decap_12
XFILLER_79_449 VPWR VGND VPWR VGND sky130_ef_sc_hd__decap_12
XTAP_TAPCELL_ROW_7_442 VGND VPWR sky130_fd_sc_hd__tapvpwrvgnd_1
XFILLER_95_909 VGND VGND VPWR VPWR sky130_fd_sc_hd__fill_1
XFILLER_0_865 VGND VGND VPWR VPWR sky130_fd_sc_hd__decap_3
XFILLER_59_162 VGND VGND VPWR VPWR sky130_fd_sc_hd__decap_6
XANTENNA_input29_A B_in[6] VGND VGND VPWR VPWR sky130_fd_sc_hd__diode_2
XFILLER_102_793 VPWR VGND VPWR VGND sky130_ef_sc_hd__decap_12
XFILLER_101_281 VPWR VGND VPWR VGND sky130_ef_sc_hd__decap_12
XFILLER_75_633 VGND VGND VPWR VPWR sky130_fd_sc_hd__fill_1
XFILLER_74_121 VPWR VGND VPWR VGND sky130_ef_sc_hd__decap_12
XFILLER_48_869 VGND VGND VPWR VPWR sky130_fd_sc_hd__decap_8
XFILLER_47_335 VGND VGND VPWR VPWR sky130_fd_sc_hd__fill_1
XFILLER_90_603 VPWR VGND VPWR VGND sky130_ef_sc_hd__decap_12
XFILLER_74_165 VPWR VGND VPWR VGND sky130_ef_sc_hd__decap_12
XFILLER_74_20 VGND VGND VPWR VPWR sky130_fd_sc_hd__decap_8
XFILLER_63_839 VGND VGND VPWR VPWR sky130_fd_sc_hd__fill_1
XFILLER_74_53 VPWR VGND VPWR VGND sky130_ef_sc_hd__decap_12
XFILLER_90_669 VPWR VGND VPWR VGND sky130_ef_sc_hd__decap_12
XFILLER_74_97 VPWR VGND VPWR VGND sky130_ef_sc_hd__decap_12
XFILLER_16_755 VGND VGND VPWR VPWR sky130_fd_sc_hd__fill_1
XTAP_TAPCELL_ROW_26_750 VGND VPWR sky130_fd_sc_hd__tapvpwrvgnd_1
XANTENNA__3298__Q B_reg\[8\] VGND VGND VPWR VPWR sky130_fd_sc_hd__diode_2
XFILLER_43_585 VPWR VGND VPWR VGND sky130_ef_sc_hd__decap_12
XFILLER_30_235 VPWR VGND VPWR VGND sky130_ef_sc_hd__decap_12
XFILLER_11_493 VGND VGND VPWR VPWR sky130_fd_sc_hd__decap_8
XFILLER_116_307 VGND VGND VPWR VPWR sky130_fd_sc_hd__fill_1
X_1680_ _0892_ _0952_ _0955_ VGND VGND VPWR VPWR _0956_ sky130_fd_sc_hd__a21oi_1
XFILLER_143_137 VPWR VGND VPWR VGND sky130_ef_sc_hd__decap_12
XFILLER_128_189 VGND VGND VPWR VPWR sky130_fd_sc_hd__decap_6
XFILLER_125_841 VPWR VGND VPWR VGND sky130_ef_sc_hd__decap_12
XFILLER_140_811 VGND VGND VPWR VPWR sky130_fd_sc_hd__fill_1
XTAP_TAPCELL_ROW_55_1213 VGND VPWR sky130_fd_sc_hd__tapvpwrvgnd_1
XFILLER_152_693 VGND VGND VPWR VPWR sky130_fd_sc_hd__decap_6
XFILLER_98_725 VPWR VGND VPWR VGND sky130_ef_sc_hd__decap_12
X_2301_ _1550_ _1553_ VGND VGND VPWR VPWR _1554_ sky130_fd_sc_hd__nand2_1
XFILLER_151_181 VPWR VGND VPWR VGND sky130_ef_sc_hd__decap_12
XFILLER_112_557 VPWR VGND VPWR VGND sky130_ef_sc_hd__decap_12
XFILLER_98_769 VPWR VGND VPWR VGND sky130_ef_sc_hd__decap_12
XFILLER_86_909 VGND VGND VPWR VPWR sky130_fd_sc_hd__fill_1
X_3281_ clknet_3_1__leaf_clk _0064_ net36 VGND VGND VPWR VPWR A_reg\[7\] sky130_fd_sc_hd__dfrtp_4
XFILLER_24_3 VPWR VGND VPWR VGND sky130_ef_sc_hd__decap_12
XFILLER_38_302 VGND VGND VPWR VPWR sky130_fd_sc_hd__decap_6
X_2232_ A_reg\[5\] _1479_ _1486_ VGND VGND VPWR VPWR _1489_ sky130_fd_sc_hd__and3_1
XPHY_EDGE_ROW_119_Right_119 VGND VGND VPWR VPWR sky130_fd_sc_hd__decap_3
XFILLER_65_121 VGND VGND VPWR VPWR sky130_fd_sc_hd__decap_3
X_2163_ _0888_ _1415_ VGND VGND VPWR VPWR _1420_ sky130_fd_sc_hd__xnor2_1
XFILLER_53_305 VPWR VGND VPWR VGND sky130_ef_sc_hd__decap_12
XFILLER_66_699 VGND VGND VPWR VPWR sky130_fd_sc_hd__fill_1
X_2094_ _1346_ _1347_ _1353_ VGND VGND VPWR VPWR _1354_ sky130_fd_sc_hd__o21a_1
XFILLER_65_198 VPWR VGND VPWR VGND sky130_ef_sc_hd__decap_12
XTAP_TAPCELL_ROW_24_709 VGND VPWR sky130_fd_sc_hd__tapvpwrvgnd_1
XFILLER_34_541 VGND VGND VPWR VPWR sky130_fd_sc_hd__decap_3
XFILLER_110_29 VPWR VGND VPWR VGND sky130_ef_sc_hd__decap_12
XTAP_TAPCELL_ROW_66_1386 VGND VPWR sky130_fd_sc_hd__tapvpwrvgnd_1
XFILLER_22_725 VPWR VGND VPWR VGND sky130_ef_sc_hd__decap_12
XFILLER_10_909 VGND VGND VPWR VPWR sky130_fd_sc_hd__fill_1
XFILLER_22_769 VPWR VGND VPWR VGND sky130_ef_sc_hd__decap_12
X_2996_ _0664_ _0666_ VGND VGND VPWR VPWR _0684_ sky130_fd_sc_hd__xor2_1
XFILLER_9_81 VPWR VGND VPWR VGND sky130_ef_sc_hd__decap_12
XFILLER_119_27 VPWR VGND VPWR VGND sky130_ef_sc_hd__decap_12
X_1947_ _1209_ _1211_ _0904_ VGND VGND VPWR VPWR _1212_ sky130_fd_sc_hd__a21o_1
XFILLER_119_167 VGND VGND VPWR VPWR sky130_fd_sc_hd__fill_1
X_1878_ _1147_ A_reg\[3\] _1145_ VGND VGND VPWR VPWR _1148_ sky130_fd_sc_hd__mux2_1
XFILLER_107_329 VGND VGND VPWR VPWR sky130_fd_sc_hd__decap_6
XFILLER_143_671 VGND VGND VPWR VPWR sky130_fd_sc_hd__fill_1
XFILLER_135_15 VPWR VGND VPWR VGND sky130_ef_sc_hd__decap_12
XFILLER_131_833 VGND VGND VPWR VPWR sky130_fd_sc_hd__decap_6
XFILLER_115_373 VPWR VGND VPWR VGND sky130_ef_sc_hd__decap_12
XFILLER_88_224 VGND VGND VPWR VPWR sky130_fd_sc_hd__decap_8
XFILLER_1_629 VPWR VGND VPWR VGND sky130_ef_sc_hd__decap_12
XFILLER_131_877 VPWR VGND VPWR VGND sky130_ef_sc_hd__decap_12
XFILLER_130_321 VPWR VGND VPWR VGND sky130_ef_sc_hd__decap_12
XTAP_TAPCELL_ROW_110_2085 VGND VPWR sky130_fd_sc_hd__tapvpwrvgnd_1
XFILLER_77_909 VGND VGND VPWR VPWR sky130_fd_sc_hd__fill_1
XFILLER_130_365 VPWR VGND VPWR VGND sky130_ef_sc_hd__decap_12
XTAP_TAPCELL_ROW_110_2096 VGND VPWR sky130_fd_sc_hd__tapvpwrvgnd_1
XFILLER_76_419 VGND VGND VPWR VPWR sky130_fd_sc_hd__fill_1
XTAP_TAPCELL_ROW_4_401 VGND VPWR sky130_fd_sc_hd__tapvpwrvgnd_1
XFILLER_29_335 VGND VGND VPWR VPWR sky130_fd_sc_hd__fill_1
XTAP_TAPCELL_ROW_86_1707 VGND VPWR sky130_fd_sc_hd__tapvpwrvgnd_1
XFILLER_56_165 VPWR VGND VPWR VGND sky130_ef_sc_hd__decap_12
XFILLER_151_69 VPWR VGND VPWR VGND sky130_ef_sc_hd__decap_12
XFILLER_72_625 VPWR VGND VPWR VGND sky130_ef_sc_hd__decap_12
XFILLER_71_113 VGND VGND VPWR VPWR sky130_fd_sc_hd__decap_6
XFILLER_45_839 VGND VGND VPWR VPWR sky130_fd_sc_hd__fill_1
XFILLER_72_669 VPWR VGND VPWR VGND sky130_ef_sc_hd__decap_12
XFILLER_60_809 VGND VGND VPWR VPWR sky130_fd_sc_hd__fill_1
XFILLER_25_541 VPWR VGND VPWR VGND sky130_ef_sc_hd__decap_12
XFILLER_25_585 VPWR VGND VPWR VGND sky130_ef_sc_hd__decap_12
XFILLER_40_533 VPWR VGND VPWR VGND sky130_ef_sc_hd__decap_12
XTAP_TAPCELL_ROW_117_2206 VGND VPWR sky130_fd_sc_hd__tapvpwrvgnd_1
XFILLER_9_729 VPWR VGND VPWR VGND sky130_ef_sc_hd__decap_12
XFILLER_12_279 VPWR VGND VPWR VGND sky130_ef_sc_hd__decap_12
XFILLER_138_421 VPWR VGND VPWR VGND sky130_ef_sc_hd__decap_12
XTAP_TAPCELL_ROW_130_2417 VGND VPWR sky130_fd_sc_hd__tapvpwrvgnd_1
XTAP_TAPCELL_ROW_130_2406 VGND VPWR sky130_fd_sc_hd__tapvpwrvgnd_1
XFILLER_125_137 VPWR VGND VPWR VGND sky130_ef_sc_hd__decap_12
XFILLER_107_841 VPWR VGND VPWR VGND sky130_ef_sc_hd__decap_12
XFILLER_5_39 VPWR VGND VPWR VGND sky130_ef_sc_hd__decap_12
XFILLER_4_445 VPWR VGND VPWR VGND sky130_ef_sc_hd__decap_12
XFILLER_134_693 VGND VGND VPWR VPWR sky130_fd_sc_hd__decap_6
XFILLER_122_811 VGND VGND VPWR VPWR sky130_fd_sc_hd__fill_1
XFILLER_109_93 VPWR VGND VPWR VGND sky130_ef_sc_hd__decap_12
XFILLER_133_181 VPWR VGND VPWR VGND sky130_ef_sc_hd__decap_12
XFILLER_68_909 VGND VGND VPWR VPWR sky130_fd_sc_hd__fill_1
XFILLER_48_611 VPWR VGND VPWR VGND sky130_ef_sc_hd__decap_12
XFILLER_0_673 VPWR VGND VPWR VGND sky130_ef_sc_hd__decap_12
XFILLER_125_81 VPWR VGND VPWR VGND sky130_ef_sc_hd__decap_12
XANTENNA__2676__C1 _0188_ VGND VGND VPWR VPWR sky130_fd_sc_hd__diode_2
XTAP_TAPCELL_ROW_50_1132 VGND VPWR sky130_fd_sc_hd__tapvpwrvgnd_1
XFILLER_48_633 VGND VGND VPWR VPWR sky130_fd_sc_hd__decap_8
XTAP_TAPCELL_ROW_128_2379 VGND VPWR sky130_fd_sc_hd__tapvpwrvgnd_1
XFILLER_75_441 VGND VGND VPWR VPWR sky130_fd_sc_hd__decap_6
XFILLER_48_666 VGND VGND VPWR VPWR sky130_fd_sc_hd__fill_1
XFILLER_75_485 VPWR VGND VPWR VGND sky130_ef_sc_hd__decap_12
XFILLER_62_113 VGND VGND VPWR VPWR sky130_fd_sc_hd__fill_1
XFILLER_48_699 VGND VGND VPWR VPWR sky130_fd_sc_hd__fill_1
XFILLER_90_433 VGND VGND VPWR VPWR sky130_fd_sc_hd__decap_3
XANTENNA__3242__RESET_B net36 VGND VGND VPWR VPWR sky130_fd_sc_hd__diode_2
XANTENNA_clkbuf_3_4__f_clk_X clknet_3_4__leaf_clk VGND VGND VPWR VPWR sky130_fd_sc_hd__diode_2
XFILLER_35_349 VGND VGND VPWR VPWR sky130_fd_sc_hd__decap_3
XFILLER_44_861 VGND VGND VPWR VPWR sky130_fd_sc_hd__decap_6
XFILLER_90_477 VPWR VGND VPWR VGND sky130_ef_sc_hd__decap_12
X_2850_ net17 B_reg\[0\] _0383_ VGND VGND VPWR VPWR _0073_ sky130_fd_sc_hd__mux2_1
XTAP_TAPCELL_ROW_48_1094 VGND VPWR sky130_fd_sc_hd__tapvpwrvgnd_1
XFILLER_43_382 VGND VGND VPWR VPWR sky130_fd_sc_hd__decap_8
XFILLER_43_393 VPWR VGND VPWR VGND sky130_ef_sc_hd__decap_12
X_1801_ _1066_ _1068_ VGND VGND VPWR VPWR _1074_ sky130_fd_sc_hd__nand2_1
X_2781_ _0520_ VGND VGND VPWR VPWR _0521_ sky130_fd_sc_hd__inv_2
XFILLER_31_588 VGND VGND VPWR VPWR sky130_fd_sc_hd__decap_4
XFILLER_144_413 VGND VGND VPWR VPWR sky130_fd_sc_hd__decap_6
X_1732_ _0993_ _1005_ _1001_ _0996_ VGND VGND VPWR VPWR _1006_ sky130_fd_sc_hd__a2bb2o_1
XANTENNA__1954__A1 B_reg\[5\] VGND VGND VPWR VPWR sky130_fd_sc_hd__diode_2
XFILLER_7_261 VPWR VGND VPWR VGND sky130_ef_sc_hd__decap_12
X_1663_ _0937_ _0938_ VGND VGND VPWR VPWR _0939_ sky130_fd_sc_hd__nor2_1
XFILLER_144_457 VPWR VGND VPWR VGND sky130_ef_sc_hd__decap_12
XFILLER_125_671 VGND VGND VPWR VPWR sky130_fd_sc_hd__fill_1
XFILLER_113_833 VGND VGND VPWR VPWR sky130_fd_sc_hd__decap_6
XFILLER_98_533 VPWR VGND VPWR VGND sky130_ef_sc_hd__decap_12
XANTENNA__3207__B _0912_ VGND VGND VPWR VPWR sky130_fd_sc_hd__diode_2
XFILLER_112_321 VPWR VGND VPWR VGND sky130_ef_sc_hd__decap_12
XFILLER_86_706 VGND VGND VPWR VPWR sky130_fd_sc_hd__fill_1
XFILLER_59_909 VGND VGND VPWR VPWR sky130_fd_sc_hd__fill_1
XFILLER_113_877 VPWR VGND VPWR VGND sky130_ef_sc_hd__decap_12
XFILLER_112_365 VPWR VGND VPWR VGND sky130_ef_sc_hd__decap_12
X_3264_ clknet_3_7__leaf_clk _0047_ net36 VGND VGND VPWR VPWR net50 sky130_fd_sc_hd__dfrtp_1
XPHY_EDGE_ROW_7_Right_7 VGND VGND VPWR VPWR sky130_fd_sc_hd__decap_3
X_2215_ _1454_ _1459_ _1461_ VGND VGND VPWR VPWR _1472_ sky130_fd_sc_hd__a21oi_1
XFILLER_38_121 VPWR VGND VPWR VGND sky130_ef_sc_hd__decap_12
XANTENNA__2131__A1 B_reg\[4\] VGND VGND VPWR VPWR sky130_fd_sc_hd__diode_2
XTAP_TAPCELL_ROW_68_1415 VGND VPWR sky130_fd_sc_hd__tapvpwrvgnd_1
X_3195_ _0847_ _0858_ VGND VGND VPWR VPWR _0876_ sky130_fd_sc_hd__nor2_1
X_2146_ _1401_ _1402_ VGND VGND VPWR VPWR _1405_ sky130_fd_sc_hd__and2_1
XTAP_TAPCELL_ROW_68_1426 VGND VPWR sky130_fd_sc_hd__tapvpwrvgnd_1
XFILLER_26_305 VGND VGND VPWR VPWR sky130_fd_sc_hd__decap_3
XFILLER_27_839 VGND VGND VPWR VPWR sky130_fd_sc_hd__fill_1
XFILLER_38_165 VPWR VGND VPWR VGND sky130_ef_sc_hd__decap_12
XFILLER_121_39 VPWR VGND VPWR VGND sky130_ef_sc_hd__decap_12
XFILLER_93_293 VPWR VGND VPWR VGND sky130_ef_sc_hd__decap_12
X_2077_ B_reg\[2\] _1336_ VGND VGND VPWR VPWR _1339_ sky130_fd_sc_hd__xnor2_1
XFILLER_19_390 VGND VGND VPWR VPWR sky130_fd_sc_hd__fill_2
XTAP_TAPCELL_ROW_81_1626 VGND VPWR sky130_fd_sc_hd__tapvpwrvgnd_1
XFILLER_14_15 VPWR VGND VPWR VGND sky130_ef_sc_hd__decap_12
XFILLER_22_533 VPWR VGND VPWR VGND sky130_ef_sc_hd__decap_12
X_2979_ _0580_ _0607_ _0666_ VGND VGND VPWR VPWR _0667_ sky130_fd_sc_hd__or3_1
XFILLER_147_273 VGND VGND VPWR VPWR sky130_fd_sc_hd__decap_6
XFILLER_107_137 VPWR VGND VPWR VGND sky130_ef_sc_hd__decap_12
XANTENNA__1945__A1 B_reg\[7\] VGND VGND VPWR VPWR sky130_fd_sc_hd__diode_2
XANTENNA__1945__B2 B_reg\[8\] VGND VGND VPWR VPWR sky130_fd_sc_hd__diode_2
XTAP_TAPCELL_ROW_112_2125 VGND VPWR sky130_fd_sc_hd__tapvpwrvgnd_1
XTAP_TAPCELL_ROW_79_1599 VGND VPWR sky130_fd_sc_hd__tapvpwrvgnd_1
XTAP_TAPCELL_ROW_79_1588 VGND VPWR sky130_fd_sc_hd__tapvpwrvgnd_1
XFILLER_2_905 VGND VGND VPWR VPWR sky130_fd_sc_hd__decap_4
XFILLER_116_693 VGND VGND VPWR VPWR sky130_fd_sc_hd__decap_6
XFILLER_104_811 VGND VGND VPWR VPWR sky130_fd_sc_hd__fill_1
XFILLER_131_641 VPWR VGND VPWR VGND sky130_ef_sc_hd__decap_12
XFILLER_115_181 VPWR VGND VPWR VGND sky130_ef_sc_hd__decap_12
XFILLER_131_685 VPWR VGND VPWR VGND sky130_ef_sc_hd__decap_12
XTAP_TAPCELL_ROW_92_1799 VGND VPWR sky130_fd_sc_hd__tapvpwrvgnd_1
XFILLER_130_195 VGND VGND VPWR VPWR sky130_fd_sc_hd__fill_1
XANTENNA__2122__A1 B_reg\[7\] VGND VGND VPWR VPWR sky130_fd_sc_hd__diode_2
XFILLER_69_290 VGND VGND VPWR VPWR sky130_fd_sc_hd__decap_8
XFILLER_85_783 VGND VGND VPWR VPWR sky130_fd_sc_hd__fill_1
XFILLER_57_485 VPWR VGND VPWR VGND sky130_ef_sc_hd__decap_12
XFILLER_55_44 VPWR VGND VPWR VGND sky130_ef_sc_hd__decap_12
XFILLER_17_305 VGND VGND VPWR VPWR sky130_fd_sc_hd__fill_2
XFILLER_17_316 VPWR VGND VPWR VGND sky130_ef_sc_hd__decap_12
XFILLER_45_625 VPWR VGND VPWR VGND sky130_ef_sc_hd__decap_12
XFILLER_17_349 VPWR VGND VPWR VGND sky130_ef_sc_hd__decap_12
XFILLER_45_669 VGND VGND VPWR VPWR sky130_fd_sc_hd__decap_3
XTAP_TAPCELL_ROW_123_2298 VGND VPWR sky130_fd_sc_hd__tapvpwrvgnd_1
XFILLER_13_500 VGND VGND VPWR VPWR sky130_fd_sc_hd__decap_4
XFILLER_26_861 VGND VGND VPWR VPWR sky130_fd_sc_hd__decap_6
XFILLER_25_393 VGND VGND VPWR VPWR sky130_fd_sc_hd__decap_4
XFILLER_41_853 VPWR VGND VPWR VGND sky130_ef_sc_hd__decap_12
XTAP_TAPCELL_ROW_99_1909 VGND VPWR sky130_fd_sc_hd__tapvpwrvgnd_1
XFILLER_40_363 VGND VGND VPWR VPWR sky130_fd_sc_hd__fill_1
XFILLER_139_741 VPWR VGND VPWR VGND sky130_ef_sc_hd__decap_12
XFILLER_9_559 VGND VGND VPWR VPWR sky130_fd_sc_hd__fill_1
XFILLER_40_385 VGND VGND VPWR VPWR sky130_fd_sc_hd__decap_3
XFILLER_41_897 VPWR VGND VPWR VGND sky130_ef_sc_hd__decap_12
XFILLER_139_785 VPWR VGND VPWR VGND sky130_ef_sc_hd__decap_12
XFILLER_138_251 VGND VGND VPWR VPWR sky130_fd_sc_hd__fill_1
XFILLER_153_221 VGND VGND VPWR VPWR sky130_fd_sc_hd__decap_3
XFILLER_126_413 VGND VGND VPWR VPWR sky130_fd_sc_hd__decap_6
XANTENNA__1936__A1 B_reg\[8\] VGND VGND VPWR VPWR sky130_fd_sc_hd__diode_2
XFILLER_5_721 VGND VGND VPWR VPWR sky130_fd_sc_hd__decap_6
XFILLER_126_457 VPWR VGND VPWR VGND sky130_ef_sc_hd__decap_12
XFILLER_5_765 VPWR VGND VPWR VGND sky130_ef_sc_hd__decap_12
XFILLER_153_265 VPWR VGND VPWR VGND sky130_ef_sc_hd__decap_12
XFILLER_141_405 VPWR VGND VPWR VGND sky130_ef_sc_hd__decap_12
XFILLER_107_671 VGND VGND VPWR VPWR sky130_fd_sc_hd__fill_1
XFILLER_4_253 VPWR VGND VPWR VGND sky130_ef_sc_hd__decap_12
XFILLER_141_449 VPWR VGND VPWR VGND sky130_ef_sc_hd__decap_12
XFILLER_110_825 VPWR VGND VPWR VGND sky130_ef_sc_hd__decap_12
XFILLER_95_503 VGND VGND VPWR VPWR sky130_fd_sc_hd__fill_1
XFILLER_67_249 VPWR VGND VPWR VGND sky130_ef_sc_hd__decap_12
XTAP_TAPCELL_ROW_143_2619 VGND VPWR sky130_fd_sc_hd__tapvpwrvgnd_1
XFILLER_110_869 VPWR VGND VPWR VGND sky130_ef_sc_hd__decap_12
XFILLER_83_709 VPWR VGND VPWR VGND sky130_ef_sc_hd__decap_12
X_2000_ B_reg\[12\] _1255_ VGND VGND VPWR VPWR _1262_ sky130_fd_sc_hd__or2_1
XFILLER_48_441 VGND VGND VPWR VPWR sky130_fd_sc_hd__fill_2
XFILLER_35_113 VPWR VGND VPWR VGND sky130_ef_sc_hd__decap_12
XFILLER_36_625 VPWR VGND VPWR VGND sky130_ef_sc_hd__decap_12
XFILLER_91_753 VPWR VGND VPWR VGND sky130_ef_sc_hd__decap_12
XFILLER_75_293 VGND VGND VPWR VPWR sky130_fd_sc_hd__decap_8
XFILLER_63_444 VGND VGND VPWR VPWR sky130_fd_sc_hd__decap_4
XFILLER_36_669 VPWR VGND VPWR VGND sky130_ef_sc_hd__decap_12
XFILLER_91_797 VPWR VGND VPWR VGND sky130_ef_sc_hd__decap_12
XFILLER_63_466 VGND VGND VPWR VPWR sky130_fd_sc_hd__decap_3
XFILLER_51_617 VPWR VGND VPWR VGND sky130_ef_sc_hd__decap_12
XFILLER_149_505 VPWR VGND VPWR VGND sky130_ef_sc_hd__decap_12
X_2902_ _0566_ _0588_ VGND VGND VPWR VPWR _0590_ sky130_fd_sc_hd__xor2_1
XTAP_TAPCELL_ROW_63_1345 VGND VPWR sky130_fd_sc_hd__tapvpwrvgnd_1
XTAP_TAPCELL_ROW_63_1334 VGND VPWR sky130_fd_sc_hd__tapvpwrvgnd_1
X_2833_ net44 X_crt\[15\] _0553_ VGND VGND VPWR VPWR _0056_ sky130_fd_sc_hd__mux2_1
XTAP_TAPCELL_ROW_14_550 VGND VPWR sky130_fd_sc_hd__tapvpwrvgnd_1
XTAP_TAPCELL_ROW_14_561 VGND VPWR sky130_fd_sc_hd__tapvpwrvgnd_1
X_2764_ _0469_ _0483_ _0493_ _0503_ VGND VGND VPWR VPWR _0504_ sky130_fd_sc_hd__a31o_1
XANTENNA__2821__S _0553_ VGND VGND VPWR VPWR sky130_fd_sc_hd__diode_2
XFILLER_144_221 VPWR VGND VPWR VGND sky130_ef_sc_hd__decap_12
XFILLER_129_273 VGND VGND VPWR VPWR sky130_fd_sc_hd__decap_6
X_1715_ _0979_ _0990_ VGND VGND VPWR VPWR _0991_ sky130_fd_sc_hd__xor2_1
XFILLER_145_777 VGND VGND VPWR VPWR sky130_fd_sc_hd__decap_6
XFILLER_105_608 VGND VGND VPWR VPWR sky130_fd_sc_hd__decap_8
X_2695_ _0405_ _0434_ OpSel_reg\[0\] VGND VGND VPWR VPWR _0435_ sky130_fd_sc_hd__a21bo_1
XFILLER_144_265 VPWR VGND VPWR VGND sky130_ef_sc_hd__decap_12
X_1646_ A_reg\[15\] A_reg\[12\] VGND VGND VPWR VPWR _0922_ sky130_fd_sc_hd__nor2_1
XFILLER_113_641 VPWR VGND VPWR VGND sky130_ef_sc_hd__decap_12
XFILLER_99_853 VPWR VGND VPWR VGND sky130_ef_sc_hd__decap_12
XFILLER_98_330 VPWR VGND VPWR VGND sky130_ef_sc_hd__decap_12
XFILLER_113_685 VPWR VGND VPWR VGND sky130_ef_sc_hd__decap_12
XFILLER_99_897 VPWR VGND VPWR VGND sky130_ef_sc_hd__decap_12
X_3316_ clknet_3_6__leaf_clk _0099_ net36 VGND VGND VPWR VPWR X_crt\[10\] sky130_fd_sc_hd__dfrtp_1
XFILLER_112_195 VGND VGND VPWR VPWR sky130_fd_sc_hd__fill_1
XFILLER_132_27 VGND VGND VPWR VPWR sky130_fd_sc_hd__fill_1
XFILLER_100_357 VGND VGND VPWR VPWR sky130_fd_sc_hd__decap_6
XFILLER_86_569 VPWR VGND VPWR VGND sky130_ef_sc_hd__decap_12
X_3247_ clknet_3_3__leaf_clk _0032_ net36 VGND VGND VPWR VPWR u_crt.r2\[0\] sky130_fd_sc_hd__dfrtp_1
XFILLER_67_783 VGND VGND VPWR VPWR sky130_fd_sc_hd__fill_1
XFILLER_39_485 VGND VGND VPWR VPWR sky130_fd_sc_hd__decap_6
X_3178_ _0835_ _0863_ VGND VGND VPWR VPWR _0864_ sky130_fd_sc_hd__nor2_1
X_2129_ B_reg\[5\] _1384_ _1385_ VGND VGND VPWR VPWR _1388_ sky130_fd_sc_hd__mux2_1
XFILLER_54_433 VPWR VGND VPWR VGND sky130_ef_sc_hd__decap_12
XFILLER_15_809 VPWR VGND VPWR VGND sky130_ef_sc_hd__decap_12
XFILLER_54_477 VGND VGND VPWR VPWR sky130_fd_sc_hd__fill_2
XFILLER_41_105 VGND VGND VPWR VPWR sky130_fd_sc_hd__decap_6
XFILLER_25_69 VPWR VGND VPWR VGND sky130_ef_sc_hd__decap_12
XFILLER_23_853 VPWR VGND VPWR VGND sky130_ef_sc_hd__decap_12
XFILLER_41_149 VPWR VGND VPWR VGND sky130_ef_sc_hd__decap_12
XFILLER_10_525 VGND VGND VPWR VPWR sky130_fd_sc_hd__decap_6
XFILLER_22_363 VGND VGND VPWR VPWR sky130_fd_sc_hd__fill_1
XFILLER_23_897 VPWR VGND VPWR VGND sky130_ef_sc_hd__decap_12
XFILLER_10_569 VPWR VGND VPWR VGND sky130_ef_sc_hd__decap_12
XFILLER_41_57 VPWR VGND VPWR VGND sky130_ef_sc_hd__decap_12
XFILLER_136_755 VGND VGND VPWR VPWR sky130_fd_sc_hd__fill_1
XTAP_TAPCELL_ROW_94_1839 VGND VPWR sky130_fd_sc_hd__tapvpwrvgnd_1
XTAP_TAPCELL_ROW_94_1828 VGND VPWR sky130_fd_sc_hd__tapvpwrvgnd_1
XFILLER_123_405 VPWR VGND VPWR VGND sky130_ef_sc_hd__decap_12
XFILLER_2_713 VPWR VGND VPWR VGND sky130_ef_sc_hd__decap_12
XFILLER_123_449 VPWR VGND VPWR VGND sky130_ef_sc_hd__decap_12
XFILLER_2_757 VPWR VGND VPWR VGND sky130_ef_sc_hd__decap_12
XFILLER_1_223 VGND VGND VPWR VPWR sky130_fd_sc_hd__fill_1
XFILLER_77_503 VGND VGND VPWR VPWR sky130_fd_sc_hd__fill_1
XFILLER_49_205 VPWR VGND VPWR VGND sky130_ef_sc_hd__decap_12
XFILLER_66_10 VPWR VGND VPWR VGND sky130_ef_sc_hd__decap_12
XFILLER_2_29 VPWR VGND VPWR VGND sky130_ef_sc_hd__decap_12
XFILLER_106_83 VGND VGND VPWR VPWR sky130_fd_sc_hd__fill_1
XFILLER_49_249 VPWR VGND VPWR VGND sky130_ef_sc_hd__decap_12
XTAP_TAPCELL_ROW_125_2338 VGND VPWR sky130_fd_sc_hd__tapvpwrvgnd_1
XTAP_TAPCELL_ROW_125_2327 VGND VPWR sky130_fd_sc_hd__tapvpwrvgnd_1
XFILLER_18_625 VPWR VGND VPWR VGND sky130_ef_sc_hd__decap_12
XFILLER_73_753 VGND VGND VPWR VPWR sky130_fd_sc_hd__decap_3
XANTENNA_input11_A A_in[4] VGND VGND VPWR VPWR sky130_fd_sc_hd__diode_2
XFILLER_57_293 VPWR VGND VPWR VGND sky130_ef_sc_hd__decap_12
XFILLER_17_113 VPWR VGND VPWR VGND sky130_ef_sc_hd__decap_12
XFILLER_18_669 VPWR VGND VPWR VGND sky130_ef_sc_hd__decap_12
XFILLER_82_31 VPWR VGND VPWR VGND sky130_ef_sc_hd__decap_12
XFILLER_73_797 VPWR VGND VPWR VGND sky130_ef_sc_hd__decap_12
XFILLER_33_617 VPWR VGND VPWR VGND sky130_ef_sc_hd__decap_12
XTAP_TAPCELL_ROW_103_1979 VGND VPWR sky130_fd_sc_hd__tapvpwrvgnd_1
XFILLER_60_469 VGND VGND VPWR VPWR sky130_fd_sc_hd__decap_6
XFILLER_41_661 VGND VGND VPWR VPWR sky130_fd_sc_hd__fill_1
XTAP_TAPCELL_ROW_45_1053 VGND VPWR sky130_fd_sc_hd__tapvpwrvgnd_1
XTAP_TAPCELL_ROW_31_829 VGND VPWR sky130_fd_sc_hd__tapvpwrvgnd_1
XTAP_TAPCELL_ROW_153_2792 VGND VPWR sky130_fd_sc_hd__tapvpwrvgnd_1
XTAP_TAPCELL_ROW_153_2781 VGND VPWR sky130_fd_sc_hd__tapvpwrvgnd_1
XFILLER_127_777 VGND VGND VPWR VPWR sky130_fd_sc_hd__decap_6
XFILLER_126_221 VPWR VGND VPWR VGND sky130_ef_sc_hd__decap_12
XFILLER_142_725 VPWR VGND VPWR VGND sky130_ef_sc_hd__decap_12
XFILLER_126_265 VPWR VGND VPWR VGND sky130_ef_sc_hd__decap_12
XFILLER_99_105 VGND VGND VPWR VPWR sky130_fd_sc_hd__decap_6
X_2480_ b_r1\[1\] _0227_ VGND VGND VPWR VPWR _0228_ sky130_fd_sc_hd__xnor2_1
XFILLER_5_573 VPWR VGND VPWR VGND sky130_ef_sc_hd__decap_12
XFILLER_142_769 VPWR VGND VPWR VGND sky130_ef_sc_hd__decap_12
XFILLER_130_909 VGND VGND VPWR VPWR sky130_fd_sc_hd__fill_1
XFILLER_107_490 VPWR VGND VPWR VGND sky130_ef_sc_hd__decap_12
XFILLER_99_149 VPWR VGND VPWR VGND sky130_ef_sc_hd__decap_12
XFILLER_141_279 VGND VGND VPWR VPWR sky130_fd_sc_hd__fill_1
XFILLER_68_525 VGND VGND VPWR VPWR sky130_fd_sc_hd__decap_6
X_3101_ _0742_ _0751_ _0759_ VGND VGND VPWR VPWR _0789_ sky130_fd_sc_hd__nand3_1
XFILLER_96_867 VGND VGND VPWR VPWR sky130_fd_sc_hd__fill_1
XFILLER_68_569 VPWR VGND VPWR VGND sky130_ef_sc_hd__decap_12
XFILLER_110_699 VGND VGND VPWR VPWR sky130_fd_sc_hd__fill_1
XFILLER_83_517 VPWR VGND VPWR VGND sky130_ef_sc_hd__decap_12
X_3032_ _0718_ _0719_ VGND VGND VPWR VPWR _0720_ sky130_fd_sc_hd__and2b_1
XFILLER_49_783 VGND VGND VPWR VPWR sky130_fd_sc_hd__fill_1
XTAP_TAPCELL_ROW_19_631 VGND VPWR sky130_fd_sc_hd__tapvpwrvgnd_1
XFILLER_36_433 VGND VGND VPWR VPWR sky130_fd_sc_hd__fill_1
XFILLER_91_561 VPWR VGND VPWR VGND sky130_ef_sc_hd__decap_12
XFILLER_64_775 VPWR VGND VPWR VGND sky130_ef_sc_hd__decap_12
XFILLER_52_904 VGND VGND VPWR VPWR sky130_fd_sc_hd__decap_6
XTAP_TAPCELL_ROW_19_642 VGND VPWR sky130_fd_sc_hd__tapvpwrvgnd_1
XFILLER_36_488 VPWR VGND VPWR VGND sky130_ef_sc_hd__decap_12
XFILLER_23_105 VGND VGND VPWR VPWR sky130_fd_sc_hd__decap_6
XFILLER_23_149 VPWR VGND VPWR VGND sky130_ef_sc_hd__decap_12
XFILLER_149_335 VGND VGND VPWR VPWR sky130_fd_sc_hd__fill_1
X_2816_ u_crt.r3\[3\] _0910_ _0184_ _0552_ VGND VGND VPWR VPWR _0040_ sky130_fd_sc_hd__a22o_1
XFILLER_20_867 VGND VGND VPWR VPWR sky130_fd_sc_hd__fill_1
XFILLER_31_193 VPWR VGND VPWR VGND sky130_ef_sc_hd__decap_12
XANTENNA__3220__CLK clknet_3_4__leaf_clk VGND VGND VPWR VPWR sky130_fd_sc_hd__diode_2
XFILLER_145_541 VPWR VGND VPWR VGND sky130_ef_sc_hd__decap_12
XFILLER_118_755 VGND VGND VPWR VPWR sky130_fd_sc_hd__fill_1
X_2747_ _0451_ _0486_ VGND VGND VPWR VPWR _0487_ sky130_fd_sc_hd__or2_1
XFILLER_11_27 VPWR VGND VPWR VGND sky130_ef_sc_hd__decap_12
XFILLER_145_585 VPWR VGND VPWR VGND sky130_ef_sc_hd__decap_12
XFILLER_127_27 VPWR VGND VPWR VGND sky130_ef_sc_hd__decap_12
XFILLER_105_405 VGND VGND VPWR VPWR sky130_fd_sc_hd__decap_6
X_2678_ OpSel_reg\[0\] OpSel_reg\[1\] a_r3\[0\] _0414_ VGND VGND VPWR VPWR _0418_
+ sky130_fd_sc_hd__or4_1
XTAP_TAPCELL_ROW_76_1547 VGND VPWR sky130_fd_sc_hd__tapvpwrvgnd_1
XFILLER_121_909 VGND VGND VPWR VPWR sky130_fd_sc_hd__fill_1
XFILLER_105_449 VPWR VGND VPWR VGND sky130_ef_sc_hd__decap_12
X_1629_ B_reg\[1\] VGND VGND VPWR VPWR _0909_ sky130_fd_sc_hd__inv_2
XFILLER_120_419 VGND VGND VPWR VPWR sky130_fd_sc_hd__fill_1
XFILLER_59_503 VGND VGND VPWR VPWR sky130_fd_sc_hd__fill_1
XFILLER_143_15 VPWR VGND VPWR VGND sky130_ef_sc_hd__decap_12
XFILLER_86_311 VPWR VGND VPWR VGND sky130_ef_sc_hd__decap_12
XANTENNA_input3_A A_in[11] VGND VGND VPWR VPWR sky130_fd_sc_hd__diode_2
XFILLER_100_121 VPWR VGND VPWR VGND sky130_ef_sc_hd__decap_12
XFILLER_87_889 VGND VGND VPWR VPWR sky130_fd_sc_hd__decap_6
XFILLER_100_165 VPWR VGND VPWR VGND sky130_ef_sc_hd__decap_12
XFILLER_86_377 VPWR VGND VPWR VGND sky130_ef_sc_hd__decap_12
XANTENNA__2089__B1 _0911_ VGND VGND VPWR VPWR sky130_fd_sc_hd__diode_2
XFILLER_27_400 VPWR VGND VPWR VGND sky130_ef_sc_hd__decap_12
XTAP_TAPCELL_ROW_107_2046 VGND VPWR sky130_fd_sc_hd__tapvpwrvgnd_1
XFILLER_55_753 VGND VGND VPWR VPWR sky130_fd_sc_hd__decap_3
XFILLER_27_444 VGND VGND VPWR VPWR sky130_fd_sc_hd__fill_2
XANTENNA__1836__B1 a_r1\[0\] VGND VGND VPWR VPWR sky130_fd_sc_hd__diode_2
XTAP_TAPCELL_ROW_38_940 VGND VPWR sky130_fd_sc_hd__tapvpwrvgnd_1
XFILLER_39_293 VPWR VGND VPWR VGND sky130_ef_sc_hd__decap_12
XFILLER_70_701 VPWR VGND VPWR VGND sky130_ef_sc_hd__decap_12
XFILLER_54_241 VGND VGND VPWR VPWR sky130_fd_sc_hd__fill_1
XFILLER_15_617 VPWR VGND VPWR VGND sky130_ef_sc_hd__decap_12
XTAP_TAPCELL_ROW_120_2246 VGND VPWR sky130_fd_sc_hd__tapvpwrvgnd_1
XFILLER_55_797 VPWR VGND VPWR VGND sky130_ef_sc_hd__decap_12
XTAP_TAPCELL_ROW_120_2257 VGND VPWR sky130_fd_sc_hd__tapvpwrvgnd_1
XFILLER_42_469 VGND VGND VPWR VPWR sky130_fd_sc_hd__decap_6
XFILLER_139_3 VPWR VGND VPWR VGND sky130_ef_sc_hd__decap_12
XFILLER_52_78 VGND VGND VPWR VPWR sky130_fd_sc_hd__fill_1
XFILLER_10_333 VGND VGND VPWR VPWR sky130_fd_sc_hd__decap_8
XFILLER_10_377 VPWR VGND VPWR VGND sky130_ef_sc_hd__decap_12
XFILLER_11_889 VGND VGND VPWR VPWR sky130_fd_sc_hd__decap_6
XFILLER_108_221 VPWR VGND VPWR VGND sky130_ef_sc_hd__decap_12
XFILLER_124_725 VPWR VGND VPWR VGND sky130_ef_sc_hd__decap_12
XFILLER_109_777 VGND VGND VPWR VPWR sky130_fd_sc_hd__decap_6
XFILLER_108_265 VPWR VGND VPWR VGND sky130_ef_sc_hd__decap_12
XFILLER_124_769 VPWR VGND VPWR VGND sky130_ef_sc_hd__decap_12
XFILLER_112_909 VGND VGND VPWR VPWR sky130_fd_sc_hd__fill_1
XANTENNA__2697__A a_r3\[1\] VGND VGND VPWR VPWR sky130_fd_sc_hd__diode_2
XFILLER_123_279 VGND VGND VPWR VPWR sky130_fd_sc_hd__fill_1
XFILLER_97_609 VGND VGND VPWR VPWR sky130_fd_sc_hd__decap_6
XFILLER_117_93 VPWR VGND VPWR VGND sky130_ef_sc_hd__decap_12
XFILLER_77_311 VPWR VGND VPWR VGND sky130_ef_sc_hd__decap_12
XFILLER_89_193 VPWR VGND VPWR VGND sky130_ef_sc_hd__decap_12
XFILLER_78_867 VGND VGND VPWR VPWR sky130_fd_sc_hd__fill_1
XFILLER_77_97 VPWR VGND VPWR VGND sky130_ef_sc_hd__decap_12
XFILLER_65_517 VPWR VGND VPWR VGND sky130_ef_sc_hd__decap_12
XFILLER_133_81 VPWR VGND VPWR VGND sky130_ef_sc_hd__decap_12
XFILLER_73_561 VPWR VGND VPWR VGND sky130_ef_sc_hd__decap_12
XFILLER_18_477 VPWR VGND VPWR VGND sky130_ef_sc_hd__decap_12
XANTENNA__3243__CLK clknet_3_6__leaf_clk VGND VGND VPWR VPWR sky130_fd_sc_hd__diode_2
X_1980_ B_reg\[1\] _1240_ _1243_ _1239_ VGND VGND VPWR VPWR _1245_ sky130_fd_sc_hd__a31o_1
XFILLER_60_233 VPWR VGND VPWR VGND sky130_ef_sc_hd__decap_12
XFILLER_21_609 VGND VGND VPWR VPWR sky130_fd_sc_hd__decap_6
XFILLER_33_447 VGND VGND VPWR VPWR sky130_fd_sc_hd__fill_1
XFILLER_13_193 VPWR VGND VPWR VGND sky130_ef_sc_hd__decap_12
XFILLER_147_839 VGND VGND VPWR VPWR sky130_fd_sc_hd__fill_1
XFILLER_127_541 VPWR VGND VPWR VGND sky130_ef_sc_hd__decap_12
X_2601_ _0186_ _0313_ _0342_ _0345_ VGND VGND VPWR VPWR _0346_ sky130_fd_sc_hd__o31a_1
XFILLER_127_585 VPWR VGND VPWR VGND sky130_ef_sc_hd__decap_12
X_2532_ _0268_ _0278_ _0279_ VGND VGND VPWR VPWR _0280_ sky130_fd_sc_hd__a21oi_1
XFILLER_142_533 VPWR VGND VPWR VGND sky130_ef_sc_hd__decap_12
XFILLER_103_909 VGND VGND VPWR VPWR sky130_fd_sc_hd__fill_1
XTAP_TAPCELL_ROW_58_1266 VGND VPWR sky130_fd_sc_hd__tapvpwrvgnd_1
XTAP_TAPCELL_ROW_58_1255 VGND VPWR sky130_fd_sc_hd__tapvpwrvgnd_1
XFILLER_6_893 VPWR VGND VPWR VGND sky130_ef_sc_hd__decap_12
XFILLER_102_408 VGND VGND VPWR VPWR sky130_fd_sc_hd__decap_6
X_2463_ _0201_ _0205_ _0206_ _0210_ VGND VGND VPWR VPWR _0213_ sky130_fd_sc_hd__and4_1
X_2394_ _0146_ _0147_ VGND VGND VPWR VPWR _0148_ sky130_fd_sc_hd__and2_1
XTAP_TAPCELL_ROW_71_1466 VGND VPWR sky130_fd_sc_hd__tapvpwrvgnd_1
XFILLER_69_889 VGND VGND VPWR VPWR sky130_fd_sc_hd__decap_6
XFILLER_68_344 VGND VGND VPWR VPWR sky130_fd_sc_hd__fill_1
XFILLER_29_709 VPWR VGND VPWR VGND sky130_ef_sc_hd__decap_12
XFILLER_84_837 VPWR VGND VPWR VGND sky130_ef_sc_hd__decap_12
XFILLER_68_377 VPWR VGND VPWR VGND sky130_ef_sc_hd__decap_12
XFILLER_95_185 VPWR VGND VPWR VGND sky130_ef_sc_hd__decap_12
X_3015_ _0604_ _0699_ _0701_ VGND VGND VPWR VPWR _0703_ sky130_fd_sc_hd__or3_1
XFILLER_52_701 VPWR VGND VPWR VGND sky130_ef_sc_hd__decap_12
XFILLER_36_230 VPWR VGND VPWR VGND sky130_ef_sc_hd__decap_12
XFILLER_37_753 VPWR VGND VPWR VGND sky130_ef_sc_hd__decap_12
XFILLER_92_881 VPWR VGND VPWR VGND sky130_ef_sc_hd__decap_12
XFILLER_37_797 VPWR VGND VPWR VGND sky130_ef_sc_hd__decap_12
XFILLER_91_391 VGND VGND VPWR VPWR sky130_fd_sc_hd__fill_1
XFILLER_51_244 VPWR VGND VPWR VGND sky130_ef_sc_hd__decap_12
XFILLER_24_469 VGND VGND VPWR VPWR sky130_fd_sc_hd__decap_6
XFILLER_22_15 VPWR VGND VPWR VGND sky130_ef_sc_hd__decap_12
XANTENNA__1686__A A_reg\[6\] VGND VGND VPWR VPWR sky130_fd_sc_hd__diode_2
XFILLER_138_15 VPWR VGND VPWR VGND sky130_ef_sc_hd__decap_12
XFILLER_137_305 VPWR VGND VPWR VGND sky130_ef_sc_hd__decap_12
XFILLER_153_809 VGND VGND VPWR VPWR sky130_fd_sc_hd__decap_3
XFILLER_137_349 VPWR VGND VPWR VGND sky130_ef_sc_hd__decap_12
XFILLER_146_861 VGND VGND VPWR VPWR sky130_fd_sc_hd__decap_6
XFILLER_106_725 VPWR VGND VPWR VGND sky130_ef_sc_hd__decap_12
XFILLER_145_393 VPWR VGND VPWR VGND sky130_ef_sc_hd__decap_12
XFILLER_106_769 VPWR VGND VPWR VGND sky130_ef_sc_hd__decap_12
XFILLER_105_279 VGND VGND VPWR VPWR sky130_fd_sc_hd__fill_1
XFILLER_59_300 VPWR VGND VPWR VGND sky130_ef_sc_hd__decap_12
XFILLER_86_141 VPWR VGND VPWR VGND sky130_ef_sc_hd__decap_12
XFILLER_87_697 VPWR VGND VPWR VGND sky130_ef_sc_hd__decap_12
XTAP_TAPCELL_ROW_89_1749 VGND VPWR sky130_fd_sc_hd__tapvpwrvgnd_1
XFILLER_103_51 VGND VGND VPWR VPWR sky130_fd_sc_hd__decap_4
XFILLER_74_369 VGND VGND VPWR VPWR sky130_fd_sc_hd__decap_8
XFILLER_55_561 VGND VGND VPWR VPWR sky130_fd_sc_hd__decap_8
XTAP_TAPCELL_ROW_2_362 VGND VPWR sky130_fd_sc_hd__tapvpwrvgnd_1
XANTENNA__3266__CLK clknet_3_7__leaf_clk VGND VGND VPWR VPWR sky130_fd_sc_hd__diode_2
XFILLER_63_11 VGND VGND VPWR VPWR sky130_fd_sc_hd__decap_3
XFILLER_70_531 VGND VGND VPWR VPWR sky130_fd_sc_hd__fill_1
XFILLER_15_447 VGND VGND VPWR VPWR sky130_fd_sc_hd__fill_1
XFILLER_42_233 VPWR VGND VPWR VGND sky130_ef_sc_hd__decap_12
XTAP_TAPCELL_ROW_100_1927 VGND VPWR sky130_fd_sc_hd__tapvpwrvgnd_1
XFILLER_30_406 VPWR VGND VPWR VGND sky130_ef_sc_hd__decap_12
XFILLER_42_277 VPWR VGND VPWR VGND sky130_ef_sc_hd__decap_12
XTAP_TAPCELL_ROW_42_1001 VGND VPWR sky130_fd_sc_hd__tapvpwrvgnd_1
XTAP_TAPCELL_ROW_100_1938 VGND VPWR sky130_fd_sc_hd__tapvpwrvgnd_1
XFILLER_129_839 VGND VGND VPWR VPWR sky130_fd_sc_hd__fill_1
XFILLER_10_141 VPWR VGND VPWR VGND sky130_ef_sc_hd__decap_12
XFILLER_11_653 VPWR VGND VPWR VGND sky130_ef_sc_hd__decap_12
XFILLER_11_697 VPWR VGND VPWR VGND sky130_ef_sc_hd__decap_12
XTAP_TAPCELL_ROW_21_670 VGND VPWR sky130_fd_sc_hd__tapvpwrvgnd_1
XANTENNA__3267__RESET_B net36 VGND VGND VPWR VPWR sky130_fd_sc_hd__diode_2
XTAP_TAPCELL_ROW_133_2459 VGND VPWR sky130_fd_sc_hd__tapvpwrvgnd_1
XFILLER_109_585 VPWR VGND VPWR VGND sky130_ef_sc_hd__decap_12
XFILLER_109_552 VGND VGND VPWR VPWR sky130_fd_sc_hd__decap_8
XFILLER_124_533 VPWR VGND VPWR VGND sky130_ef_sc_hd__decap_12
XFILLER_6_189 VGND VGND VPWR VPWR sky130_fd_sc_hd__decap_6
XFILLER_88_41 VPWR VGND VPWR VGND sky130_ef_sc_hd__decap_12
XFILLER_3_841 VPWR VGND VPWR VGND sky130_ef_sc_hd__decap_12
XFILLER_151_385 VGND VGND VPWR VPWR sky130_fd_sc_hd__decap_6
XFILLER_111_205 VPWR VGND VPWR VGND sky130_ef_sc_hd__decap_12
XFILLER_88_85 VPWR VGND VPWR VGND sky130_ef_sc_hd__decap_12
XFILLER_2_362 VGND VGND VPWR VPWR sky130_fd_sc_hd__fill_2
XFILLER_111_249 VPWR VGND VPWR VGND sky130_ef_sc_hd__decap_12
XFILLER_78_642 VGND VGND VPWR VPWR sky130_fd_sc_hd__fill_2
XTAP_TAPCELL_ROW_53_1174 VGND VPWR sky130_fd_sc_hd__tapvpwrvgnd_1
XFILLER_66_837 VPWR VGND VPWR VGND sky130_ef_sc_hd__decap_12
XTAP_TAPCELL_ROW_53_1185 VGND VPWR sky130_fd_sc_hd__tapvpwrvgnd_1
XFILLER_38_528 VGND VGND VPWR VPWR sky130_fd_sc_hd__decap_4
XFILLER_93_645 VPWR VGND VPWR VGND sky130_ef_sc_hd__decap_12
XFILLER_46_561 VGND VGND VPWR VPWR sky130_fd_sc_hd__fill_1
XFILLER_19_753 VPWR VGND VPWR VGND sky130_ef_sc_hd__decap_12
XFILLER_34_701 VPWR VGND VPWR VGND sky130_ef_sc_hd__decap_12
XFILLER_74_881 VPWR VGND VPWR VGND sky130_ef_sc_hd__decap_12
XFILLER_19_797 VPWR VGND VPWR VGND sky130_ef_sc_hd__decap_12
XFILLER_73_391 VGND VGND VPWR VPWR sky130_fd_sc_hd__fill_1
XFILLER_61_553 VGND VGND VPWR VPWR sky130_fd_sc_hd__decap_6
XTAP_TAPCELL_ROW_29_792 VGND VPWR sky130_fd_sc_hd__tapvpwrvgnd_1
XFILLER_61_597 VPWR VGND VPWR VGND sky130_ef_sc_hd__decap_12
X_1963_ B_reg\[4\] _1222_ VGND VGND VPWR VPWR _1228_ sky130_fd_sc_hd__nor2_1
XANTENNA__3197__S CRT_Start VGND VGND VPWR VPWR sky130_fd_sc_hd__diode_2
XFILLER_119_305 VPWR VGND VPWR VGND sky130_ef_sc_hd__decap_12
X_1894_ ALU_Done_all _0910_ net37 net35 VGND VGND VPWR VPWR _1162_ sky130_fd_sc_hd__a2bb2o_1
XFILLER_135_809 VPWR VGND VPWR VGND sky130_ef_sc_hd__decap_12
XFILLER_119_349 VPWR VGND VPWR VGND sky130_ef_sc_hd__decap_12
XFILLER_128_861 VGND VGND VPWR VPWR sky130_fd_sc_hd__decap_6
XFILLER_127_393 VPWR VGND VPWR VGND sky130_ef_sc_hd__decap_12
XFILLER_108_29 VPWR VGND VPWR VGND sky130_ef_sc_hd__decap_12
XTAP_TAPCELL_ROW_73_1506 VGND VPWR sky130_fd_sc_hd__tapvpwrvgnd_1
XFILLER_6_690 VGND VGND VPWR VPWR sky130_fd_sc_hd__decap_8
XFILLER_143_853 VPWR VGND VPWR VGND sky130_ef_sc_hd__decap_12
X_2515_ _0260_ _0261_ _0259_ VGND VGND VPWR VPWR _0263_ sky130_fd_sc_hd__a21oi_1
XFILLER_143_897 VPWR VGND VPWR VGND sky130_ef_sc_hd__decap_12
XFILLER_142_363 VGND VGND VPWR VPWR sky130_fd_sc_hd__fill_1
XFILLER_130_525 VGND VGND VPWR VPWR sky130_fd_sc_hd__decap_6
X_2446_ b_r0\[1\] _0193_ _0194_ b_r0\[0\] a_r0\[0\] VGND VGND VPWR VPWR _0196_ sky130_fd_sc_hd__a32o_1
XFILLER_130_569 VPWR VGND VPWR VGND sky130_ef_sc_hd__decap_12
XFILLER_68_130 VGND VGND VPWR VPWR sky130_fd_sc_hd__decap_8
XANTENNA__3289__CLK clknet_3_5__leaf_clk VGND VGND VPWR VPWR sky130_fd_sc_hd__diode_2
XFILLER_111_783 VGND VGND VPWR VPWR sky130_fd_sc_hd__fill_1
X_2377_ _0115_ _0130_ VGND VGND VPWR VPWR _0131_ sky130_fd_sc_hd__xnor2_1
XFILLER_84_623 VPWR VGND VPWR VGND sky130_ef_sc_hd__decap_12
XFILLER_69_697 VPWR VGND VPWR VGND sky130_ef_sc_hd__decap_12
XFILLER_68_141 VPWR VGND VPWR VGND sky130_ef_sc_hd__decap_12
XFILLER_29_517 VPWR VGND VPWR VGND sky130_ef_sc_hd__decap_12
XFILLER_84_645 VPWR VGND VPWR VGND sky130_ef_sc_hd__decap_12
XFILLER_29_539 VPWR VGND VPWR VGND sky130_ef_sc_hd__decap_12
XFILLER_17_15 VPWR VGND VPWR VGND sky130_ef_sc_hd__decap_12
XFILLER_140_27 VGND VGND VPWR VPWR sky130_fd_sc_hd__fill_1
XFILLER_71_317 VPWR VGND VPWR VGND sky130_ef_sc_hd__decap_12
XTAP_TAPCELL_ROW_84_1668 VGND VPWR sky130_fd_sc_hd__tapvpwrvgnd_1
XFILLER_52_553 VGND VGND VPWR VPWR sky130_fd_sc_hd__fill_2
XFILLER_24_233 VGND VGND VPWR VPWR sky130_fd_sc_hd__decap_3
XTAP_TAPCELL_ROW_84_1679 VGND VPWR sky130_fd_sc_hd__tapvpwrvgnd_1
XFILLER_24_277 VPWR VGND VPWR VGND sky130_ef_sc_hd__decap_12
XFILLER_40_737 VGND VGND VPWR VPWR sky130_fd_sc_hd__decap_6
XPHY_EDGE_ROW_135_Left_289 VGND VGND VPWR VPWR sky130_fd_sc_hd__decap_3
XFILLER_138_625 VPWR VGND VPWR VGND sky130_ef_sc_hd__decap_12
XFILLER_137_113 VPWR VGND VPWR VGND sky130_ef_sc_hd__decap_12
XFILLER_33_69 VPWR VGND VPWR VGND sky130_ef_sc_hd__decap_12
XFILLER_149_69 VPWR VGND VPWR VGND sky130_ef_sc_hd__decap_12
XFILLER_138_669 VPWR VGND VPWR VGND sky130_ef_sc_hd__decap_12
XFILLER_153_617 VPWR VGND VPWR VGND sky130_ef_sc_hd__decap_12
XTAP_TAPCELL_ROW_115_2178 VGND VPWR sky130_fd_sc_hd__tapvpwrvgnd_1
XTAP_TAPCELL_ROW_115_2167 VGND VPWR sky130_fd_sc_hd__tapvpwrvgnd_1
XFILLER_106_533 VGND VGND VPWR VPWR sky130_fd_sc_hd__decap_3
XFILLER_4_638 VGND VGND VPWR VPWR sky130_fd_sc_hd__decap_4
XFILLER_106_544 VGND VGND VPWR VPWR sky130_fd_sc_hd__decap_8
XFILLER_3_137 VPWR VGND VPWR VGND sky130_ef_sc_hd__decap_12
XFILLER_133_385 VGND VGND VPWR VPWR sky130_fd_sc_hd__decap_6
XFILLER_121_503 VGND VGND VPWR VPWR sky130_fd_sc_hd__fill_1
XANTENNA__2678__C a_r3\[0\] VGND VGND VPWR VPWR sky130_fd_sc_hd__diode_2
XPHY_EDGE_ROW_144_Left_298 VGND VGND VPWR VPWR sky130_fd_sc_hd__decap_3
XTAP_TAPCELL_ROW_7_443 VGND VPWR sky130_fd_sc_hd__tapvpwrvgnd_1
XFILLER_87_461 VPWR VGND VPWR VGND sky130_ef_sc_hd__decap_12
XANTENNA__2152__C1 A_reg\[15\] VGND VGND VPWR VPWR sky130_fd_sc_hd__diode_2
XFILLER_101_293 VPWR VGND VPWR VGND sky130_ef_sc_hd__decap_12
XFILLER_114_83 VGND VGND VPWR VPWR sky130_fd_sc_hd__fill_1
XFILLER_90_615 VPWR VGND VPWR VGND sky130_ef_sc_hd__decap_12
XFILLER_74_133 VGND VGND VPWR VPWR sky130_fd_sc_hd__decap_6
XFILLER_16_701 VPWR VGND VPWR VGND sky130_ef_sc_hd__decap_12
XFILLER_74_65 VGND VGND VPWR VPWR sky130_fd_sc_hd__decap_8
XFILLER_56_881 VPWR VGND VPWR VGND sky130_ef_sc_hd__decap_12
XFILLER_15_233 VGND VGND VPWR VPWR sky130_fd_sc_hd__decap_3
XTAP_TAPCELL_ROW_26_740 VGND VPWR sky130_fd_sc_hd__tapvpwrvgnd_1
XFILLER_71_895 VGND VGND VPWR VPWR sky130_fd_sc_hd__fill_1
XTAP_TAPCELL_ROW_26_751 VGND VPWR sky130_fd_sc_hd__tapvpwrvgnd_1
XFILLER_43_597 VPWR VGND VPWR VGND sky130_ef_sc_hd__decap_12
XFILLER_30_247 VGND VGND VPWR VPWR sky130_fd_sc_hd__decap_4
XFILLER_117_809 VPWR VGND VPWR VGND sky130_ef_sc_hd__decap_12
XFILLER_143_105 VGND VGND VPWR VPWR sky130_fd_sc_hd__decap_6
XFILLER_109_393 VPWR VGND VPWR VGND sky130_ef_sc_hd__decap_12
XFILLER_99_51 VGND VGND VPWR VPWR sky130_fd_sc_hd__decap_4
XFILLER_143_149 VPWR VGND VPWR VGND sky130_ef_sc_hd__decap_12
XFILLER_125_853 VPWR VGND VPWR VGND sky130_ef_sc_hd__decap_12
XTAP_TAPCELL_ROW_55_1214 VGND VPWR sky130_fd_sc_hd__tapvpwrvgnd_1
XFILLER_125_897 VPWR VGND VPWR VGND sky130_ef_sc_hd__decap_12
XFILLER_124_363 VGND VGND VPWR VPWR sky130_fd_sc_hd__fill_1
XFILLER_98_737 VPWR VGND VPWR VGND sky130_ef_sc_hd__decap_12
XFILLER_97_225 VPWR VGND VPWR VGND sky130_ef_sc_hd__decap_12
XANTENNA__2930__A1 _0554_ VGND VGND VPWR VPWR sky130_fd_sc_hd__diode_2
XANTENNA__1733__A2 _0911_ VGND VGND VPWR VPWR sky130_fd_sc_hd__diode_2
X_2300_ _0899_ _1175_ _1549_ _1551_ VGND VGND VPWR VPWR _1553_ sky130_fd_sc_hd__or4_1
XFILLER_3_671 VGND VGND VPWR VPWR sky130_fd_sc_hd__fill_1
X_3280_ clknet_3_0__leaf_clk _0063_ net36 VGND VGND VPWR VPWR A_reg\[6\] sky130_fd_sc_hd__dfrtp_4
XFILLER_151_193 VPWR VGND VPWR VGND sky130_ef_sc_hd__decap_12
XFILLER_140_867 VGND VGND VPWR VPWR sky130_fd_sc_hd__fill_1
XFILLER_112_569 VPWR VGND VPWR VGND sky130_ef_sc_hd__decap_12
X_2231_ A_reg\[5\] _1486_ VGND VGND VPWR VPWR _1488_ sky130_fd_sc_hd__xnor2_1
XFILLER_97_269 VGND VGND VPWR VPWR sky130_fd_sc_hd__fill_2
XFILLER_66_601 VPWR VGND VPWR VGND sky130_ef_sc_hd__decap_12
XFILLER_66_645 VPWR VGND VPWR VGND sky130_ef_sc_hd__decap_12
XFILLER_65_111 VGND VGND VPWR VPWR sky130_fd_sc_hd__fill_1
X_2162_ _1417_ _1418_ VGND VGND VPWR VPWR _1419_ sky130_fd_sc_hd__or2_1
XFILLER_17_3 VPWR VGND VPWR VGND sky130_ef_sc_hd__decap_12
X_2093_ _1346_ _1348_ _1347_ VGND VGND VPWR VPWR _1353_ sky130_fd_sc_hd__o21ai_1
XFILLER_53_317 VPWR VGND VPWR VGND sky130_ef_sc_hd__decap_12
XFILLER_19_561 VPWR VGND VPWR VGND sky130_ef_sc_hd__decap_12
XTAP_TAPCELL_ROW_66_1387 VGND VPWR sky130_fd_sc_hd__tapvpwrvgnd_1
XFILLER_61_361 VGND VGND VPWR VPWR sky130_fd_sc_hd__decap_6
XANTENNA__2824__S _0553_ VGND VGND VPWR VPWR sky130_fd_sc_hd__diode_2
XFILLER_21_225 VGND VGND VPWR VPWR sky130_fd_sc_hd__fill_1
XFILLER_21_236 VGND VGND VPWR VPWR sky130_fd_sc_hd__fill_2
XFILLER_22_737 VPWR VGND VPWR VGND sky130_ef_sc_hd__decap_12
XANTENNA__2125__A B_reg\[5\] VGND VGND VPWR VPWR sky130_fd_sc_hd__diode_2
X_2995_ _0681_ _0682_ VGND VGND VPWR VPWR _0683_ sky130_fd_sc_hd__nand2_1
XFILLER_119_113 VPWR VGND VPWR VGND sky130_ef_sc_hd__decap_12
X_1946_ _1199_ _1210_ VGND VGND VPWR VPWR _1211_ sky130_fd_sc_hd__xnor2_1
XFILLER_9_93 VPWR VGND VPWR VGND sky130_ef_sc_hd__decap_12
XFILLER_30_781 VPWR VGND VPWR VGND sky130_ef_sc_hd__decap_12
XFILLER_135_617 VPWR VGND VPWR VGND sky130_ef_sc_hd__decap_12
XFILLER_119_39 VPWR VGND VPWR VGND sky130_ef_sc_hd__decap_12
X_1877_ _1145_ _1146_ A_reg\[3\] VGND VGND VPWR VPWR _1147_ sky130_fd_sc_hd__o21ai_1
XANTENNA__3174__A1 _0912_ VGND VGND VPWR VPWR sky130_fd_sc_hd__diode_2
XFILLER_135_27 VPWR VGND VPWR VGND sky130_ef_sc_hd__decap_12
XFILLER_115_385 VGND VGND VPWR VPWR sky130_fd_sc_hd__decap_6
XFILLER_103_503 VGND VGND VPWR VPWR sky130_fd_sc_hd__fill_1
XFILLER_130_333 VPWR VGND VPWR VGND sky130_ef_sc_hd__decap_12
XFILLER_88_247 VGND VGND VPWR VPWR sky130_fd_sc_hd__decap_4
XFILLER_131_889 VGND VGND VPWR VPWR sky130_fd_sc_hd__decap_6
XFILLER_130_377 VPWR VGND VPWR VGND sky130_ef_sc_hd__decap_12
XTAP_TAPCELL_ROW_110_2097 VGND VPWR sky130_fd_sc_hd__tapvpwrvgnd_1
XTAP_TAPCELL_ROW_110_2086 VGND VPWR sky130_fd_sc_hd__tapvpwrvgnd_1
X_2429_ _0170_ _0180_ VGND VGND VPWR VPWR _0181_ sky130_fd_sc_hd__xor2_1
XFILLER_69_461 VPWR VGND VPWR VGND sky130_ef_sc_hd__decap_12
XTAP_TAPCELL_ROW_4_402 VGND VPWR sky130_fd_sc_hd__tapvpwrvgnd_1
XFILLER_151_15 VPWR VGND VPWR VGND sky130_ef_sc_hd__decap_12
XTAP_TAPCELL_ROW_86_1708 VGND VPWR sky130_fd_sc_hd__tapvpwrvgnd_1
XFILLER_84_475 VGND VGND VPWR VPWR sky130_fd_sc_hd__fill_1
XFILLER_72_637 VGND VGND VPWR VPWR sky130_fd_sc_hd__decap_6
XFILLER_56_177 VPWR VGND VPWR VGND sky130_ef_sc_hd__decap_12
XFILLER_37_391 VGND VGND VPWR VPWR sky130_fd_sc_hd__fill_1
XFILLER_71_169 VPWR VGND VPWR VGND sky130_ef_sc_hd__decap_12
XFILLER_53_895 VGND VGND VPWR VPWR sky130_fd_sc_hd__fill_1
XFILLER_25_553 VGND VGND VPWR VPWR sky130_fd_sc_hd__decap_6
XFILLER_80_681 VPWR VGND VPWR VGND sky130_ef_sc_hd__decap_12
XANTENNA__3304__CLK clknet_3_0__leaf_clk VGND VGND VPWR VPWR sky130_fd_sc_hd__diode_2
XFILLER_25_597 VPWR VGND VPWR VGND sky130_ef_sc_hd__decap_12
XFILLER_40_545 VPWR VGND VPWR VGND sky130_ef_sc_hd__decap_12
XFILLER_100_41 VPWR VGND VPWR VGND sky130_ef_sc_hd__decap_12
XFILLER_138_433 VPWR VGND VPWR VGND sky130_ef_sc_hd__decap_12
XTAP_TAPCELL_ROW_117_2207 VGND VPWR sky130_fd_sc_hd__tapvpwrvgnd_1
XFILLER_100_85 VPWR VGND VPWR VGND sky130_ef_sc_hd__decap_12
XFILLER_60_45 VGND VGND VPWR VPWR sky130_fd_sc_hd__fill_1
XFILLER_40_589 VPWR VGND VPWR VGND sky130_ef_sc_hd__decap_12
XFILLER_138_477 VPWR VGND VPWR VGND sky130_ef_sc_hd__decap_12
XFILLER_121_3 VPWR VGND VPWR VGND sky130_ef_sc_hd__decap_12
XTAP_TAPCELL_ROW_130_2418 VGND VPWR sky130_fd_sc_hd__tapvpwrvgnd_1
XTAP_TAPCELL_ROW_130_2407 VGND VPWR sky130_fd_sc_hd__tapvpwrvgnd_1
XFILLER_125_105 VGND VGND VPWR VPWR sky130_fd_sc_hd__decap_6
XFILLER_4_413 VGND VGND VPWR VPWR sky130_fd_sc_hd__fill_1
XPHY_EDGE_ROW_152_Left_306 VGND VGND VPWR VPWR sky130_fd_sc_hd__decap_3
XFILLER_141_609 VGND VGND VPWR VPWR sky130_fd_sc_hd__decap_6
XFILLER_125_149 VPWR VGND VPWR VGND sky130_ef_sc_hd__decap_12
XFILLER_107_853 VPWR VGND VPWR VGND sky130_ef_sc_hd__decap_12
XFILLER_69_10 VPWR VGND VPWR VGND sky130_ef_sc_hd__decap_12
XFILLER_4_457 VPWR VGND VPWR VGND sky130_ef_sc_hd__decap_12
XFILLER_107_897 VPWR VGND VPWR VGND sky130_ef_sc_hd__decap_12
XFILLER_106_363 VGND VGND VPWR VPWR sky130_fd_sc_hd__fill_1
XFILLER_69_54 VGND VGND VPWR VPWR sky130_fd_sc_hd__fill_2
XFILLER_133_193 VPWR VGND VPWR VGND sky130_ef_sc_hd__decap_12
XFILLER_122_867 VGND VGND VPWR VPWR sky130_fd_sc_hd__fill_1
XFILLER_79_258 VPWR VGND VPWR VGND sky130_ef_sc_hd__decap_12
XFILLER_79_247 VGND VGND VPWR VPWR sky130_fd_sc_hd__decap_3
XFILLER_95_729 VPWR VGND VPWR VGND sky130_ef_sc_hd__decap_12
XFILLER_48_601 VGND VGND VPWR VPWR sky130_fd_sc_hd__decap_3
XFILLER_125_93 VPWR VGND VPWR VGND sky130_ef_sc_hd__decap_12
XFILLER_102_580 VGND VGND VPWR VPWR sky130_fd_sc_hd__decap_8
XFILLER_88_781 VPWR VGND VPWR VGND sky130_ef_sc_hd__decap_12
XTAP_TAPCELL_ROW_50_1133 VGND VPWR sky130_fd_sc_hd__tapvpwrvgnd_1
XFILLER_48_645 VPWR VGND VPWR VGND sky130_ef_sc_hd__decap_12
XFILLER_48_623 VGND VGND VPWR VPWR sky130_fd_sc_hd__fill_2
XFILLER_0_685 VPWR VGND VPWR VGND sky130_ef_sc_hd__decap_12
XFILLER_47_111 VGND VGND VPWR VPWR sky130_fd_sc_hd__fill_1
XTAP_TAPCELL_ROW_145_2650 VGND VPWR sky130_fd_sc_hd__tapvpwrvgnd_1
XFILLER_75_497 VGND VGND VPWR VPWR sky130_fd_sc_hd__decap_6
XFILLER_63_615 VGND VGND VPWR VPWR sky130_fd_sc_hd__fill_1
XFILLER_141_81 VPWR VGND VPWR VGND sky130_ef_sc_hd__decap_12
XFILLER_16_531 VGND VGND VPWR VPWR sky130_fd_sc_hd__fill_1
XFILLER_90_489 VPWR VGND VPWR VGND sky130_ef_sc_hd__decap_12
XFILLER_90_467 VGND VGND VPWR VPWR sky130_fd_sc_hd__decap_8
XFILLER_50_309 VPWR VGND VPWR VGND sky130_ef_sc_hd__decap_12
XFILLER_149_709 VPWR VGND VPWR VGND sky130_ef_sc_hd__decap_12
XTAP_TAPCELL_ROW_48_1095 VGND VPWR sky130_fd_sc_hd__tapvpwrvgnd_1
XANTENNA__3282__RESET_B net36 VGND VGND VPWR VPWR sky130_fd_sc_hd__diode_2
X_1800_ A_reg\[4\] _1071_ _1072_ VGND VGND VPWR VPWR _1073_ sky130_fd_sc_hd__o21ai_1
X_2780_ _0513_ _0514_ _0519_ VGND VGND VPWR VPWR _0520_ sky130_fd_sc_hd__o21ai_1
XFILLER_12_781 VPWR VGND VPWR VGND sky130_ef_sc_hd__decap_12
XFILLER_117_617 VPWR VGND VPWR VGND sky130_ef_sc_hd__decap_12
X_1731_ A_reg\[1\] _0991_ _0989_ VGND VGND VPWR VPWR _1005_ sky130_fd_sc_hd__a21oi_1
XPHY_EDGE_ROW_152_Right_152 VGND VGND VPWR VPWR sky130_fd_sc_hd__decap_3
XFILLER_7_273 VGND VGND VPWR VPWR sky130_fd_sc_hd__decap_6
X_1662_ _0889_ _0932_ _0936_ VGND VGND VPWR VPWR _0938_ sky130_fd_sc_hd__and3_1
XFILLER_144_469 VGND VGND VPWR VPWR sky130_fd_sc_hd__decap_6
XFILLER_98_501 VPWR VGND VPWR VGND sky130_ef_sc_hd__decap_12
XFILLER_112_333 VPWR VGND VPWR VGND sky130_ef_sc_hd__decap_12
XFILLER_98_556 VPWR VGND VPWR VGND sky130_ef_sc_hd__decap_12
XFILLER_98_545 VGND VGND VPWR VPWR sky130_fd_sc_hd__decap_6
XFILLER_113_889 VGND VGND VPWR VPWR sky130_fd_sc_hd__decap_6
XFILLER_112_377 VPWR VGND VPWR VGND sky130_ef_sc_hd__decap_12
XFILLER_98_589 VPWR VGND VPWR VGND sky130_ef_sc_hd__decap_12
XFILLER_79_770 VPWR VGND VPWR VGND sky130_ef_sc_hd__decap_12
X_3263_ clknet_3_7__leaf_clk _0046_ net36 VGND VGND VPWR VPWR net49 sky130_fd_sc_hd__dfrtp_1
XANTENNA__2819__S _0553_ VGND VGND VPWR VPWR sky130_fd_sc_hd__diode_2
X_2214_ _1468_ _1469_ A_reg\[6\] _1463_ VGND VGND VPWR VPWR _1471_ sky130_fd_sc_hd__a2bb2o_1
X_3194_ _0847_ _0848_ _0858_ VGND VGND VPWR VPWR _0875_ sky130_fd_sc_hd__o21ba_1
X_2145_ B_reg\[0\] _1403_ _0911_ VGND VGND VPWR VPWR _1404_ sky130_fd_sc_hd__a21oi_1
XFILLER_38_133 VGND VGND VPWR VPWR sky130_fd_sc_hd__decap_6
XFILLER_93_261 VPWR VGND VPWR VGND sky130_ef_sc_hd__decap_12
XFILLER_81_423 VPWR VGND VPWR VGND sky130_ef_sc_hd__decap_12
XTAP_TAPCELL_ROW_68_1427 VGND VPWR sky130_fd_sc_hd__tapvpwrvgnd_1
XTAP_TAPCELL_ROW_68_1416 VGND VPWR sky130_fd_sc_hd__tapvpwrvgnd_1
XFILLER_66_475 VGND VGND VPWR VPWR sky130_fd_sc_hd__fill_1
XFILLER_38_177 VPWR VGND VPWR VGND sky130_ef_sc_hd__decap_12
X_2076_ _1332_ _1337_ VGND VGND VPWR VPWR _1338_ sky130_fd_sc_hd__xnor2_1
XFILLER_81_489 VGND VGND VPWR VPWR sky130_fd_sc_hd__fill_1
Xclkbuf_3_5__f_clk clknet_0_clk VGND VGND VPWR VPWR clknet_3_5__leaf_clk sky130_fd_sc_hd__clkbuf_16
XFILLER_22_501 VPWR VGND VPWR VGND sky130_ef_sc_hd__decap_12
XTAP_TAPCELL_ROW_81_1627 VGND VPWR sky130_fd_sc_hd__tapvpwrvgnd_1
XFILLER_14_27 VGND VGND VPWR VPWR sky130_fd_sc_hd__fill_1
XFILLER_35_895 VGND VGND VPWR VPWR sky130_fd_sc_hd__fill_1
XFILLER_22_545 VPWR VGND VPWR VGND sky130_ef_sc_hd__decap_12
X_2978_ _0564_ _0571_ VGND VGND VPWR VPWR _0666_ sky130_fd_sc_hd__xnor2_1
XFILLER_22_589 VPWR VGND VPWR VGND sky130_ef_sc_hd__decap_12
X_1929_ _1173_ _1188_ _1192_ _1193_ VGND VGND VPWR VPWR _1194_ sky130_fd_sc_hd__o22a_1
XFILLER_107_105 VGND VGND VPWR VPWR sky130_fd_sc_hd__decap_6
XFILLER_30_15 VPWR VGND VPWR VGND sky130_ef_sc_hd__decap_12
XFILLER_146_15 VPWR VGND VPWR VGND sky130_ef_sc_hd__decap_12
XFILLER_135_447 VGND VGND VPWR VPWR sky130_fd_sc_hd__fill_1
XFILLER_123_609 VGND VGND VPWR VPWR sky130_fd_sc_hd__decap_6
XTAP_TAPCELL_ROW_112_2126 VGND VPWR sky130_fd_sc_hd__tapvpwrvgnd_1
XFILLER_107_149 VPWR VGND VPWR VGND sky130_ef_sc_hd__decap_12
XTAP_TAPCELL_ROW_96_1870 VGND VPWR sky130_fd_sc_hd__tapvpwrvgnd_1
XTAP_TAPCELL_ROW_79_1589 VGND VPWR sky130_fd_sc_hd__tapvpwrvgnd_1
XFILLER_1_405 VPWR VGND VPWR VGND sky130_ef_sc_hd__decap_12
XFILLER_115_193 VPWR VGND VPWR VGND sky130_ef_sc_hd__decap_12
XFILLER_104_867 VGND VGND VPWR VPWR sky130_fd_sc_hd__fill_1
XFILLER_1_449 VPWR VGND VPWR VGND sky130_ef_sc_hd__decap_12
XFILLER_131_653 VPWR VGND VPWR VGND sky130_ef_sc_hd__decap_12
XFILLER_130_141 VPWR VGND VPWR VGND sky130_ef_sc_hd__decap_12
XFILLER_103_377 VPWR VGND VPWR VGND sky130_ef_sc_hd__decap_12
XFILLER_77_729 VGND VGND VPWR VPWR sky130_fd_sc_hd__decap_4
XFILLER_39_57 VPWR VGND VPWR VGND sky130_ef_sc_hd__decap_12
XFILLER_131_697 VPWR VGND VPWR VGND sky130_ef_sc_hd__decap_12
XFILLER_57_420 VGND VGND VPWR VPWR sky130_fd_sc_hd__fill_1
XFILLER_29_111 VGND VGND VPWR VPWR sky130_fd_sc_hd__fill_1
XFILLER_72_401 VPWR VGND VPWR VGND sky130_ef_sc_hd__decap_12
XFILLER_57_497 VGND VGND VPWR VPWR sky130_fd_sc_hd__decap_6
XFILLER_17_328 VGND VGND VPWR VPWR sky130_fd_sc_hd__decap_8
XFILLER_45_615 VGND VGND VPWR VPWR sky130_fd_sc_hd__fill_1
XFILLER_45_637 VPWR VGND VPWR VGND sky130_ef_sc_hd__decap_12
XFILLER_72_445 VGND VGND VPWR VPWR sky130_fd_sc_hd__fill_2
XFILLER_55_78 VPWR VGND VPWR VGND sky130_ef_sc_hd__decap_12
XTAP_TAPCELL_ROW_123_2299 VGND VPWR sky130_fd_sc_hd__tapvpwrvgnd_1
XFILLER_25_361 VGND VGND VPWR VPWR sky130_fd_sc_hd__decap_8
XFILLER_32_309 VPWR VGND VPWR VGND sky130_ef_sc_hd__decap_12
XFILLER_111_51 VGND VGND VPWR VPWR sky130_fd_sc_hd__decap_4
XFILLER_71_55 VGND VGND VPWR VPWR sky130_fd_sc_hd__fill_1
XFILLER_9_505 VPWR VGND VPWR VGND sky130_ef_sc_hd__decap_12
XFILLER_41_865 VPWR VGND VPWR VGND sky130_ef_sc_hd__decap_12
XFILLER_139_753 VPWR VGND VPWR VGND sky130_ef_sc_hd__decap_12
XFILLER_139_797 VPWR VGND VPWR VGND sky130_ef_sc_hd__decap_12
XFILLER_126_469 VGND VGND VPWR VPWR sky130_fd_sc_hd__decap_6
XFILLER_4_221 VGND VGND VPWR VPWR sky130_fd_sc_hd__decap_8
XFILLER_153_277 VGND VGND VPWR VPWR sky130_fd_sc_hd__decap_3
XFILLER_141_417 VPWR VGND VPWR VGND sky130_ef_sc_hd__decap_12
XFILLER_5_777 VGND VGND VPWR VPWR sky130_fd_sc_hd__decap_6
XFILLER_4_265 VPWR VGND VPWR VGND sky130_ef_sc_hd__decap_12
XFILLER_96_41 VPWR VGND VPWR VGND sky130_ef_sc_hd__decap_12
XFILLER_68_707 VGND VGND VPWR VPWR sky130_fd_sc_hd__fill_1
XFILLER_110_837 VPWR VGND VPWR VGND sky130_ef_sc_hd__decap_12
XFILLER_96_85 VPWR VGND VPWR VGND sky130_ef_sc_hd__decap_12
XFILLER_95_559 VGND VGND VPWR VPWR sky130_fd_sc_hd__fill_1
XANTENNA__2649__B1 OpSel_reg\[0\] VGND VGND VPWR VPWR sky130_fd_sc_hd__diode_2
XFILLER_76_762 VPWR VGND VPWR VGND sky130_ef_sc_hd__decap_12
XFILLER_91_721 VGND VGND VPWR VPWR sky130_fd_sc_hd__decap_6
XFILLER_82_209 VPWR VGND VPWR VGND sky130_ef_sc_hd__decap_12
XFILLER_75_261 VPWR VGND VPWR VGND sky130_ef_sc_hd__decap_12
XFILLER_36_637 VGND VGND VPWR VPWR sky130_fd_sc_hd__decap_6
XFILLER_91_765 VPWR VGND VPWR VGND sky130_ef_sc_hd__decap_12
XFILLER_35_125 VPWR VGND VPWR VGND sky130_ef_sc_hd__decap_12
XFILLER_51_629 VPWR VGND VPWR VGND sky130_ef_sc_hd__decap_12
XFILLER_35_169 VPWR VGND VPWR VGND sky130_ef_sc_hd__decap_12
X_2901_ _0566_ _0588_ VGND VGND VPWR VPWR _0589_ sky130_fd_sc_hd__and2_1
XTAP_TAPCELL_ROW_63_1335 VGND VPWR sky130_fd_sc_hd__tapvpwrvgnd_1
XFILLER_50_139 VGND VGND VPWR VPWR sky130_fd_sc_hd__fill_1
XFILLER_17_895 VGND VGND VPWR VPWR sky130_fd_sc_hd__fill_1
XFILLER_149_517 VPWR VGND VPWR VGND sky130_ef_sc_hd__decap_12
XTAP_TAPCELL_ROW_63_1346 VGND VPWR sky130_fd_sc_hd__tapvpwrvgnd_1
XFILLER_32_854 VGND VGND VPWR VPWR sky130_fd_sc_hd__decap_3
X_2832_ net43 X_crt\[14\] _0553_ VGND VGND VPWR VPWR _0055_ sky130_fd_sc_hd__mux2_1
XTAP_TAPCELL_ROW_14_551 VGND VPWR sky130_fd_sc_hd__tapvpwrvgnd_1
XTAP_TAPCELL_ROW_14_562 VGND VPWR sky130_fd_sc_hd__tapvpwrvgnd_1
X_2763_ _0469_ _0483_ _0493_ _0500_ VGND VGND VPWR VPWR _0503_ sky130_fd_sc_hd__a22oi_1
X_1714_ _0981_ _0988_ _0982_ VGND VGND VPWR VPWR _0990_ sky130_fd_sc_hd__o21ba_1
XFILLER_144_233 VPWR VGND VPWR VGND sky130_ef_sc_hd__decap_12
XFILLER_117_447 VGND VGND VPWR VPWR sky130_fd_sc_hd__fill_1
X_2694_ _0400_ _0402_ _0404_ VGND VGND VPWR VPWR _0434_ sky130_fd_sc_hd__or3_1
XFILLER_144_277 VPWR VGND VPWR VGND sky130_ef_sc_hd__decap_12
XFILLER_99_821 VPWR VGND VPWR VGND sky130_ef_sc_hd__decap_12
XFILLER_6_83 VGND VGND VPWR VPWR sky130_fd_sc_hd__fill_1
X_1645_ _0919_ _0920_ VGND VGND VPWR VPWR _0921_ sky130_fd_sc_hd__and2_1
XFILLER_116_29 VPWR VGND VPWR VGND sky130_ef_sc_hd__decap_12
XFILLER_99_865 VPWR VGND VPWR VGND sky130_ef_sc_hd__decap_12
XFILLER_113_653 VPWR VGND VPWR VGND sky130_ef_sc_hd__decap_12
XFILLER_112_141 VPWR VGND VPWR VGND sky130_ef_sc_hd__decap_12
XFILLER_98_342 VPWR VGND VPWR VGND sky130_ef_sc_hd__decap_12
XFILLER_86_504 VPWR VGND VPWR VGND sky130_ef_sc_hd__decap_12
XFILLER_59_729 VPWR VGND VPWR VGND sky130_ef_sc_hd__decap_12
X_3315_ clknet_3_7__leaf_clk _0098_ net36 VGND VGND VPWR VPWR X_crt\[9\] sky130_fd_sc_hd__dfrtp_1
XFILLER_113_697 VPWR VGND VPWR VGND sky130_ef_sc_hd__decap_12
X_3246_ clknet_3_6__leaf_clk _0031_ net36 VGND VGND VPWR VPWR u_crt.r1\[2\] sky130_fd_sc_hd__dfrtp_1
XFILLER_73_209 VPWR VGND VPWR VGND sky130_ef_sc_hd__decap_12
XFILLER_27_615 VGND VGND VPWR VPWR sky130_fd_sc_hd__fill_1
X_3177_ _0832_ _0858_ VGND VGND VPWR VPWR _0863_ sky130_fd_sc_hd__or2_1
X_2128_ _1384_ _1386_ VGND VGND VPWR VPWR _1387_ sky130_fd_sc_hd__nand2_1
XFILLER_54_445 VPWR VGND VPWR VGND sky130_ef_sc_hd__decap_12
X_2059_ _1310_ _1313_ _1320_ VGND VGND VPWR VPWR _1321_ sky130_fd_sc_hd__o21ba_1
XFILLER_70_905 VGND VGND VPWR VPWR sky130_fd_sc_hd__decap_4
XFILLER_54_467 VGND VGND VPWR VPWR sky130_fd_sc_hd__decap_8
XFILLER_14_309 VPWR VGND VPWR VGND sky130_ef_sc_hd__decap_12
XFILLER_25_15 VPWR VGND VPWR VGND sky130_ef_sc_hd__decap_12
XFILLER_42_629 VGND VGND VPWR VPWR sky130_fd_sc_hd__fill_1
XFILLER_23_821 VPWR VGND VPWR VGND sky130_ef_sc_hd__decap_12
XFILLER_23_865 VPWR VGND VPWR VGND sky130_ef_sc_hd__decap_12
XTAP_TAPCELL_ROW_33_860 VGND VPWR sky130_fd_sc_hd__tapvpwrvgnd_1
XFILLER_136_701 VPWR VGND VPWR VGND sky130_ef_sc_hd__decap_12
XFILLER_41_69 VPWR VGND VPWR VGND sky130_ef_sc_hd__decap_12
XTAP_TAPCELL_ROW_94_1829 VGND VPWR sky130_fd_sc_hd__tapvpwrvgnd_1
XFILLER_123_417 VPWR VGND VPWR VGND sky130_ef_sc_hd__decap_12
XFILLER_2_725 VPWR VGND VPWR VGND sky130_ef_sc_hd__decap_12
XFILLER_2_769 VPWR VGND VPWR VGND sky130_ef_sc_hd__decap_12
XFILLER_131_461 VPWR VGND VPWR VGND sky130_ef_sc_hd__decap_12
XFILLER_49_217 VGND VGND VPWR VPWR sky130_fd_sc_hd__decap_6
XFILLER_1_279 VGND VGND VPWR VPWR sky130_fd_sc_hd__fill_1
XFILLER_77_559 VGND VGND VPWR VPWR sky130_fd_sc_hd__fill_1
XFILLER_66_33 VGND VGND VPWR VPWR sky130_fd_sc_hd__decap_4
XFILLER_66_22 VGND VGND VPWR VPWR sky130_fd_sc_hd__decap_6
XTAP_TAPCELL_ROW_125_2339 VGND VPWR sky130_fd_sc_hd__tapvpwrvgnd_1
XTAP_TAPCELL_ROW_125_2328 VGND VPWR sky130_fd_sc_hd__tapvpwrvgnd_1
XFILLER_100_881 VPWR VGND VPWR VGND sky130_ef_sc_hd__decap_12
XANTENNA__2983__A _0554_ VGND VGND VPWR VPWR sky130_fd_sc_hd__diode_2
XFILLER_57_261 VGND VGND VPWR VPWR sky130_fd_sc_hd__decap_4
XFILLER_17_125 VPWR VGND VPWR VGND sky130_ef_sc_hd__decap_12
XFILLER_18_637 VGND VGND VPWR VPWR sky130_fd_sc_hd__decap_6
XFILLER_122_83 VGND VGND VPWR VPWR sky130_fd_sc_hd__fill_1
XFILLER_73_765 VPWR VGND VPWR VGND sky130_ef_sc_hd__decap_12
XFILLER_61_905 VGND VGND VPWR VPWR sky130_fd_sc_hd__fill_2
XFILLER_17_169 VPWR VGND VPWR VGND sky130_ef_sc_hd__decap_12
XFILLER_82_43 VGND VGND VPWR VPWR sky130_fd_sc_hd__decap_4
XFILLER_26_681 VPWR VGND VPWR VGND sky130_ef_sc_hd__decap_12
XFILLER_33_629 VPWR VGND VPWR VGND sky130_ef_sc_hd__decap_12
XFILLER_32_139 VGND VGND VPWR VPWR sky130_fd_sc_hd__fill_1
XTAP_TAPCELL_ROW_45_1054 VGND VPWR sky130_fd_sc_hd__tapvpwrvgnd_1
XFILLER_15_81 VPWR VGND VPWR VGND sky130_ef_sc_hd__decap_12
XFILLER_41_673 VGND VGND VPWR VPWR sky130_fd_sc_hd__decap_4
XFILLER_139_561 VPWR VGND VPWR VGND sky130_ef_sc_hd__decap_12
XFILLER_9_335 VGND VGND VPWR VPWR sky130_fd_sc_hd__fill_1
XTAP_TAPCELL_ROW_11_510 VGND VPWR sky130_fd_sc_hd__tapvpwrvgnd_1
XFILLER_40_183 VPWR VGND VPWR VGND sky130_ef_sc_hd__decap_12
XTAP_TAPCELL_ROW_153_2782 VGND VPWR sky130_fd_sc_hd__tapvpwrvgnd_1
XFILLER_126_233 VPWR VGND VPWR VGND sky130_ef_sc_hd__decap_12
XFILLER_5_541 VPWR VGND VPWR VGND sky130_ef_sc_hd__decap_12
XTAP_TAPCELL_ROW_153_2793 VGND VPWR sky130_fd_sc_hd__tapvpwrvgnd_1
XFILLER_126_277 VPWR VGND VPWR VGND sky130_ef_sc_hd__decap_12
XFILLER_142_737 VPWR VGND VPWR VGND sky130_ef_sc_hd__decap_12
XFILLER_141_225 VPWR VGND VPWR VGND sky130_ef_sc_hd__decap_12
XFILLER_5_585 VPWR VGND VPWR VGND sky130_ef_sc_hd__decap_12
XFILLER_96_813 VPWR VGND VPWR VGND sky130_ef_sc_hd__decap_12
XFILLER_150_781 VPWR VGND VPWR VGND sky130_ef_sc_hd__decap_12
XFILLER_110_601 VPWR VGND VPWR VGND sky130_ef_sc_hd__decap_12
XFILLER_95_323 VPWR VGND VPWR VGND sky130_ef_sc_hd__decap_12
X_3100_ _0761_ _0787_ VGND VGND VPWR VPWR _0788_ sky130_fd_sc_hd__or2_1
XFILLER_110_645 VPWR VGND VPWR VGND sky130_ef_sc_hd__decap_12
XFILLER_49_740 VGND VGND VPWR VPWR sky130_fd_sc_hd__fill_2
XFILLER_83_529 VPWR VGND VPWR VGND sky130_ef_sc_hd__decap_12
X_3031_ _0693_ _0694_ VGND VGND VPWR VPWR _0719_ sky130_fd_sc_hd__xnor2_1
XFILLER_49_795 VPWR VGND VPWR VGND sky130_ef_sc_hd__decap_12
XFILLER_36_401 VGND VGND VPWR VPWR sky130_fd_sc_hd__decap_6
XFILLER_76_581 VGND VGND VPWR VPWR sky130_fd_sc_hd__decap_6
XTAP_TAPCELL_ROW_19_632 VGND VPWR sky130_fd_sc_hd__tapvpwrvgnd_1
XFILLER_91_573 VPWR VGND VPWR VGND sky130_ef_sc_hd__decap_12
XFILLER_64_787 VPWR VGND VPWR VGND sky130_ef_sc_hd__decap_12
XTAP_TAPCELL_ROW_19_643 VGND VPWR sky130_fd_sc_hd__tapvpwrvgnd_1
XANTENNA__2832__S _0553_ VGND VGND VPWR VPWR sky130_fd_sc_hd__diode_2
XFILLER_20_813 VPWR VGND VPWR VGND sky130_ef_sc_hd__decap_12
XFILLER_31_161 VGND VGND VPWR VPWR sky130_fd_sc_hd__decap_6
X_2815_ _0409_ _0551_ VGND VGND VPWR VPWR _0552_ sky130_fd_sc_hd__or2_1
XFILLER_118_701 VPWR VGND VPWR VGND sky130_ef_sc_hd__decap_12
XFILLER_145_553 VGND VGND VPWR VPWR sky130_fd_sc_hd__decap_6
X_2746_ _0476_ _0485_ VGND VGND VPWR VPWR _0486_ sky130_fd_sc_hd__and2_1
XFILLER_11_39 VPWR VGND VPWR VGND sky130_ef_sc_hd__decap_12
XFILLER_127_39 VPWR VGND VPWR VGND sky130_ef_sc_hd__decap_12
XFILLER_105_417 VPWR VGND VPWR VGND sky130_ef_sc_hd__decap_12
X_2677_ a_r3\[0\] _0186_ _0414_ _0416_ VGND VGND VPWR VPWR _0417_ sky130_fd_sc_hd__o211a_1
XTAP_TAPCELL_ROW_76_1548 VGND VPWR sky130_fd_sc_hd__tapvpwrvgnd_1
XFILLER_145_597 VPWR VGND VPWR VGND sky130_ef_sc_hd__decap_12
X_1628_ B_reg\[2\] VGND VGND VPWR VPWR _0908_ sky130_fd_sc_hd__inv_2
XANTENNA__1781__B1 A_reg\[7\] VGND VGND VPWR VPWR sky130_fd_sc_hd__diode_2
XFILLER_99_673 VPWR VGND VPWR VGND sky130_ef_sc_hd__decap_12
XFILLER_143_27 VPWR VGND VPWR VGND sky130_ef_sc_hd__decap_12
XFILLER_113_461 VPWR VGND VPWR VGND sky130_ef_sc_hd__decap_12
XFILLER_86_323 VPWR VGND VPWR VGND sky130_ef_sc_hd__decap_12
XFILLER_100_133 VGND VGND VPWR VPWR sky130_fd_sc_hd__decap_6
XTAP_TAPCELL_ROW_107_2036 VGND VPWR sky130_fd_sc_hd__tapvpwrvgnd_1
XFILLER_100_177 VPWR VGND VPWR VGND sky130_ef_sc_hd__decap_12
XFILLER_86_389 VPWR VGND VPWR VGND sky130_ef_sc_hd__decap_12
X_3229_ clknet_3_1__leaf_clk _0016_ net36 VGND VGND VPWR VPWR b_r1\[2\] sky130_fd_sc_hd__dfrtp_4
XANTENNA__3314__RESET_B net36 VGND VGND VPWR VPWR sky130_fd_sc_hd__diode_2
XFILLER_46_209 VGND VGND VPWR VPWR sky130_fd_sc_hd__decap_4
XTAP_TAPCELL_ROW_107_2047 VGND VPWR sky130_fd_sc_hd__tapvpwrvgnd_1
XFILLER_27_412 VPWR VGND VPWR VGND sky130_ef_sc_hd__decap_12
XTAP_TAPCELL_ROW_38_941 VGND VPWR sky130_fd_sc_hd__tapvpwrvgnd_1
XFILLER_82_551 VPWR VGND VPWR VGND sky130_ef_sc_hd__decap_12
XFILLER_70_713 VPWR VGND VPWR VGND sky130_ef_sc_hd__decap_12
XANTENNA__1836__B2 Encode_EN VGND VGND VPWR VPWR sky130_fd_sc_hd__diode_2
XTAP_TAPCELL_ROW_120_2247 VGND VPWR sky130_fd_sc_hd__tapvpwrvgnd_1
XFILLER_54_286 VPWR VGND VPWR VGND sky130_ef_sc_hd__decap_12
XFILLER_54_264 VPWR VGND VPWR VGND sky130_ef_sc_hd__decap_12
XFILLER_15_629 VPWR VGND VPWR VGND sky130_ef_sc_hd__decap_12
XTAP_TAPCELL_ROW_120_2258 VGND VPWR sky130_fd_sc_hd__tapvpwrvgnd_1
XFILLER_70_768 VPWR VGND VPWR VGND sky130_ef_sc_hd__decap_12
XFILLER_70_757 VGND VGND VPWR VPWR sky130_fd_sc_hd__decap_6
XFILLER_14_139 VGND VGND VPWR VPWR sky130_fd_sc_hd__fill_1
XFILLER_10_301 VGND VGND VPWR VPWR sky130_fd_sc_hd__decap_6
XFILLER_23_673 VPWR VGND VPWR VGND sky130_ef_sc_hd__decap_12
XFILLER_7_839 VGND VGND VPWR VPWR sky130_fd_sc_hd__fill_1
XFILLER_136_531 VGND VGND VPWR VPWR sky130_fd_sc_hd__fill_1
XFILLER_108_233 VPWR VGND VPWR VGND sky130_ef_sc_hd__decap_12
XFILLER_10_389 VGND VGND VPWR VPWR sky130_fd_sc_hd__decap_3
XTAP_TAPCELL_ROW_135_2490 VGND VPWR sky130_fd_sc_hd__tapvpwrvgnd_1
XFILLER_108_277 VPWR VGND VPWR VGND sky130_ef_sc_hd__decap_12
XFILLER_124_737 VPWR VGND VPWR VGND sky130_ef_sc_hd__decap_12
XFILLER_123_225 VPWR VGND VPWR VGND sky130_ef_sc_hd__decap_12
XANTENNA__2697__B b_r3\[3\] VGND VGND VPWR VPWR sky130_fd_sc_hd__diode_2
XFILLER_96_109 VPWR VGND VPWR VGND sky130_ef_sc_hd__decap_12
XFILLER_78_813 VPWR VGND VPWR VGND sky130_ef_sc_hd__decap_12
XFILLER_132_781 VPWR VGND VPWR VGND sky130_ef_sc_hd__decap_12
XFILLER_89_150 VPWR VGND VPWR VGND sky130_ef_sc_hd__decap_12
XFILLER_77_323 VPWR VGND VPWR VGND sky130_ef_sc_hd__decap_12
XFILLER_133_93 VPWR VGND VPWR VGND sky130_ef_sc_hd__decap_12
XFILLER_73_573 VPWR VGND VPWR VGND sky130_ef_sc_hd__decap_12
XFILLER_18_489 VPWR VGND VPWR VGND sky130_ef_sc_hd__decap_12
XANTENNA__2218__A A_reg\[6\] VGND VGND VPWR VPWR sky130_fd_sc_hd__diode_2
XFILLER_60_245 VGND VGND VPWR VPWR sky130_fd_sc_hd__decap_6
XFILLER_20_109 VPWR VGND VPWR VGND sky130_ef_sc_hd__decap_12
XFILLER_13_161 VGND VGND VPWR VPWR sky130_fd_sc_hd__decap_6
XFILLER_139_391 VGND VGND VPWR VPWR sky130_fd_sc_hd__fill_1
X_2600_ OpSel_reg\[0\] _0338_ _0344_ _0188_ VGND VGND VPWR VPWR _0345_ sky130_fd_sc_hd__o2bb2a_1
XFILLER_142_501 VPWR VGND VPWR VGND sky130_ef_sc_hd__decap_12
XFILLER_127_553 VGND VGND VPWR VPWR sky130_fd_sc_hd__decap_6
XFILLER_6_861 VGND VGND VPWR VPWR sky130_fd_sc_hd__decap_6
X_2531_ _0275_ _0276_ VGND VGND VPWR VPWR _0279_ sky130_fd_sc_hd__and2_1
XFILLER_142_545 VPWR VGND VPWR VGND sky130_ef_sc_hd__decap_12
XFILLER_127_597 VPWR VGND VPWR VGND sky130_ef_sc_hd__decap_12
XTAP_TAPCELL_ROW_58_1267 VGND VPWR sky130_fd_sc_hd__tapvpwrvgnd_1
XTAP_TAPCELL_ROW_58_1256 VGND VPWR sky130_fd_sc_hd__tapvpwrvgnd_1
XFILLER_5_371 VGND VGND VPWR VPWR sky130_fd_sc_hd__fill_1
X_2462_ _0192_ _0211_ _0184_ VGND VGND VPWR VPWR _0212_ sky130_fd_sc_hd__o21ai_1
XFILLER_5_393 VGND VGND VPWR VPWR sky130_fd_sc_hd__decap_6
XPHY_EDGE_ROW_39_Left_193 VGND VGND VPWR VPWR sky130_fd_sc_hd__decap_3
XFILLER_47_3 VPWR VGND VPWR VGND sky130_ef_sc_hd__decap_12
XFILLER_142_589 VPWR VGND VPWR VGND sky130_ef_sc_hd__decap_12
X_2393_ _0138_ _0143_ VGND VGND VPWR VPWR _0147_ sky130_fd_sc_hd__xnor2_1
XFILLER_96_643 VGND VGND VPWR VPWR sky130_fd_sc_hd__fill_1
XFILLER_84_805 VGND VGND VPWR VPWR sky130_fd_sc_hd__decap_6
XTAP_TAPCELL_ROW_71_1467 VGND VPWR sky130_fd_sc_hd__tapvpwrvgnd_1
XFILLER_3_51 VGND VGND VPWR VPWR sky130_fd_sc_hd__decap_4
XFILLER_110_475 VGND VGND VPWR VPWR sky130_fd_sc_hd__fill_1
XFILLER_110_453 VGND VGND VPWR VPWR sky130_fd_sc_hd__decap_3
XFILLER_68_389 VPWR VGND VPWR VGND sky130_ef_sc_hd__decap_12
XFILLER_56_529 VGND VGND VPWR VPWR sky130_fd_sc_hd__decap_3
XFILLER_28_209 VGND VGND VPWR VPWR sky130_fd_sc_hd__decap_4
XANTENNA__2827__S _0553_ VGND VGND VPWR VPWR sky130_fd_sc_hd__diode_2
XFILLER_95_197 VPWR VGND VPWR VGND sky130_ef_sc_hd__decap_12
XFILLER_84_849 VPWR VGND VPWR VGND sky130_ef_sc_hd__decap_12
X_3014_ _0699_ _0701_ VGND VGND VPWR VPWR _0702_ sky130_fd_sc_hd__nor2_1
XFILLER_37_721 VGND VGND VPWR VPWR sky130_fd_sc_hd__decap_6
XFILLER_64_540 VPWR VGND VPWR VGND sky130_ef_sc_hd__decap_12
XFILLER_36_242 VGND VGND VPWR VPWR sky130_fd_sc_hd__decap_8
XFILLER_36_253 VPWR VGND VPWR VGND sky130_ef_sc_hd__decap_12
XFILLER_37_765 VPWR VGND VPWR VGND sky130_ef_sc_hd__decap_12
XFILLER_92_893 VPWR VGND VPWR VGND sky130_ef_sc_hd__decap_12
XFILLER_52_713 VPWR VGND VPWR VGND sky130_ef_sc_hd__decap_12
XFILLER_149_111 VGND VGND VPWR VPWR sky130_fd_sc_hd__fill_1
XFILLER_51_256 VPWR VGND VPWR VGND sky130_ef_sc_hd__decap_12
XFILLER_20_643 VGND VGND VPWR VPWR sky130_fd_sc_hd__fill_1
XFILLER_137_317 VPWR VGND VPWR VGND sky130_ef_sc_hd__decap_12
XFILLER_22_27 VGND VGND VPWR VPWR sky130_fd_sc_hd__fill_1
XFILLER_138_27 VGND VGND VPWR VPWR sky130_fd_sc_hd__fill_1
XFILLER_118_531 VGND VGND VPWR VPWR sky130_fd_sc_hd__fill_1
XFILLER_152_309 VPWR VGND VPWR VGND sky130_ef_sc_hd__decap_12
XFILLER_145_361 VPWR VGND VPWR VGND sky130_ef_sc_hd__decap_12
X_2729_ _0423_ _0453_ VGND VGND VPWR VPWR _0469_ sky130_fd_sc_hd__nor2_2
XFILLER_106_737 VPWR VGND VPWR VGND sky130_ef_sc_hd__decap_12
XFILLER_105_225 VPWR VGND VPWR VGND sky130_ef_sc_hd__decap_12
XFILLER_121_729 VPWR VGND VPWR VGND sky130_ef_sc_hd__decap_12
XFILLER_114_781 VPWR VGND VPWR VGND sky130_ef_sc_hd__decap_12
XFILLER_59_312 VPWR VGND VPWR VGND sky130_ef_sc_hd__decap_12
XFILLER_86_153 VPWR VGND VPWR VGND sky130_ef_sc_hd__decap_12
XFILLER_47_518 VPWR VGND VPWR VGND sky130_ef_sc_hd__decap_12
XFILLER_86_197 VPWR VGND VPWR VGND sky130_ef_sc_hd__decap_12
XPHY_EDGE_ROW_29_Right_29 VGND VGND VPWR VPWR sky130_fd_sc_hd__decap_3
XFILLER_47_57 VPWR VGND VPWR VGND sky130_ef_sc_hd__decap_12
XTAP_TAPCELL_ROW_2_363 VGND VPWR sky130_fd_sc_hd__tapvpwrvgnd_1
XFILLER_16_905 VGND VGND VPWR VPWR sky130_fd_sc_hd__decap_4
XANTENNA__1809__A1 A_reg\[4\] VGND VGND VPWR VPWR sky130_fd_sc_hd__diode_2
XFILLER_82_370 VPWR VGND VPWR VGND sky130_ef_sc_hd__decap_12
XFILLER_151_3 VPWR VGND VPWR VGND sky130_ef_sc_hd__decap_12
XFILLER_42_245 VGND VGND VPWR VPWR sky130_fd_sc_hd__decap_6
XFILLER_70_587 VGND VGND VPWR VPWR sky130_fd_sc_hd__fill_1
XFILLER_30_418 VGND VGND VPWR VPWR sky130_fd_sc_hd__fill_2
XANTENNA__2234__A1 A_reg\[4\] VGND VGND VPWR VPWR sky130_fd_sc_hd__diode_2
XTAP_TAPCELL_ROW_42_1002 VGND VPWR sky130_fd_sc_hd__tapvpwrvgnd_1
XTAP_TAPCELL_ROW_100_1939 VGND VPWR sky130_fd_sc_hd__tapvpwrvgnd_1
XTAP_TAPCELL_ROW_100_1928 VGND VPWR sky130_fd_sc_hd__tapvpwrvgnd_1
XFILLER_51_790 VPWR VGND VPWR VGND sky130_ef_sc_hd__decap_12
XFILLER_8_29 VPWR VGND VPWR VGND sky130_ef_sc_hd__decap_12
XTAP_TAPCELL_ROW_137_2530 VGND VPWR sky130_fd_sc_hd__tapvpwrvgnd_1
XFILLER_11_665 VGND VGND VPWR VPWR sky130_fd_sc_hd__decap_6
XPHY_EDGE_ROW_38_Right_38 VGND VGND VPWR VPWR sky130_fd_sc_hd__decap_3
XFILLER_10_153 VPWR VGND VPWR VGND sky130_ef_sc_hd__decap_12
XTAP_TAPCELL_ROW_21_660 VGND VPWR sky130_fd_sc_hd__tapvpwrvgnd_1
XTAP_TAPCELL_ROW_21_671 VGND VPWR sky130_fd_sc_hd__tapvpwrvgnd_1
XTAP_TAPCELL_ROW_150_2730 VGND VPWR sky130_fd_sc_hd__tapvpwrvgnd_1
XFILLER_124_501 VPWR VGND VPWR VGND sky130_ef_sc_hd__decap_12
XFILLER_10_197 VPWR VGND VPWR VGND sky130_ef_sc_hd__decap_12
XFILLER_137_895 VGND VGND VPWR VPWR sky130_fd_sc_hd__fill_1
XFILLER_109_597 VPWR VGND VPWR VGND sky130_ef_sc_hd__decap_12
XFILLER_124_545 VPWR VGND VPWR VGND sky130_ef_sc_hd__decap_12
XFILLER_88_53 VGND VGND VPWR VPWR sky130_fd_sc_hd__decap_6
XFILLER_3_853 VPWR VGND VPWR VGND sky130_ef_sc_hd__decap_12
XFILLER_124_589 VPWR VGND VPWR VGND sky130_ef_sc_hd__decap_12
XFILLER_111_217 VGND VGND VPWR VPWR sky130_fd_sc_hd__decap_6
XFILLER_97_418 VGND VGND VPWR VPWR sky130_fd_sc_hd__decap_6
XANTENNA__3236__RESET_B net36 VGND VGND VPWR VPWR sky130_fd_sc_hd__diode_2
XFILLER_88_97 VPWR VGND VPWR VGND sky130_ef_sc_hd__decap_12
XFILLER_78_610 VPWR VGND VPWR VGND sky130_ef_sc_hd__decap_12
XFILLER_3_897 VPWR VGND VPWR VGND sky130_ef_sc_hd__decap_12
XTAP_TAPCELL_ROW_148_2692 VGND VPWR sky130_fd_sc_hd__tapvpwrvgnd_1
XFILLER_77_142 VPWR VGND VPWR VGND sky130_ef_sc_hd__decap_12
XTAP_TAPCELL_ROW_53_1186 VGND VPWR sky130_fd_sc_hd__tapvpwrvgnd_1
XTAP_TAPCELL_ROW_53_1175 VGND VPWR sky130_fd_sc_hd__tapvpwrvgnd_1
XPHY_EDGE_ROW_47_Right_47 VGND VGND VPWR VPWR sky130_fd_sc_hd__decap_3
XFILLER_93_657 VPWR VGND VPWR VGND sky130_ef_sc_hd__decap_12
XFILLER_66_849 VPWR VGND VPWR VGND sky130_ef_sc_hd__decap_12
XFILLER_65_337 VGND VGND VPWR VPWR sky130_fd_sc_hd__decap_6
XFILLER_19_721 VGND VGND VPWR VPWR sky130_fd_sc_hd__decap_6
XFILLER_80_307 VGND VGND VPWR VPWR sky130_fd_sc_hd__fill_1
XFILLER_19_765 VPWR VGND VPWR VGND sky130_ef_sc_hd__decap_12
XFILLER_74_893 VPWR VGND VPWR VGND sky130_ef_sc_hd__decap_12
XFILLER_73_370 VGND VGND VPWR VPWR sky130_fd_sc_hd__fill_1
XFILLER_18_253 VPWR VGND VPWR VGND sky130_ef_sc_hd__decap_12
XFILLER_34_713 VPWR VGND VPWR VGND sky130_ef_sc_hd__decap_12
XTAP_TAPCELL_ROW_29_793 VGND VPWR sky130_fd_sc_hd__tapvpwrvgnd_1
XFILLER_33_223 VGND VGND VPWR VPWR sky130_fd_sc_hd__fill_1
XFILLER_34_757 VPWR VGND VPWR VGND sky130_ef_sc_hd__decap_12
XFILLER_33_278 VGND VGND VPWR VPWR sky130_fd_sc_hd__fill_2
X_1962_ _1215_ _1226_ VGND VGND VPWR VPWR _1227_ sky130_fd_sc_hd__xnor2_1
XPHY_EDGE_ROW_56_Right_56 VGND VGND VPWR VPWR sky130_fd_sc_hd__decap_3
XFILLER_147_615 VGND VGND VPWR VPWR sky130_fd_sc_hd__fill_1
XFILLER_119_317 VPWR VGND VPWR VGND sky130_ef_sc_hd__decap_12
X_1893_ Encode_Done_A _0911_ VGND VGND VPWR VPWR _1161_ sky130_fd_sc_hd__nor2_1
XFILLER_134_309 VPWR VGND VPWR VGND sky130_ef_sc_hd__decap_12
XFILLER_143_821 VPWR VGND VPWR VGND sky130_ef_sc_hd__decap_12
XFILLER_127_361 VPWR VGND VPWR VGND sky130_ef_sc_hd__decap_12
XTAP_TAPCELL_ROW_73_1507 VGND VPWR sky130_fd_sc_hd__tapvpwrvgnd_1
XPHY_EDGE_ROW_47_Left_201 VGND VGND VPWR VPWR sky130_fd_sc_hd__decap_3
XFILLER_143_865 VPWR VGND VPWR VGND sky130_ef_sc_hd__decap_12
X_2514_ _0259_ _0260_ _0261_ VGND VGND VPWR VPWR _0262_ sky130_fd_sc_hd__and3_1
XFILLER_103_729 VPWR VGND VPWR VGND sky130_ef_sc_hd__decap_12
X_2445_ _0193_ _0194_ b_r0\[1\] VGND VGND VPWR VPWR _0195_ sky130_fd_sc_hd__a21oi_1
XPHY_EDGE_ROW_65_Right_65 VGND VGND VPWR VPWR sky130_fd_sc_hd__decap_3
XFILLER_124_29 VPWR VGND VPWR VGND sky130_ef_sc_hd__decap_12
X_2376_ _0120_ _0122_ _0118_ VGND VGND VPWR VPWR _0130_ sky130_fd_sc_hd__a21bo_1
XFILLER_68_153 VPWR VGND VPWR VGND sky130_ef_sc_hd__decap_12
XFILLER_84_635 VGND VGND VPWR VPWR sky130_fd_sc_hd__decap_8
XFILLER_83_101 VGND VGND VPWR VPWR sky130_fd_sc_hd__decap_8
XFILLER_29_529 VGND VGND VPWR VPWR sky130_fd_sc_hd__decap_4
XFILLER_84_657 VPWR VGND VPWR VGND sky130_ef_sc_hd__decap_12
XPHY_EDGE_ROW_56_Left_210 VGND VGND VPWR VPWR sky130_fd_sc_hd__decap_3
XFILLER_17_27 VPWR VGND VPWR VGND sky130_ef_sc_hd__decap_12
XFILLER_83_167 VGND VGND VPWR VPWR sky130_fd_sc_hd__fill_1
XFILLER_71_329 VGND VGND VPWR VPWR sky130_fd_sc_hd__decap_6
XTAP_TAPCELL_ROW_84_1669 VGND VPWR sky130_fd_sc_hd__tapvpwrvgnd_1
XANTENNA__2292__S Encode_EN VGND VGND VPWR VPWR sky130_fd_sc_hd__diode_2
XPHY_EDGE_ROW_74_Right_74 VGND VGND VPWR VPWR sky130_fd_sc_hd__decap_3
XFILLER_33_15 VPWR VGND VPWR VGND sky130_ef_sc_hd__decap_12
XFILLER_149_15 VPWR VGND VPWR VGND sky130_ef_sc_hd__decap_12
XFILLER_24_289 VPWR VGND VPWR VGND sky130_ef_sc_hd__decap_12
XFILLER_138_637 VGND VGND VPWR VPWR sky130_fd_sc_hd__decap_6
XFILLER_137_125 VPWR VGND VPWR VGND sky130_ef_sc_hd__decap_12
XFILLER_153_629 VPWR VGND VPWR VGND sky130_ef_sc_hd__decap_12
XFILLER_137_169 VPWR VGND VPWR VGND sky130_ef_sc_hd__decap_12
XFILLER_152_139 VGND VGND VPWR VPWR sky130_fd_sc_hd__fill_1
XFILLER_146_681 VPWR VGND VPWR VGND sky130_ef_sc_hd__decap_12
XFILLER_119_895 VGND VGND VPWR VPWR sky130_fd_sc_hd__fill_1
XTAP_TAPCELL_ROW_115_2179 VGND VPWR sky130_fd_sc_hd__tapvpwrvgnd_1
XTAP_TAPCELL_ROW_115_2168 VGND VPWR sky130_fd_sc_hd__tapvpwrvgnd_1
XFILLER_106_501 VPWR VGND VPWR VGND sky130_ef_sc_hd__decap_12
XFILLER_3_105 VGND VGND VPWR VPWR sky130_fd_sc_hd__decap_6
XPHY_EDGE_ROW_83_Right_83 VGND VGND VPWR VPWR sky130_fd_sc_hd__decap_3
XFILLER_3_149 VPWR VGND VPWR VGND sky130_ef_sc_hd__decap_12
XFILLER_106_589 VPWR VGND VPWR VGND sky130_ef_sc_hd__decap_12
XANTENNA__3233__CLK clknet_3_3__leaf_clk VGND VGND VPWR VPWR sky130_fd_sc_hd__diode_2
XFILLER_121_559 VGND VGND VPWR VPWR sky130_fd_sc_hd__fill_1
XTAP_TAPCELL_ROW_7_444 VGND VPWR sky130_fd_sc_hd__tapvpwrvgnd_1
XFILLER_87_473 VPWR VGND VPWR VGND sky130_ef_sc_hd__decap_12
XFILLER_101_261 VPWR VGND VPWR VGND sky130_ef_sc_hd__decap_12
XFILLER_59_175 VGND VGND VPWR VPWR sky130_fd_sc_hd__fill_1
XFILLER_47_337 VGND VGND VPWR VPWR sky130_fd_sc_hd__decap_4
XFILLER_90_627 VPWR VGND VPWR VGND sky130_ef_sc_hd__decap_12
XFILLER_62_307 VGND VGND VPWR VPWR sky130_fd_sc_hd__fill_1
XFILLER_56_893 VPWR VGND VPWR VGND sky130_ef_sc_hd__decap_12
XFILLER_16_713 VPWR VGND VPWR VGND sky130_ef_sc_hd__decap_12
XPHY_EDGE_ROW_92_Right_92 VGND VGND VPWR VPWR sky130_fd_sc_hd__decap_3
XFILLER_71_841 VPWR VGND VPWR VGND sky130_ef_sc_hd__decap_12
XFILLER_15_223 VGND VGND VPWR VPWR sky130_fd_sc_hd__fill_1
XFILLER_16_757 VPWR VGND VPWR VGND sky130_ef_sc_hd__decap_12
XTAP_TAPCELL_ROW_26_741 VGND VPWR sky130_fd_sc_hd__tapvpwrvgnd_1
XPHY_EDGE_ROW_133_Right_133 VGND VGND VPWR VPWR sky130_fd_sc_hd__decap_3
XFILLER_90_10 VGND VGND VPWR VPWR sky130_fd_sc_hd__decap_8
XFILLER_15_245 VGND VGND VPWR VPWR sky130_fd_sc_hd__fill_2
XTAP_TAPCELL_ROW_26_752 VGND VPWR sky130_fd_sc_hd__tapvpwrvgnd_1
XFILLER_31_727 VGND VGND VPWR VPWR sky130_fd_sc_hd__fill_1
XFILLER_130_83 VGND VGND VPWR VPWR sky130_fd_sc_hd__fill_1
XFILLER_129_615 VGND VGND VPWR VPWR sky130_fd_sc_hd__fill_1
XFILLER_90_98 VGND VGND VPWR VPWR sky130_fd_sc_hd__fill_2
XFILLER_23_81 VPWR VGND VPWR VGND sky130_ef_sc_hd__decap_12
XFILLER_139_81 VPWR VGND VPWR VGND sky130_ef_sc_hd__decap_12
XFILLER_116_309 VPWR VGND VPWR VGND sky130_ef_sc_hd__decap_12
XFILLER_7_466 VPWR VGND VPWR VGND sky130_ef_sc_hd__decap_12
XFILLER_125_821 VPWR VGND VPWR VGND sky130_ef_sc_hd__decap_12
XFILLER_109_361 VPWR VGND VPWR VGND sky130_ef_sc_hd__decap_12
XFILLER_125_865 VPWR VGND VPWR VGND sky130_ef_sc_hd__decap_12
XTAP_TAPCELL_ROW_55_1215 VGND VPWR sky130_fd_sc_hd__tapvpwrvgnd_1
XTAP_TAPCELL_ROW_55_1204 VGND VPWR sky130_fd_sc_hd__tapvpwrvgnd_1
XFILLER_151_161 VGND VGND VPWR VPWR sky130_fd_sc_hd__decap_6
XFILLER_140_813 VPWR VGND VPWR VGND sky130_ef_sc_hd__decap_12
XFILLER_98_749 VGND VGND VPWR VPWR sky130_fd_sc_hd__decap_6
XFILLER_97_204 VPWR VGND VPWR VGND sky130_ef_sc_hd__decap_12
XANTENNA__2930__A2 _0604_ VGND VGND VPWR VPWR sky130_fd_sc_hd__diode_2
XFILLER_97_237 VPWR VGND VPWR VGND sky130_ef_sc_hd__decap_12
X_2230_ _0894_ _1486_ VGND VGND VPWR VPWR _1487_ sky130_fd_sc_hd__xnor2_1
XFILLER_66_613 VPWR VGND VPWR VGND sky130_ef_sc_hd__decap_12
XFILLER_120_581 VGND VGND VPWR VPWR sky130_fd_sc_hd__decap_6
X_2161_ A_reg\[11\] _1415_ _1410_ VGND VGND VPWR VPWR _1418_ sky130_fd_sc_hd__a21oi_1
XFILLER_66_657 VPWR VGND VPWR VGND sky130_ef_sc_hd__decap_12
XFILLER_65_156 VPWR VGND VPWR VGND sky130_ef_sc_hd__decap_12
X_2092_ b_r1\[1\] _1352_ Encode_EN VGND VGND VPWR VPWR _0015_ sky130_fd_sc_hd__mux2_1
XFILLER_65_189 VGND VGND VPWR VPWR sky130_fd_sc_hd__fill_2
XFILLER_53_329 VGND VGND VPWR VPWR sky130_fd_sc_hd__decap_6
XFILLER_0_41 VPWR VGND VPWR VGND sky130_ef_sc_hd__decap_12
XFILLER_19_573 VPWR VGND VPWR VGND sky130_ef_sc_hd__decap_12
XFILLER_0_85 VPWR VGND VPWR VGND sky130_ef_sc_hd__decap_12
XTAP_TAPCELL_ROW_66_1388 VGND VPWR sky130_fd_sc_hd__tapvpwrvgnd_1
XPHY_EDGE_ROW_100_Right_100 VGND VGND VPWR VPWR sky130_fd_sc_hd__decap_3
X_2994_ _0580_ _0607_ VGND VGND VPWR VPWR _0682_ sky130_fd_sc_hd__xor2_1
XFILLER_61_373 VPWR VGND VPWR VGND sky130_ef_sc_hd__decap_12
XFILLER_22_749 VGND VGND VPWR VPWR sky130_fd_sc_hd__decap_6
XFILLER_34_587 VGND VGND VPWR VPWR sky130_fd_sc_hd__fill_1
X_1945_ B_reg\[7\] _1204_ _1205_ _1203_ B_reg\[8\] VGND VGND VPWR VPWR _1210_ sky130_fd_sc_hd__a32o_1
XFILLER_119_125 VPWR VGND VPWR VGND sky130_ef_sc_hd__decap_12
XFILLER_30_793 VPWR VGND VPWR VGND sky130_ef_sc_hd__decap_12
XANTENNA__2840__S _0383_ VGND VGND VPWR VPWR sky130_fd_sc_hd__diode_2
XFILLER_119_169 VPWR VGND VPWR VGND sky130_ef_sc_hd__decap_12
X_1876_ _1143_ _1140_ A_reg\[4\] VGND VGND VPWR VPWR _1146_ sky130_fd_sc_hd__mux2_1
XFILLER_135_629 VPWR VGND VPWR VGND sky130_ef_sc_hd__decap_12
XFILLER_128_681 VPWR VGND VPWR VGND sky130_ef_sc_hd__decap_12
XANTENNA__3256__CLK clknet_3_6__leaf_clk VGND VGND VPWR VPWR sky130_fd_sc_hd__diode_2
XFILLER_134_139 VGND VGND VPWR VPWR sky130_fd_sc_hd__fill_1
XANTENNA__2141__A B_reg\[1\] VGND VGND VPWR VPWR sky130_fd_sc_hd__diode_2
XFILLER_143_673 VPWR VGND VPWR VGND sky130_ef_sc_hd__decap_12
XFILLER_130_301 VGND VGND VPWR VPWR sky130_fd_sc_hd__decap_6
XFILLER_89_727 VGND VGND VPWR VPWR sky130_fd_sc_hd__fill_1
XFILLER_1_609 VGND VGND VPWR VPWR sky130_fd_sc_hd__decap_6
XFILLER_135_39 VPWR VGND VPWR VGND sky130_ef_sc_hd__decap_12
XFILLER_130_345 VPWR VGND VPWR VGND sky130_ef_sc_hd__decap_12
XFILLER_103_559 VGND VGND VPWR VPWR sky130_fd_sc_hd__fill_1
XTAP_TAPCELL_ROW_110_2098 VGND VPWR sky130_fd_sc_hd__tapvpwrvgnd_1
XTAP_TAPCELL_ROW_110_2087 VGND VPWR sky130_fd_sc_hd__tapvpwrvgnd_1
X_2428_ _0174_ _0175_ _0169_ VGND VGND VPWR VPWR _0180_ sky130_fd_sc_hd__a21bo_1
XTAP_TAPCELL_ROW_4_403 VGND VPWR sky130_fd_sc_hd__tapvpwrvgnd_1
XFILLER_130_389 VPWR VGND VPWR VGND sky130_ef_sc_hd__decap_12
X_2359_ _1602_ _0112_ VGND VGND VPWR VPWR _0113_ sky130_fd_sc_hd__xnor2_1
XFILLER_84_421 VPWR VGND VPWR VGND sky130_ef_sc_hd__decap_12
XFILLER_69_473 VPWR VGND VPWR VGND sky130_ef_sc_hd__decap_12
XFILLER_28_15 VPWR VGND VPWR VGND sky130_ef_sc_hd__decap_12
XFILLER_29_337 VPWR VGND VPWR VGND sky130_ef_sc_hd__decap_12
XFILLER_151_27 VPWR VGND VPWR VGND sky130_ef_sc_hd__decap_12
XTAP_TAPCELL_ROW_86_1709 VGND VPWR sky130_fd_sc_hd__tapvpwrvgnd_1
XFILLER_56_189 VGND VGND VPWR VPWR sky130_fd_sc_hd__decap_6
XFILLER_38_871 VGND VGND VPWR VPWR sky130_fd_sc_hd__decap_8
XFILLER_44_307 VGND VGND VPWR VPWR sky130_fd_sc_hd__fill_1
XFILLER_65_690 VPWR VGND VPWR VGND sky130_ef_sc_hd__decap_12
XFILLER_53_841 VPWR VGND VPWR VGND sky130_ef_sc_hd__decap_12
XFILLER_52_362 VGND VGND VPWR VPWR sky130_fd_sc_hd__fill_2
XFILLER_52_340 VGND VGND VPWR VPWR sky130_fd_sc_hd__decap_3
XFILLER_40_502 VPWR VGND VPWR VGND sky130_ef_sc_hd__decap_12
XFILLER_80_693 VGND VGND VPWR VPWR sky130_fd_sc_hd__decap_6
XFILLER_9_709 VPWR VGND VPWR VGND sky130_ef_sc_hd__decap_12
XFILLER_13_727 VGND VGND VPWR VPWR sky130_fd_sc_hd__fill_1
XTAP_TAPCELL_ROW_23_700 VGND VPWR sky130_fd_sc_hd__tapvpwrvgnd_1
XFILLER_138_401 VPWR VGND VPWR VGND sky130_ef_sc_hd__decap_12
XFILLER_100_53 VPWR VGND VPWR VGND sky130_ef_sc_hd__decap_12
XFILLER_40_557 VPWR VGND VPWR VGND sky130_ef_sc_hd__decap_12
XFILLER_138_445 VPWR VGND VPWR VGND sky130_ef_sc_hd__decap_12
XTAP_TAPCELL_ROW_117_2208 VGND VPWR sky130_fd_sc_hd__tapvpwrvgnd_1
XFILLER_100_97 VPWR VGND VPWR VGND sky130_ef_sc_hd__decap_12
XFILLER_138_489 VPWR VGND VPWR VGND sky130_ef_sc_hd__decap_12
XTAP_TAPCELL_ROW_130_2408 VGND VPWR sky130_fd_sc_hd__tapvpwrvgnd_1
XFILLER_114_3 VPWR VGND VPWR VGND sky130_ef_sc_hd__decap_12
XFILLER_107_821 VPWR VGND VPWR VGND sky130_ef_sc_hd__decap_12
XTAP_TAPCELL_ROW_130_2419 VGND VPWR sky130_fd_sc_hd__tapvpwrvgnd_1
XFILLER_109_51 VGND VGND VPWR VPWR sky130_fd_sc_hd__decap_4
XFILLER_107_865 VPWR VGND VPWR VGND sky130_ef_sc_hd__decap_12
XFILLER_69_22 VPWR VGND VPWR VGND sky130_ef_sc_hd__decap_12
XFILLER_140_109 VPWR VGND VPWR VGND sky130_ef_sc_hd__decap_12
XFILLER_133_161 VGND VGND VPWR VPWR sky130_fd_sc_hd__decap_6
XFILLER_122_813 VPWR VGND VPWR VGND sky130_ef_sc_hd__decap_12
XFILLER_4_469 VGND VGND VPWR VPWR sky130_fd_sc_hd__decap_6
XFILLER_106_386 VPWR VGND VPWR VGND sky130_ef_sc_hd__decap_12
XANTENNA_input34_A Op_Sel[1] VGND VGND VPWR VPWR sky130_fd_sc_hd__diode_2
XFILLER_88_793 VPWR VGND VPWR VGND sky130_ef_sc_hd__decap_12
XFILLER_87_281 VPWR VGND VPWR VGND sky130_ef_sc_hd__decap_12
XFILLER_85_43 VPWR VGND VPWR VGND sky130_ef_sc_hd__decap_12
XTAP_TAPCELL_ROW_50_1134 VGND VPWR sky130_fd_sc_hd__tapvpwrvgnd_1
XFILLER_0_697 VGND VGND VPWR VPWR sky130_fd_sc_hd__decap_3
XTAP_TAPCELL_ROW_145_2651 VGND VPWR sky130_fd_sc_hd__tapvpwrvgnd_1
XFILLER_48_657 VGND VGND VPWR VPWR sky130_fd_sc_hd__decap_6
XFILLER_47_167 VGND VGND VPWR VPWR sky130_fd_sc_hd__fill_1
XFILLER_90_457 VGND VGND VPWR VPWR sky130_fd_sc_hd__fill_1
XFILLER_141_93 VPWR VGND VPWR VGND sky130_ef_sc_hd__decap_12
XTAP_TAPCELL_ROW_48_1096 VGND VPWR sky130_fd_sc_hd__tapvpwrvgnd_1
XFILLER_16_587 VGND VGND VPWR VPWR sky130_fd_sc_hd__fill_1
XFILLER_148_209 VPWR VGND VPWR VGND sky130_ef_sc_hd__decap_12
XANTENNA__3279__CLK clknet_3_0__leaf_clk VGND VGND VPWR VPWR sky130_fd_sc_hd__diode_2
XANTENNA__2600__B2 _0188_ VGND VGND VPWR VPWR sky130_fd_sc_hd__diode_2
X_1730_ a_r2\[1\] _0911_ _1003_ _1004_ VGND VGND VPWR VPWR _0001_ sky130_fd_sc_hd__a22o_1
XFILLER_12_793 VPWR VGND VPWR VGND sky130_ef_sc_hd__decap_12
XFILLER_117_629 VPWR VGND VPWR VGND sky130_ef_sc_hd__decap_12
X_1661_ _0932_ _0935_ _0936_ _0889_ VGND VGND VPWR VPWR _0937_ sky130_fd_sc_hd__a31oi_2
XANTENNA__3251__RESET_B net36 VGND VGND VPWR VPWR sky130_fd_sc_hd__diode_2
XFILLER_116_139 VGND VGND VPWR VPWR sky130_fd_sc_hd__fill_1
XFILLER_125_673 VPWR VGND VPWR VGND sky130_ef_sc_hd__decap_12
XFILLER_112_301 VGND VGND VPWR VPWR sky130_fd_sc_hd__decap_6
XFILLER_98_513 VPWR VGND VPWR VGND sky130_ef_sc_hd__decap_12
XFILLER_140_643 VGND VGND VPWR VPWR sky130_fd_sc_hd__fill_1
XFILLER_112_345 VPWR VGND VPWR VGND sky130_ef_sc_hd__decap_12
XFILLER_100_507 VPWR VGND VPWR VGND sky130_ef_sc_hd__decap_12
XFILLER_98_568 VGND VGND VPWR VPWR sky130_fd_sc_hd__decap_4
XANTENNA__2116__B1 B_reg\[8\] VGND VGND VPWR VPWR sky130_fd_sc_hd__diode_2
X_3262_ clknet_3_7__leaf_clk _0045_ net36 VGND VGND VPWR VPWR net48 sky130_fd_sc_hd__dfrtp_1
XFILLER_112_389 VPWR VGND VPWR VGND sky130_ef_sc_hd__decap_12
XFILLER_79_782 VGND VGND VPWR VPWR sky130_fd_sc_hd__fill_2
X_3193_ _0842_ _0874_ _0873_ VGND VGND VPWR VPWR _0095_ sky130_fd_sc_hd__mux2_1
X_2213_ _1468_ _1469_ VGND VGND VPWR VPWR _1470_ sky130_fd_sc_hd__or2_1
X_2144_ B_reg\[1\] _1398_ _1402_ VGND VGND VPWR VPWR _1403_ sky130_fd_sc_hd__o21ba_1
XFILLER_93_273 VGND VGND VPWR VPWR sky130_fd_sc_hd__decap_6
XTAP_TAPCELL_ROW_68_1417 VGND VPWR sky130_fd_sc_hd__tapvpwrvgnd_1
XANTENNA__2835__S _0383_ VGND VGND VPWR VPWR sky130_fd_sc_hd__diode_2
XFILLER_81_435 VGND VGND VPWR VPWR sky130_fd_sc_hd__fill_2
X_2075_ B_reg\[2\] _1336_ VGND VGND VPWR VPWR _1337_ sky130_fd_sc_hd__nor2_1
XFILLER_35_841 VPWR VGND VPWR VGND sky130_ef_sc_hd__decap_12
XFILLER_38_189 VGND VGND VPWR VPWR sky130_fd_sc_hd__decap_6
XTAP_TAPCELL_ROW_81_1628 VGND VPWR sky130_fd_sc_hd__tapvpwrvgnd_1
XANTENNA__1961__A1_N B_reg\[5\] VGND VGND VPWR VPWR sky130_fd_sc_hd__diode_2
XFILLER_22_513 VPWR VGND VPWR VGND sky130_ef_sc_hd__decap_12
XFILLER_61_181 VGND VGND VPWR VPWR sky130_fd_sc_hd__decap_6
XFILLER_22_557 VPWR VGND VPWR VGND sky130_ef_sc_hd__decap_12
X_2977_ _0564_ _0571_ VGND VGND VPWR VPWR _0665_ sky130_fd_sc_hd__nand2_1
XFILLER_136_905 VGND VGND VPWR VPWR sky130_fd_sc_hd__decap_4
X_1928_ _1173_ _1185_ _1188_ VGND VGND VPWR VPWR _1193_ sky130_fd_sc_hd__a21oi_1
X_1859_ _1127_ _1128_ A_reg\[8\] VGND VGND VPWR VPWR _1129_ sky130_fd_sc_hd__o21ai_1
XFILLER_30_27 VGND VGND VPWR VPWR sky130_fd_sc_hd__fill_1
XFILLER_146_27 VGND VGND VPWR VPWR sky130_fd_sc_hd__fill_1
XTAP_TAPCELL_ROW_112_2127 VGND VPWR sky130_fd_sc_hd__tapvpwrvgnd_1
XTAP_TAPCELL_ROW_112_2116 VGND VPWR sky130_fd_sc_hd__tapvpwrvgnd_1
XTAP_TAPCELL_ROW_96_1871 VGND VPWR sky130_fd_sc_hd__tapvpwrvgnd_1
XTAP_TAPCELL_ROW_96_1860 VGND VPWR sky130_fd_sc_hd__tapvpwrvgnd_1
XFILLER_122_109 VPWR VGND VPWR VGND sky130_ef_sc_hd__decap_12
XFILLER_104_813 VPWR VGND VPWR VGND sky130_ef_sc_hd__decap_12
XFILLER_1_417 VPWR VGND VPWR VGND sky130_ef_sc_hd__decap_12
XFILLER_115_161 VGND VGND VPWR VPWR sky130_fd_sc_hd__decap_6
XFILLER_131_665 VGND VGND VPWR VPWR sky130_fd_sc_hd__decap_6
XFILLER_130_153 VPWR VGND VPWR VGND sky130_ef_sc_hd__decap_12
XFILLER_103_367 VGND VGND VPWR VPWR sky130_fd_sc_hd__fill_1
XFILLER_103_389 VGND VGND VPWR VPWR sky130_fd_sc_hd__decap_3
XFILLER_39_69 VPWR VGND VPWR VGND sky130_ef_sc_hd__decap_12
XFILLER_130_197 VPWR VGND VPWR VGND sky130_ef_sc_hd__decap_12
XFILLER_85_741 VPWR VGND VPWR VGND sky130_ef_sc_hd__decap_12
XTAP_TAPCELL_ROW_127_2370 VGND VPWR sky130_fd_sc_hd__tapvpwrvgnd_1
XFILLER_85_785 VPWR VGND VPWR VGND sky130_ef_sc_hd__decap_12
XFILLER_84_262 VPWR VGND VPWR VGND sky130_ef_sc_hd__decap_12
XFILLER_72_413 VGND VGND VPWR VPWR sky130_fd_sc_hd__decap_6
XFILLER_29_167 VGND VGND VPWR VPWR sky130_fd_sc_hd__fill_1
XFILLER_55_57 VPWR VGND VPWR VGND sky130_ef_sc_hd__decap_12
XFILLER_45_649 VPWR VGND VPWR VGND sky130_ef_sc_hd__decap_12
XFILLER_72_457 VGND VGND VPWR VPWR sky130_fd_sc_hd__decap_8
XTAP_TAPCELL_ROW_140_2570 VGND VPWR sky130_fd_sc_hd__tapvpwrvgnd_1
XFILLER_52_181 VPWR VGND VPWR VGND sky130_ef_sc_hd__decap_12
XFILLER_9_517 VPWR VGND VPWR VGND sky130_ef_sc_hd__decap_12
XFILLER_41_877 VGND VGND VPWR VPWR sky130_fd_sc_hd__decap_6
XFILLER_139_721 VGND VGND VPWR VPWR sky130_fd_sc_hd__decap_6
XFILLER_40_365 VPWR VGND VPWR VGND sky130_ef_sc_hd__decap_12
XFILLER_139_765 VPWR VGND VPWR VGND sky130_ef_sc_hd__decap_12
XFILLER_138_253 VPWR VGND VPWR VGND sky130_ef_sc_hd__decap_12
XFILLER_141_429 VPWR VGND VPWR VGND sky130_ef_sc_hd__decap_12
XFILLER_107_673 VPWR VGND VPWR VGND sky130_ef_sc_hd__decap_12
XFILLER_4_244 VGND VGND VPWR VPWR sky130_fd_sc_hd__decap_8
XFILLER_122_643 VGND VGND VPWR VPWR sky130_fd_sc_hd__fill_1
XFILLER_4_277 VPWR VGND VPWR VGND sky130_ef_sc_hd__decap_12
XFILLER_110_805 VGND VGND VPWR VPWR sky130_fd_sc_hd__decap_6
XFILLER_96_53 VPWR VGND VPWR VGND sky130_ef_sc_hd__decap_12
XFILLER_95_505 VGND VGND VPWR VPWR sky130_fd_sc_hd__decap_4
XFILLER_110_849 VPWR VGND VPWR VGND sky130_ef_sc_hd__decap_12
XFILLER_0_461 VGND VGND VPWR VPWR sky130_fd_sc_hd__fill_2
XFILLER_96_97 VPWR VGND VPWR VGND sky130_ef_sc_hd__decap_12
XFILLER_76_730 VPWR VGND VPWR VGND sky130_ef_sc_hd__decap_12
XFILLER_48_421 VPWR VGND VPWR VGND sky130_ef_sc_hd__decap_12
XFILLER_76_774 VPWR VGND VPWR VGND sky130_ef_sc_hd__decap_12
XFILLER_75_273 VGND VGND VPWR VPWR sky130_fd_sc_hd__decap_6
XFILLER_63_435 VGND VGND VPWR VPWR sky130_fd_sc_hd__decap_4
XFILLER_17_841 VPWR VGND VPWR VGND sky130_ef_sc_hd__decap_12
XFILLER_35_137 VPWR VGND VPWR VGND sky130_ef_sc_hd__decap_12
XFILLER_91_777 VGND VGND VPWR VPWR sky130_fd_sc_hd__decap_6
XPHY_EDGE_ROW_11_Left_165 VGND VGND VPWR VPWR sky130_fd_sc_hd__decap_3
X_2900_ _0570_ _0574_ VGND VGND VPWR VPWR _0588_ sky130_fd_sc_hd__xor2_1
XTAP_TAPCELL_ROW_63_1336 VGND VPWR sky130_fd_sc_hd__tapvpwrvgnd_1
XFILLER_32_811 VGND VGND VPWR VPWR sky130_fd_sc_hd__fill_1
XFILLER_32_822 VPWR VGND VPWR VGND sky130_ef_sc_hd__decap_12
XFILLER_149_529 VPWR VGND VPWR VGND sky130_ef_sc_hd__decap_12
XTAP_TAPCELL_ROW_63_1347 VGND VPWR sky130_fd_sc_hd__tapvpwrvgnd_1
XFILLER_32_877 VGND VGND VPWR VPWR sky130_fd_sc_hd__decap_3
X_2831_ net42 X_crt\[13\] _0553_ VGND VGND VPWR VPWR _0054_ sky130_fd_sc_hd__mux2_1
XTAP_TAPCELL_ROW_14_552 VGND VPWR sky130_fd_sc_hd__tapvpwrvgnd_1
XTAP_TAPCELL_ROW_14_563 VGND VPWR sky130_fd_sc_hd__tapvpwrvgnd_1
XFILLER_118_905 VGND VGND VPWR VPWR sky130_fd_sc_hd__decap_4
X_2762_ _0500_ _0501_ VGND VGND VPWR VPWR _0502_ sky130_fd_sc_hd__nand2_1
X_1713_ A_reg\[2\] _0986_ _0988_ VGND VGND VPWR VPWR _0989_ sky130_fd_sc_hd__o21ba_1
XFILLER_144_245 VGND VGND VPWR VPWR sky130_fd_sc_hd__decap_6
X_2693_ _0187_ _0431_ _0432_ _0427_ _0185_ VGND VGND VPWR VPWR _0433_ sky130_fd_sc_hd__a32o_1
XFILLER_104_109 VPWR VGND VPWR VGND sky130_ef_sc_hd__decap_12
X_1644_ A_reg\[12\] _0916_ VGND VGND VPWR VPWR _0920_ sky130_fd_sc_hd__or2_1
XPHY_EDGE_ROW_20_Left_174 VGND VGND VPWR VPWR sky130_fd_sc_hd__decap_3
XFILLER_144_289 VPWR VGND VPWR VGND sky130_ef_sc_hd__decap_12
XFILLER_99_833 VGND VGND VPWR VPWR sky130_fd_sc_hd__decap_6
XFILLER_113_665 VGND VGND VPWR VPWR sky130_fd_sc_hd__decap_6
XFILLER_99_877 VPWR VGND VPWR VGND sky130_ef_sc_hd__decap_12
XFILLER_98_365 VPWR VGND VPWR VGND sky130_ef_sc_hd__decap_12
XFILLER_98_354 VGND VGND VPWR VPWR sky130_fd_sc_hd__decap_8
X_3314_ clknet_3_7__leaf_clk _0097_ net36 VGND VGND VPWR VPWR X_crt\[8\] sky130_fd_sc_hd__dfrtp_1
XFILLER_112_153 VPWR VGND VPWR VGND sky130_ef_sc_hd__decap_12
XTAP_TAPCELL_ROW_91_1790 VGND VPWR sky130_fd_sc_hd__tapvpwrvgnd_1
XFILLER_86_516 VPWR VGND VPWR VGND sky130_ef_sc_hd__decap_12
X_3245_ clknet_3_6__leaf_clk _0030_ net36 VGND VGND VPWR VPWR u_crt.r1\[1\] sky130_fd_sc_hd__dfrtp_2
XFILLER_112_197 VPWR VGND VPWR VGND sky130_ef_sc_hd__decap_12
XFILLER_67_741 VGND VGND VPWR VPWR sky130_fd_sc_hd__fill_1
XFILLER_132_29 VPWR VGND VPWR VGND sky130_ef_sc_hd__decap_12
XFILLER_67_785 VPWR VGND VPWR VGND sky130_ef_sc_hd__decap_12
XFILLER_66_251 VGND VGND VPWR VPWR sky130_fd_sc_hd__fill_1
X_3176_ X_crt\[1\] _0862_ CRT_Start VGND VGND VPWR VPWR _0090_ sky130_fd_sc_hd__mux2_1
X_2127_ _1383_ _1385_ B_reg\[5\] VGND VGND VPWR VPWR _1386_ sky130_fd_sc_hd__mux2_1
X_2058_ _0905_ _1319_ _1307_ VGND VGND VPWR VPWR _1320_ sky130_fd_sc_hd__a21oi_1
XFILLER_54_457 VGND VGND VPWR VPWR sky130_fd_sc_hd__decap_3
XFILLER_25_27 VPWR VGND VPWR VGND sky130_ef_sc_hd__decap_12
XFILLER_23_833 VGND VGND VPWR VPWR sky130_fd_sc_hd__decap_6
XFILLER_35_671 VGND VGND VPWR VPWR sky130_fd_sc_hd__fill_1
XFILLER_22_321 VPWR VGND VPWR VGND sky130_ef_sc_hd__decap_12
XFILLER_22_343 VPWR VGND VPWR VGND sky130_ef_sc_hd__decap_12
XFILLER_22_365 VPWR VGND VPWR VGND sky130_ef_sc_hd__decap_12
XFILLER_23_877 VPWR VGND VPWR VGND sky130_ef_sc_hd__decap_12
XTAP_TAPCELL_ROW_33_861 VGND VPWR sky130_fd_sc_hd__tapvpwrvgnd_1
XTAP_TAPCELL_ROW_98_1900 VGND VPWR sky130_fd_sc_hd__tapvpwrvgnd_1
XFILLER_41_15 VPWR VGND VPWR VGND sky130_ef_sc_hd__decap_12
XFILLER_136_713 VPWR VGND VPWR VGND sky130_ef_sc_hd__decap_12
XFILLER_136_757 VPWR VGND VPWR VGND sky130_ef_sc_hd__decap_12
XFILLER_135_223 VGND VGND VPWR VPWR sky130_fd_sc_hd__fill_1
XANTENNA_clkbuf_3_5__f_clk_A clknet_0_clk VGND VGND VPWR VPWR sky130_fd_sc_hd__diode_2
XFILLER_151_727 VGND VGND VPWR VPWR sky130_fd_sc_hd__fill_1
XFILLER_123_429 VPWR VGND VPWR VGND sky130_ef_sc_hd__decap_12
XFILLER_2_737 VPWR VGND VPWR VGND sky130_ef_sc_hd__decap_12
XFILLER_1_225 VPWR VGND VPWR VGND sky130_ef_sc_hd__decap_12
XFILLER_104_643 VGND VGND VPWR VPWR sky130_fd_sc_hd__fill_1
XFILLER_77_505 VPWR VGND VPWR VGND sky130_ef_sc_hd__decap_12
XFILLER_131_473 VPWR VGND VPWR VGND sky130_ef_sc_hd__decap_12
XFILLER_106_41 VPWR VGND VPWR VGND sky130_ef_sc_hd__decap_12
XFILLER_106_85 VPWR VGND VPWR VGND sky130_ef_sc_hd__decap_12
XTAP_TAPCELL_ROW_142_2610 VGND VPWR sky130_fd_sc_hd__tapvpwrvgnd_1
XTAP_TAPCELL_ROW_125_2329 VGND VPWR sky130_fd_sc_hd__tapvpwrvgnd_1
XFILLER_46_903 VGND VGND VPWR VPWR sky130_fd_sc_hd__decap_4
XFILLER_100_893 VPWR VGND VPWR VGND sky130_ef_sc_hd__decap_12
XFILLER_72_221 VPWR VGND VPWR VGND sky130_ef_sc_hd__decap_12
XFILLER_17_137 VPWR VGND VPWR VGND sky130_ef_sc_hd__decap_12
XFILLER_73_777 VGND VGND VPWR VPWR sky130_fd_sc_hd__decap_6
XFILLER_14_811 VGND VGND VPWR VPWR sky130_fd_sc_hd__fill_1
XFILLER_26_693 VGND VGND VPWR VPWR sky130_fd_sc_hd__decap_6
XFILLER_25_181 VPWR VGND VPWR VGND sky130_ef_sc_hd__decap_12
XFILLER_41_641 VPWR VGND VPWR VGND sky130_ef_sc_hd__decap_12
XTAP_TAPCELL_ROW_45_1044 VGND VPWR sky130_fd_sc_hd__tapvpwrvgnd_1
XTAP_TAPCELL_ROW_45_1055 VGND VPWR sky130_fd_sc_hd__tapvpwrvgnd_1
XFILLER_15_93 VPWR VGND VPWR VGND sky130_ef_sc_hd__decap_12
XTAP_TAPCELL_ROW_11_500 VGND VPWR sky130_fd_sc_hd__tapvpwrvgnd_1
XTAP_TAPCELL_ROW_11_511 VGND VPWR sky130_fd_sc_hd__tapvpwrvgnd_1
XFILLER_40_195 VGND VGND VPWR VPWR sky130_fd_sc_hd__fill_1
XANTENNA__2504__A a_r1\[0\] VGND VGND VPWR VPWR sky130_fd_sc_hd__diode_2
XFILLER_139_573 VPWR VGND VPWR VGND sky130_ef_sc_hd__decap_12
XTAP_TAPCELL_ROW_153_2783 VGND VPWR sky130_fd_sc_hd__tapvpwrvgnd_1
XTAP_TAPCELL_ROW_153_2772 VGND VPWR sky130_fd_sc_hd__tapvpwrvgnd_1
XTAP_TAPCELL_ROW_153_2794 VGND VPWR sky130_fd_sc_hd__tapvpwrvgnd_1
XFILLER_126_245 VGND VGND VPWR VPWR sky130_fd_sc_hd__decap_6
XFILLER_56_8 VPWR VGND VPWR VGND sky130_ef_sc_hd__decap_12
XANTENNA__3317__CLK clknet_3_5__leaf_clk VGND VGND VPWR VPWR sky130_fd_sc_hd__diode_2
XFILLER_5_553 VGND VGND VPWR VPWR sky130_fd_sc_hd__decap_6
XFILLER_31_81 VPWR VGND VPWR VGND sky130_ef_sc_hd__decap_12
XFILLER_147_81 VPWR VGND VPWR VGND sky130_ef_sc_hd__decap_12
XFILLER_142_749 VGND VGND VPWR VPWR sky130_fd_sc_hd__decap_6
XFILLER_141_237 VPWR VGND VPWR VGND sky130_ef_sc_hd__decap_12
XFILLER_126_289 VPWR VGND VPWR VGND sky130_ef_sc_hd__decap_12
XFILLER_5_597 VPWR VGND VPWR VGND sky130_ef_sc_hd__decap_12
XFILLER_150_793 VPWR VGND VPWR VGND sky130_ef_sc_hd__decap_12
XFILLER_110_613 VPWR VGND VPWR VGND sky130_ef_sc_hd__decap_12
XFILLER_96_825 VPWR VGND VPWR VGND sky130_ef_sc_hd__decap_12
XFILLER_110_657 VPWR VGND VPWR VGND sky130_ef_sc_hd__decap_12
XFILLER_96_869 VPWR VGND VPWR VGND sky130_ef_sc_hd__decap_12
XFILLER_95_335 VGND VGND VPWR VPWR sky130_fd_sc_hd__fill_1
X_3030_ _0714_ _0716_ _0717_ VGND VGND VPWR VPWR _0718_ sky130_fd_sc_hd__o21ai_2
XFILLER_48_251 VGND VGND VPWR VPWR sky130_fd_sc_hd__fill_1
XFILLER_64_755 VGND VGND VPWR VPWR sky130_fd_sc_hd__fill_1
XTAP_TAPCELL_ROW_19_633 VGND VPWR sky130_fd_sc_hd__tapvpwrvgnd_1
XFILLER_91_585 VPWR VGND VPWR VGND sky130_ef_sc_hd__decap_12
XFILLER_64_799 VPWR VGND VPWR VGND sky130_ef_sc_hd__decap_12
XFILLER_63_298 VGND VGND VPWR VPWR sky130_fd_sc_hd__decap_8
XFILLER_17_671 VGND VGND VPWR VPWR sky130_fd_sc_hd__fill_1
XFILLER_51_449 VPWR VGND VPWR VGND sky130_ef_sc_hd__decap_12
XFILLER_44_490 VPWR VGND VPWR VGND sky130_ef_sc_hd__decap_12
XFILLER_149_337 VPWR VGND VPWR VGND sky130_ef_sc_hd__decap_12
XFILLER_20_825 VPWR VGND VPWR VGND sky130_ef_sc_hd__decap_12
X_2814_ _0539_ _0547_ _0540_ VGND VGND VPWR VPWR _0551_ sky130_fd_sc_hd__o21a_1
XFILLER_118_713 VPWR VGND VPWR VGND sky130_ef_sc_hd__decap_12
XFILLER_20_869 VPWR VGND VPWR VGND sky130_ef_sc_hd__decap_12
XFILLER_118_757 VPWR VGND VPWR VGND sky130_ef_sc_hd__decap_12
XFILLER_117_223 VGND VGND VPWR VPWR sky130_fd_sc_hd__fill_1
X_2745_ _0443_ _0446_ _0475_ VGND VGND VPWR VPWR _0485_ sky130_fd_sc_hd__nand3_1
XFILLER_133_727 VGND VGND VPWR VPWR sky130_fd_sc_hd__fill_1
X_2676_ _0384_ _0411_ _0415_ _0188_ VGND VGND VPWR VPWR _0416_ sky130_fd_sc_hd__a211o_1
XTAP_TAPCELL_ROW_76_1549 VGND VPWR sky130_fd_sc_hd__tapvpwrvgnd_1
XFILLER_105_429 VPWR VGND VPWR VGND sky130_ef_sc_hd__decap_12
X_1627_ B_reg\[3\] VGND VGND VPWR VPWR _0907_ sky130_fd_sc_hd__inv_2
XFILLER_99_641 VPWR VGND VPWR VGND sky130_ef_sc_hd__decap_12
XFILLER_113_473 VPWR VGND VPWR VGND sky130_ef_sc_hd__decap_12
XFILLER_99_685 VPWR VGND VPWR VGND sky130_ef_sc_hd__decap_12
XFILLER_59_505 VPWR VGND VPWR VGND sky130_ef_sc_hd__decap_12
XFILLER_143_39 VPWR VGND VPWR VGND sky130_ef_sc_hd__decap_12
XFILLER_86_335 VPWR VGND VPWR VGND sky130_ef_sc_hd__decap_12
X_3228_ clknet_3_1__leaf_clk _0015_ net36 VGND VGND VPWR VPWR b_r1\[1\] sky130_fd_sc_hd__dfrtp_4
XTAP_TAPCELL_ROW_107_2048 VGND VPWR sky130_fd_sc_hd__tapvpwrvgnd_1
XTAP_TAPCELL_ROW_107_2037 VGND VPWR sky130_fd_sc_hd__tapvpwrvgnd_1
XFILLER_100_189 VGND VGND VPWR VPWR sky130_fd_sc_hd__decap_6
XFILLER_54_221 VPWR VGND VPWR VGND sky130_ef_sc_hd__decap_12
XFILLER_27_424 VPWR VGND VPWR VGND sky130_ef_sc_hd__decap_12
XFILLER_36_15 VPWR VGND VPWR VGND sky130_ef_sc_hd__decap_12
XFILLER_39_273 VGND VGND VPWR VPWR sky130_fd_sc_hd__decap_6
X_3159_ _0836_ _0841_ _0846_ VGND VGND VPWR VPWR _0847_ sky130_fd_sc_hd__and3b_1
XFILLER_82_563 VPWR VGND VPWR VGND sky130_ef_sc_hd__decap_12
XTAP_TAPCELL_ROW_38_942 VGND VPWR sky130_fd_sc_hd__tapvpwrvgnd_1
XFILLER_70_725 VPWR VGND VPWR VGND sky130_ef_sc_hd__decap_12
XFILLER_54_276 VGND VGND VPWR VPWR sky130_fd_sc_hd__decap_3
XTAP_TAPCELL_ROW_120_2259 VGND VPWR sky130_fd_sc_hd__tapvpwrvgnd_1
XTAP_TAPCELL_ROW_120_2248 VGND VPWR sky130_fd_sc_hd__tapvpwrvgnd_1
XFILLER_54_298 VGND VGND VPWR VPWR sky130_fd_sc_hd__decap_8
XFILLER_23_641 VPWR VGND VPWR VGND sky130_ef_sc_hd__decap_12
XFILLER_23_685 VPWR VGND VPWR VGND sky130_ef_sc_hd__decap_12
XTAP_TAPCELL_ROW_102_1970 VGND VPWR sky130_fd_sc_hd__tapvpwrvgnd_1
XFILLER_50_471 VGND VGND VPWR VPWR sky130_fd_sc_hd__decap_4
XFILLER_22_195 VGND VGND VPWR VPWR sky130_fd_sc_hd__fill_1
XTAP_TAPCELL_ROW_135_2491 VGND VPWR sky130_fd_sc_hd__tapvpwrvgnd_1
XFILLER_108_245 VGND VGND VPWR VPWR sky130_fd_sc_hd__decap_6
XFILLER_136_587 VGND VGND VPWR VPWR sky130_fd_sc_hd__fill_1
XFILLER_124_749 VGND VGND VPWR VPWR sky130_fd_sc_hd__decap_6
XFILLER_108_289 VPWR VGND VPWR VGND sky130_ef_sc_hd__decap_12
XFILLER_123_237 VPWR VGND VPWR VGND sky130_ef_sc_hd__decap_12
XFILLER_117_51 VGND VGND VPWR VPWR sky130_fd_sc_hd__decap_4
XFILLER_7_3 VPWR VGND VPWR VGND sky130_ef_sc_hd__decap_12
XFILLER_132_793 VPWR VGND VPWR VGND sky130_ef_sc_hd__decap_12
XFILLER_89_162 VGND VGND VPWR VPWR sky130_fd_sc_hd__decap_6
XFILLER_78_825 VPWR VGND VPWR VGND sky130_ef_sc_hd__decap_12
XFILLER_2_589 VGND VGND VPWR VPWR sky130_fd_sc_hd__fill_1
XFILLER_131_281 VPWR VGND VPWR VGND sky130_ef_sc_hd__decap_12
XFILLER_78_869 VPWR VGND VPWR VGND sky130_ef_sc_hd__decap_12
XFILLER_77_335 VGND VGND VPWR VPWR sky130_fd_sc_hd__fill_1
XFILLER_77_77 VGND VGND VPWR VPWR sky130_fd_sc_hd__decap_3
XFILLER_93_839 VGND VGND VPWR VPWR sky130_fd_sc_hd__fill_1
XFILLER_73_541 VPWR VGND VPWR VGND sky130_ef_sc_hd__decap_12
XFILLER_46_755 VGND VGND VPWR VPWR sky130_fd_sc_hd__fill_1
XFILLER_73_585 VPWR VGND VPWR VGND sky130_ef_sc_hd__decap_12
XFILLER_33_405 VPWR VGND VPWR VGND sky130_ef_sc_hd__decap_12
XFILLER_33_449 VPWR VGND VPWR VGND sky130_ef_sc_hd__decap_12
XFILLER_9_111 VGND VGND VPWR VPWR sky130_fd_sc_hd__fill_1
XFILLER_146_307 VGND VGND VPWR VPWR sky130_fd_sc_hd__fill_1
X_2530_ _0277_ VGND VGND VPWR VPWR _0278_ sky130_fd_sc_hd__inv_2
XFILLER_142_513 VPWR VGND VPWR VGND sky130_ef_sc_hd__decap_12
XFILLER_115_727 VGND VGND VPWR VPWR sky130_fd_sc_hd__fill_1
X_2461_ _0201_ _0205_ _0206_ _0210_ VGND VGND VPWR VPWR _0211_ sky130_fd_sc_hd__a31o_1
XTAP_TAPCELL_ROW_58_1257 VGND VPWR sky130_fd_sc_hd__tapvpwrvgnd_1
XFILLER_142_557 VPWR VGND VPWR VGND sky130_ef_sc_hd__decap_12
X_2392_ _0908_ _0143_ _0144_ VGND VGND VPWR VPWR _0146_ sky130_fd_sc_hd__or3_1
XFILLER_110_421 VPWR VGND VPWR VGND sky130_ef_sc_hd__decap_12
XTAP_TAPCELL_ROW_71_1468 VGND VPWR sky130_fd_sc_hd__tapvpwrvgnd_1
XFILLER_96_699 VGND VGND VPWR VPWR sky130_fd_sc_hd__fill_1
XFILLER_83_305 VGND VGND VPWR VPWR sky130_fd_sc_hd__decap_8
XFILLER_68_357 VGND VGND VPWR VPWR sky130_fd_sc_hd__decap_6
XPHY_EDGE_ROW_147_Right_147 VGND VGND VPWR VPWR sky130_fd_sc_hd__decap_3
X_3013_ _0567_ _0568_ _0569_ _0579_ VGND VGND VPWR VPWR _0701_ sky130_fd_sc_hd__o31a_1
XFILLER_83_349 VPWR VGND VPWR VGND sky130_ef_sc_hd__decap_12
XFILLER_92_861 VGND VGND VPWR VPWR sky130_fd_sc_hd__decap_6
XFILLER_64_552 VPWR VGND VPWR VGND sky130_ef_sc_hd__decap_12
XFILLER_37_777 VGND VGND VPWR VPWR sky130_fd_sc_hd__decap_6
XFILLER_52_725 VPWR VGND VPWR VGND sky130_ef_sc_hd__decap_12
XFILLER_36_265 VPWR VGND VPWR VGND sky130_ef_sc_hd__decap_12
XFILLER_91_393 VPWR VGND VPWR VGND sky130_ef_sc_hd__decap_12
XANTENNA__2843__S _0383_ VGND VGND VPWR VPWR sky130_fd_sc_hd__diode_2
XFILLER_51_268 VPWR VGND VPWR VGND sky130_ef_sc_hd__decap_12
XFILLER_149_167 VGND VGND VPWR VPWR sky130_fd_sc_hd__fill_1
XFILLER_137_329 VGND VGND VPWR VPWR sky130_fd_sc_hd__decap_6
XFILLER_20_699 VGND VGND VPWR VPWR sky130_fd_sc_hd__fill_1
X_2728_ a_r3\[3\] b_r3\[1\] _0467_ VGND VGND VPWR VPWR _0468_ sky130_fd_sc_hd__and3_1
XFILLER_3_309 VGND VGND VPWR VPWR sky130_fd_sc_hd__fill_1
XFILLER_145_373 VPWR VGND VPWR VGND sky130_ef_sc_hd__decap_12
XFILLER_118_587 VGND VGND VPWR VPWR sky130_fd_sc_hd__fill_1
XFILLER_106_749 VGND VGND VPWR VPWR sky130_fd_sc_hd__decap_6
XANTENNA__1754__A1 A_reg\[10\] VGND VGND VPWR VPWR sky130_fd_sc_hd__diode_2
XFILLER_105_237 VPWR VGND VPWR VGND sky130_ef_sc_hd__decap_12
X_2659_ b_r3\[2\] _0393_ _0397_ VGND VGND VPWR VPWR _0399_ sky130_fd_sc_hd__or3b_1
XFILLER_114_793 VPWR VGND VPWR VGND sky130_ef_sc_hd__decap_12
XFILLER_113_281 VPWR VGND VPWR VGND sky130_ef_sc_hd__decap_12
XFILLER_59_324 VPWR VGND VPWR VGND sky130_ef_sc_hd__decap_12
XFILLER_86_165 VGND VGND VPWR VPWR sky130_fd_sc_hd__decap_8
XFILLER_47_508 VGND VGND VPWR VPWR sky130_fd_sc_hd__fill_1
XPHY_EDGE_ROW_114_Right_114 VGND VGND VPWR VPWR sky130_fd_sc_hd__decap_3
XFILLER_75_839 VGND VGND VPWR VPWR sky130_fd_sc_hd__fill_1
XFILLER_47_69 VPWR VGND VPWR VGND sky130_ef_sc_hd__decap_12
XFILLER_67_390 VGND VGND VPWR VPWR sky130_fd_sc_hd__fill_2
XTAP_TAPCELL_ROW_2_364 VGND VPWR sky130_fd_sc_hd__tapvpwrvgnd_1
XFILLER_28_755 VGND VGND VPWR VPWR sky130_fd_sc_hd__fill_1
XFILLER_15_405 VPWR VGND VPWR VGND sky130_ef_sc_hd__decap_12
XFILLER_82_382 VPWR VGND VPWR VGND sky130_ef_sc_hd__decap_12
XFILLER_63_57 VPWR VGND VPWR VGND sky130_ef_sc_hd__decap_12
XFILLER_15_449 VPWR VGND VPWR VGND sky130_ef_sc_hd__decap_12
XFILLER_31_909 VGND VGND VPWR VPWR sky130_fd_sc_hd__fill_1
XFILLER_144_3 VPWR VGND VPWR VGND sky130_ef_sc_hd__decap_12
XTAP_TAPCELL_ROW_137_2520 VGND VPWR sky130_fd_sc_hd__tapvpwrvgnd_1
XTAP_TAPCELL_ROW_100_1929 VGND VPWR sky130_fd_sc_hd__tapvpwrvgnd_1
XTAP_TAPCELL_ROW_42_1003 VGND VPWR sky130_fd_sc_hd__tapvpwrvgnd_1
XTAP_TAPCELL_ROW_137_2531 VGND VPWR sky130_fd_sc_hd__tapvpwrvgnd_1
XFILLER_128_307 VGND VGND VPWR VPWR sky130_fd_sc_hd__fill_1
XANTENNA__2054__A B_reg\[4\] VGND VGND VPWR VPWR sky130_fd_sc_hd__diode_2
XFILLER_10_121 VPWR VGND VPWR VGND sky130_ef_sc_hd__decap_12
XFILLER_137_841 VPWR VGND VPWR VGND sky130_ef_sc_hd__decap_12
XFILLER_109_521 VGND VGND VPWR VPWR sky130_fd_sc_hd__decap_3
XFILLER_10_165 VPWR VGND VPWR VGND sky130_ef_sc_hd__decap_12
XTAP_TAPCELL_ROW_21_661 VGND VPWR sky130_fd_sc_hd__tapvpwrvgnd_1
XTAP_TAPCELL_ROW_21_672 VGND VPWR sky130_fd_sc_hd__tapvpwrvgnd_1
XTAP_TAPCELL_ROW_150_2731 VGND VPWR sky130_fd_sc_hd__tapvpwrvgnd_1
XANTENNA__2437__A_N OpSel_reg\[0\] VGND VGND VPWR VPWR sky130_fd_sc_hd__diode_2
XFILLER_152_811 VGND VGND VPWR VPWR sky130_fd_sc_hd__fill_1
XFILLER_124_513 VPWR VGND VPWR VGND sky130_ef_sc_hd__decap_12
XFILLER_3_821 VPWR VGND VPWR VGND sky130_ef_sc_hd__decap_12
XFILLER_12_83 VGND VGND VPWR VPWR sky130_fd_sc_hd__fill_1
XFILLER_128_83 VGND VGND VPWR VPWR sky130_fd_sc_hd__fill_1
XFILLER_124_557 VPWR VGND VPWR VGND sky130_ef_sc_hd__decap_12
XFILLER_98_909 VGND VGND VPWR VPWR sky130_fd_sc_hd__fill_1
XFILLER_3_865 VPWR VGND VPWR VGND sky130_ef_sc_hd__decap_12
XFILLER_88_76 VGND VGND VPWR VPWR sky130_fd_sc_hd__decap_8
XFILLER_2_353 VGND VGND VPWR VPWR sky130_fd_sc_hd__fill_1
XFILLER_78_622 VGND VGND VPWR VPWR sky130_fd_sc_hd__decap_6
XFILLER_77_154 VPWR VGND VPWR VGND sky130_ef_sc_hd__decap_12
XTAP_TAPCELL_ROW_53_1187 VGND VPWR sky130_fd_sc_hd__tapvpwrvgnd_1
XTAP_TAPCELL_ROW_53_1176 VGND VPWR sky130_fd_sc_hd__tapvpwrvgnd_1
XTAP_TAPCELL_ROW_148_2693 VGND VPWR sky130_fd_sc_hd__tapvpwrvgnd_1
XFILLER_78_699 VGND VGND VPWR VPWR sky130_fd_sc_hd__fill_1
XANTENNA__3276__RESET_B net36 VGND VGND VPWR VPWR sky130_fd_sc_hd__diode_2
XFILLER_93_669 VGND VGND VPWR VPWR sky130_fd_sc_hd__decap_3
XFILLER_81_809 VPWR VGND VPWR VGND sky130_ef_sc_hd__decap_12
XFILLER_74_861 VGND VGND VPWR VPWR sky130_fd_sc_hd__decap_6
XFILLER_18_221 VPWR VGND VPWR VGND sky130_ef_sc_hd__decap_12
XFILLER_46_585 VGND VGND VPWR VPWR sky130_fd_sc_hd__decap_3
XFILLER_18_265 VPWR VGND VPWR VGND sky130_ef_sc_hd__decap_12
XFILLER_19_777 VGND VGND VPWR VPWR sky130_fd_sc_hd__decap_6
XFILLER_34_725 VPWR VGND VPWR VGND sky130_ef_sc_hd__decap_12
XFILLER_73_393 VPWR VGND VPWR VGND sky130_ef_sc_hd__decap_12
XFILLER_22_909 VGND VGND VPWR VPWR sky130_fd_sc_hd__fill_1
XTAP_TAPCELL_ROW_29_794 VGND VPWR sky130_fd_sc_hd__tapvpwrvgnd_1
XFILLER_34_769 VPWR VGND VPWR VGND sky130_ef_sc_hd__decap_12
XFILLER_33_257 VGND VGND VPWR VPWR sky130_fd_sc_hd__fill_2
X_1961_ B_reg\[5\] _1218_ _1220_ _1225_ VGND VGND VPWR VPWR _1226_ sky130_fd_sc_hd__a2bb2o_1
X_1892_ a_r0\[1\] _1160_ Encode_EN VGND VGND VPWR VPWR _0007_ sky130_fd_sc_hd__mux2_1
XFILLER_119_329 VGND VGND VPWR VPWR sky130_fd_sc_hd__decap_6
XTAP_TAPCELL_ROW_40_970 VGND VPWR sky130_fd_sc_hd__tapvpwrvgnd_1
XFILLER_143_833 VGND VGND VPWR VPWR sky130_fd_sc_hd__decap_6
XFILLER_127_373 VPWR VGND VPWR VGND sky130_ef_sc_hd__decap_12
XANTENNA__1736__A1 A_reg\[13\] VGND VGND VPWR VPWR sky130_fd_sc_hd__diode_2
X_2513_ _0223_ _0238_ VGND VGND VPWR VPWR _0261_ sky130_fd_sc_hd__or2_1
XFILLER_143_877 VPWR VGND VPWR VGND sky130_ef_sc_hd__decap_12
XFILLER_142_321 VPWR VGND VPWR VGND sky130_ef_sc_hd__decap_12
XFILLER_89_909 VGND VGND VPWR VPWR sky130_fd_sc_hd__fill_1
XFILLER_142_365 VPWR VGND VPWR VGND sky130_ef_sc_hd__decap_12
X_2444_ a_r0\[0\] a_r0\[1\] VGND VGND VPWR VPWR _0194_ sky130_fd_sc_hd__or2_1
XFILLER_111_741 VPWR VGND VPWR VGND sky130_ef_sc_hd__decap_12
X_2375_ _0120_ _0128_ VGND VGND VPWR VPWR _0129_ sky130_fd_sc_hd__nand2_1
XANTENNA__2838__S _0383_ VGND VGND VPWR VPWR sky130_fd_sc_hd__diode_2
XFILLER_110_251 VGND VGND VPWR VPWR sky130_fd_sc_hd__fill_1
XFILLER_57_806 VGND VGND VPWR VPWR sky130_fd_sc_hd__decap_4
XANTENNA__2161__A1 A_reg\[11\] VGND VGND VPWR VPWR sky130_fd_sc_hd__diode_2
XFILLER_111_785 VPWR VGND VPWR VGND sky130_ef_sc_hd__decap_12
XFILLER_83_113 VPWR VGND VPWR VGND sky130_ef_sc_hd__decap_12
XFILLER_68_165 VPWR VGND VPWR VGND sky130_ef_sc_hd__decap_12
XFILLER_57_839 VGND VGND VPWR VPWR sky130_fd_sc_hd__fill_1
XTAP_TAPCELL_ROW_88_1740 VGND VPWR sky130_fd_sc_hd__tapvpwrvgnd_1
XFILLER_84_669 VPWR VGND VPWR VGND sky130_ef_sc_hd__decap_12
XFILLER_72_809 VGND VGND VPWR VPWR sky130_fd_sc_hd__decap_3
XPHY_EDGE_ROW_3_Left_157 VGND VGND VPWR VPWR sky130_fd_sc_hd__decap_3
XFILLER_140_29 VPWR VGND VPWR VGND sky130_ef_sc_hd__decap_12
XFILLER_17_39 VPWR VGND VPWR VGND sky130_ef_sc_hd__decap_12
XFILLER_37_563 VPWR VGND VPWR VGND sky130_ef_sc_hd__decap_12
XFILLER_52_533 VPWR VGND VPWR VGND sky130_ef_sc_hd__decap_12
XFILLER_13_909 VGND VGND VPWR VPWR sky130_fd_sc_hd__fill_1
XFILLER_12_419 VGND VGND VPWR VPWR sky130_fd_sc_hd__fill_1
XFILLER_33_27 VPWR VGND VPWR VGND sky130_ef_sc_hd__decap_12
XFILLER_149_27 VPWR VGND VPWR VGND sky130_ef_sc_hd__decap_12
XFILLER_137_137 VPWR VGND VPWR VGND sky130_ef_sc_hd__decap_12
XFILLER_119_841 VPWR VGND VPWR VGND sky130_ef_sc_hd__decap_12
XANTENNA__1975__A1 B_reg\[2\] VGND VGND VPWR VPWR sky130_fd_sc_hd__diode_2
XFILLER_146_693 VGND VGND VPWR VPWR sky130_fd_sc_hd__decap_6
XFILLER_134_811 VGND VGND VPWR VPWR sky130_fd_sc_hd__fill_1
XTAP_TAPCELL_ROW_132_2450 VGND VPWR sky130_fd_sc_hd__tapvpwrvgnd_1
XTAP_TAPCELL_ROW_115_2169 VGND VPWR sky130_fd_sc_hd__tapvpwrvgnd_1
XFILLER_106_513 VPWR VGND VPWR VGND sky130_ef_sc_hd__decap_12
XFILLER_145_181 VPWR VGND VPWR VGND sky130_ef_sc_hd__decap_12
XFILLER_121_505 VPWR VGND VPWR VGND sky130_ef_sc_hd__decap_12
XFILLER_0_813 VPWR VGND VPWR VGND sky130_ef_sc_hd__decap_12
XFILLER_59_121 VGND VGND VPWR VPWR sky130_fd_sc_hd__fill_1
XFILLER_58_46 VPWR VGND VPWR VGND sky130_ef_sc_hd__decap_12
XTAP_TAPCELL_ROW_7_445 VGND VPWR sky130_fd_sc_hd__tapvpwrvgnd_1
XFILLER_114_41 VPWR VGND VPWR VGND sky130_ef_sc_hd__decap_12
XFILLER_101_273 VGND VGND VPWR VPWR sky130_fd_sc_hd__decap_6
XFILLER_87_485 VPWR VGND VPWR VGND sky130_ef_sc_hd__decap_12
XFILLER_47_305 VPWR VGND VPWR VGND sky130_ef_sc_hd__decap_12
XFILLER_114_85 VPWR VGND VPWR VGND sky130_ef_sc_hd__decap_12
XANTENNA__2049__A B_reg\[6\] VGND VGND VPWR VPWR sky130_fd_sc_hd__diode_2
XFILLER_63_809 VPWR VGND VPWR VGND sky130_ef_sc_hd__decap_12
XFILLER_90_639 VGND VGND VPWR VPWR sky130_fd_sc_hd__decap_4
XFILLER_16_725 VPWR VGND VPWR VGND sky130_ef_sc_hd__decap_12
XFILLER_71_853 VPWR VGND VPWR VGND sky130_ef_sc_hd__decap_12
XFILLER_55_393 VPWR VGND VPWR VGND sky130_ef_sc_hd__decap_12
XFILLER_70_363 VGND VGND VPWR VPWR sky130_fd_sc_hd__fill_1
XFILLER_16_769 VPWR VGND VPWR VGND sky130_ef_sc_hd__decap_12
XTAP_TAPCELL_ROW_26_742 VGND VPWR sky130_fd_sc_hd__tapvpwrvgnd_1
XTAP_TAPCELL_ROW_26_753 VGND VPWR sky130_fd_sc_hd__tapvpwrvgnd_1
XFILLER_71_897 VPWR VGND VPWR VGND sky130_ef_sc_hd__decap_12
XFILLER_11_430 VPWR VGND VPWR VGND sky130_ef_sc_hd__decap_12
XFILLER_23_93 VPWR VGND VPWR VGND sky130_ef_sc_hd__decap_12
XFILLER_139_93 VPWR VGND VPWR VGND sky130_ef_sc_hd__decap_12
XFILLER_137_671 VGND VGND VPWR VPWR sky130_fd_sc_hd__fill_1
XFILLER_125_833 VGND VGND VPWR VPWR sky130_fd_sc_hd__decap_6
XFILLER_109_373 VPWR VGND VPWR VGND sky130_ef_sc_hd__decap_12
XANTENNA__1718__A1 A_reg\[1\] VGND VGND VPWR VPWR sky130_fd_sc_hd__diode_2
XFILLER_7_478 VPWR VGND VPWR VGND sky130_ef_sc_hd__decap_12
XFILLER_124_321 VPWR VGND VPWR VGND sky130_ef_sc_hd__decap_12
XTAP_TAPCELL_ROW_55_1216 VGND VPWR sky130_fd_sc_hd__tapvpwrvgnd_1
XTAP_TAPCELL_ROW_55_1205 VGND VPWR sky130_fd_sc_hd__tapvpwrvgnd_1
XFILLER_140_825 VPWR VGND VPWR VGND sky130_ef_sc_hd__decap_12
XFILLER_125_877 VPWR VGND VPWR VGND sky130_ef_sc_hd__decap_12
XFILLER_124_365 VPWR VGND VPWR VGND sky130_ef_sc_hd__decap_12
XFILLER_112_505 VPWR VGND VPWR VGND sky130_ef_sc_hd__decap_12
XFILLER_97_216 VGND VGND VPWR VPWR sky130_fd_sc_hd__decap_4
XFILLER_3_673 VPWR VGND VPWR VGND sky130_ef_sc_hd__decap_12
XFILLER_140_869 VPWR VGND VPWR VGND sky130_ef_sc_hd__decap_12
XFILLER_97_249 VPWR VGND VPWR VGND sky130_ef_sc_hd__decap_12
XANTENNA__2143__A1 B_reg\[1\] VGND VGND VPWR VPWR sky130_fd_sc_hd__diode_2
XFILLER_66_625 VPWR VGND VPWR VGND sky130_ef_sc_hd__decap_12
XFILLER_65_113 VGND VGND VPWR VPWR sky130_fd_sc_hd__decap_8
X_2160_ A_reg\[11\] _1410_ _1415_ VGND VGND VPWR VPWR _1417_ sky130_fd_sc_hd__and3_1
XFILLER_81_606 VGND VGND VPWR VPWR sky130_fd_sc_hd__fill_1
XFILLER_66_669 VPWR VGND VPWR VGND sky130_ef_sc_hd__decap_12
X_2091_ _1345_ _1350_ VGND VGND VPWR VPWR _1352_ sky130_fd_sc_hd__xnor2_1
XFILLER_19_541 VPWR VGND VPWR VGND sky130_ef_sc_hd__decap_12
XFILLER_38_349 VPWR VGND VPWR VGND sky130_ef_sc_hd__decap_12
XFILLER_81_617 VPWR VGND VPWR VGND sky130_ef_sc_hd__decap_12
XFILLER_0_53 VGND VGND VPWR VPWR sky130_fd_sc_hd__decap_3
XFILLER_80_127 VGND VGND VPWR VPWR sky130_fd_sc_hd__fill_1
XFILLER_19_585 VPWR VGND VPWR VGND sky130_ef_sc_hd__decap_12
XFILLER_34_533 VGND VGND VPWR VPWR sky130_fd_sc_hd__decap_8
XFILLER_0_97 VPWR VGND VPWR VGND sky130_ef_sc_hd__decap_12
X_2993_ _0563_ _0574_ VGND VGND VPWR VPWR _0681_ sky130_fd_sc_hd__nor2_1
XTAP_TAPCELL_ROW_66_1389 VGND VPWR sky130_fd_sc_hd__tapvpwrvgnd_1
XFILLER_61_385 VGND VGND VPWR VPWR sky130_fd_sc_hd__decap_6
XFILLER_21_205 VPWR VGND VPWR VGND sky130_ef_sc_hd__decap_12
X_1944_ B_reg\[6\] _1204_ _1207_ VGND VGND VPWR VPWR _1209_ sky130_fd_sc_hd__nand3_1
XFILLER_9_51 VGND VGND VPWR VPWR sky130_fd_sc_hd__decap_4
XFILLER_119_137 VPWR VGND VPWR VGND sky130_ef_sc_hd__decap_12
X_1875_ A_reg\[4\] _1140_ _1144_ VGND VGND VPWR VPWR _1145_ sky130_fd_sc_hd__o21a_1
XFILLER_116_811 VGND VGND VPWR VPWR sky130_fd_sc_hd__fill_1
XFILLER_143_641 VPWR VGND VPWR VGND sky130_ef_sc_hd__decap_12
XFILLER_128_693 VGND VGND VPWR VPWR sky130_fd_sc_hd__decap_6
XFILLER_127_181 VPWR VGND VPWR VGND sky130_ef_sc_hd__decap_12
XFILLER_143_685 VPWR VGND VPWR VGND sky130_ef_sc_hd__decap_12
XFILLER_103_505 VPWR VGND VPWR VGND sky130_ef_sc_hd__decap_12
XFILLER_0_109 VGND VGND VPWR VPWR sky130_fd_sc_hd__decap_3
XFILLER_142_195 VGND VGND VPWR VPWR sky130_fd_sc_hd__fill_1
X_2427_ b_r3\[1\] _0179_ Encode_EN VGND VGND VPWR VPWR _0024_ sky130_fd_sc_hd__mux2_1
XFILLER_130_357 VGND VGND VPWR VPWR sky130_fd_sc_hd__decap_6
XTAP_TAPCELL_ROW_110_2099 VGND VPWR sky130_fd_sc_hd__tapvpwrvgnd_1
XTAP_TAPCELL_ROW_110_2088 VGND VPWR sky130_fd_sc_hd__tapvpwrvgnd_1
XFILLER_97_783 VGND VGND VPWR VPWR sky130_fd_sc_hd__fill_1
X_2358_ _0109_ _0111_ _0106_ VGND VGND VPWR VPWR _0112_ sky130_fd_sc_hd__a21bo_1
XFILLER_69_485 VPWR VGND VPWR VGND sky130_ef_sc_hd__decap_12
XFILLER_28_27 VGND VGND VPWR VPWR sky130_fd_sc_hd__fill_1
XFILLER_151_39 VPWR VGND VPWR VGND sky130_ef_sc_hd__decap_12
XFILLER_84_433 VPWR VGND VPWR VGND sky130_ef_sc_hd__decap_12
X_2289_ a_r3\[1\] _1544_ Encode_EN VGND VGND VPWR VPWR _0020_ sky130_fd_sc_hd__mux2_1
XFILLER_29_349 VPWR VGND VPWR VGND sky130_ef_sc_hd__decap_12
XFILLER_45_809 VPWR VGND VPWR VGND sky130_ef_sc_hd__decap_12
XFILLER_84_477 VPWR VGND VPWR VGND sky130_ef_sc_hd__decap_12
XFILLER_71_105 VGND VGND VPWR VPWR sky130_fd_sc_hd__decap_6
XFILLER_37_393 VPWR VGND VPWR VGND sky130_ef_sc_hd__decap_12
XFILLER_44_15 VPWR VGND VPWR VGND sky130_ef_sc_hd__decap_12
XFILLER_53_853 VPWR VGND VPWR VGND sky130_ef_sc_hd__decap_12
XFILLER_52_330 VGND VGND VPWR VPWR sky130_fd_sc_hd__decap_6
XFILLER_53_897 VPWR VGND VPWR VGND sky130_ef_sc_hd__decap_12
XTAP_TAPCELL_ROW_23_701 VGND VPWR sky130_fd_sc_hd__tapvpwrvgnd_1
XFILLER_40_514 VPWR VGND VPWR VGND sky130_ef_sc_hd__decap_12
XFILLER_8_209 VPWR VGND VPWR VGND sky130_ef_sc_hd__decap_12
XFILLER_40_569 VPWR VGND VPWR VGND sky130_ef_sc_hd__decap_12
XFILLER_138_413 VGND VGND VPWR VPWR sky130_fd_sc_hd__decap_6
XTAP_TAPCELL_ROW_117_2209 VGND VPWR sky130_fd_sc_hd__tapvpwrvgnd_1
XFILLER_100_65 VPWR VGND VPWR VGND sky130_ef_sc_hd__decap_12
XFILLER_21_783 VGND VGND VPWR VPWR sky130_fd_sc_hd__fill_1
XFILLER_138_457 VPWR VGND VPWR VGND sky130_ef_sc_hd__decap_12
XFILLER_153_405 VPWR VGND VPWR VGND sky130_ef_sc_hd__decap_12
XTAP_TAPCELL_ROW_130_2409 VGND VPWR sky130_fd_sc_hd__tapvpwrvgnd_1
XFILLER_119_671 VGND VGND VPWR VPWR sky130_fd_sc_hd__fill_1
XFILLER_153_449 VPWR VGND VPWR VGND sky130_ef_sc_hd__decap_12
XFILLER_107_833 VGND VGND VPWR VPWR sky130_fd_sc_hd__decap_6
XFILLER_107_3 VPWR VGND VPWR VGND sky130_ef_sc_hd__decap_12
XFILLER_106_321 VPWR VGND VPWR VGND sky130_ef_sc_hd__decap_12
XFILLER_122_825 VPWR VGND VPWR VGND sky130_ef_sc_hd__decap_12
XFILLER_107_877 VPWR VGND VPWR VGND sky130_ef_sc_hd__decap_12
XFILLER_106_376 VGND VGND VPWR VPWR sky130_fd_sc_hd__decap_4
XFILLER_106_365 VGND VGND VPWR VPWR sky130_fd_sc_hd__decap_4
XFILLER_69_34 VPWR VGND VPWR VGND sky130_ef_sc_hd__decap_12
XFILLER_121_335 VGND VGND VPWR VPWR sky130_fd_sc_hd__fill_1
XFILLER_106_398 VPWR VGND VPWR VGND sky130_ef_sc_hd__decap_12
XFILLER_125_51 VGND VGND VPWR VPWR sky130_fd_sc_hd__decap_4
XFILLER_122_869 VPWR VGND VPWR VGND sky130_ef_sc_hd__decap_12
XFILLER_95_709 VPWR VGND VPWR VGND sky130_ef_sc_hd__decap_12
XFILLER_0_643 VGND VGND VPWR VPWR sky130_fd_sc_hd__fill_1
XFILLER_85_11 VGND VGND VPWR VPWR sky130_fd_sc_hd__decap_3
XTAP_TAPCELL_ROW_50_1135 VGND VPWR sky130_fd_sc_hd__tapvpwrvgnd_1
XTAP_TAPCELL_ROW_50_1124 VGND VPWR sky130_fd_sc_hd__tapvpwrvgnd_1
XFILLER_47_113 VPWR VGND VPWR VGND sky130_ef_sc_hd__decap_12
XTAP_TAPCELL_ROW_145_2652 VGND VPWR sky130_fd_sc_hd__tapvpwrvgnd_1
XFILLER_87_293 VGND VGND VPWR VPWR sky130_fd_sc_hd__fill_1
XFILLER_85_55 VGND VGND VPWR VPWR sky130_fd_sc_hd__fill_1
XANTENNA_input27_A B_in[4] VGND VGND VPWR VPWR sky130_fd_sc_hd__diode_2
XANTENNA__1884__B1 A_reg\[1\] VGND VGND VPWR VPWR sky130_fd_sc_hd__diode_2
XFILLER_63_617 VPWR VGND VPWR VGND sky130_ef_sc_hd__decap_12
XFILLER_62_105 VGND VGND VPWR VPWR sky130_fd_sc_hd__decap_8
XFILLER_35_308 VPWR VGND VPWR VGND sky130_ef_sc_hd__decap_12
XFILLER_62_127 VPWR VGND VPWR VGND sky130_ef_sc_hd__decap_12
XFILLER_16_533 VPWR VGND VPWR VGND sky130_ef_sc_hd__decap_12
XFILLER_28_393 VPWR VGND VPWR VGND sky130_ef_sc_hd__decap_12
XFILLER_71_661 VGND VGND VPWR VPWR sky130_fd_sc_hd__decap_8
XFILLER_70_160 VPWR VGND VPWR VGND sky130_ef_sc_hd__decap_12
XTAP_TAPCELL_ROW_48_1097 VGND VPWR sky130_fd_sc_hd__tapvpwrvgnd_1
XFILLER_31_503 VGND VGND VPWR VPWR sky130_fd_sc_hd__fill_1
XPHY_EDGE_ROW_75_Left_229 VGND VGND VPWR VPWR sky130_fd_sc_hd__decap_3
XFILLER_70_193 VGND VGND VPWR VPWR sky130_fd_sc_hd__decap_3
X_1660_ _0914_ _0919_ _0931_ VGND VGND VPWR VPWR _0936_ sky130_fd_sc_hd__nand3_1
XFILLER_125_641 VPWR VGND VPWR VGND sky130_ef_sc_hd__decap_12
XFILLER_109_181 VPWR VGND VPWR VGND sky130_ef_sc_hd__decap_12
XFILLER_50_91 VPWR VGND VPWR VGND sky130_ef_sc_hd__decap_12
XFILLER_125_685 VPWR VGND VPWR VGND sky130_ef_sc_hd__decap_12
XANTENNA__3291__RESET_B net36 VGND VGND VPWR VPWR sky130_fd_sc_hd__diode_2
XPHY_EDGE_ROW_84_Left_238 VGND VGND VPWR VPWR sky130_fd_sc_hd__decap_3
XFILLER_124_195 VGND VGND VPWR VPWR sky130_fd_sc_hd__fill_1
XFILLER_112_357 VGND VGND VPWR VPWR sky130_fd_sc_hd__decap_6
XANTENNA__3220__RESET_B net36 VGND VGND VPWR VPWR sky130_fd_sc_hd__diode_2
X_3261_ clknet_3_7__leaf_clk _0044_ net36 VGND VGND VPWR VPWR net47 sky130_fd_sc_hd__dfrtp_1
XFILLER_140_699 VGND VGND VPWR VPWR sky130_fd_sc_hd__fill_1
XFILLER_100_519 VPWR VGND VPWR VGND sky130_ef_sc_hd__decap_12
XFILLER_22_3 VPWR VGND VPWR VGND sky130_ef_sc_hd__decap_12
X_2212_ A_reg\[7\] _1462_ _1455_ VGND VGND VPWR VPWR _1469_ sky130_fd_sc_hd__a21oi_1
X_3192_ X_crt\[6\] _0841_ CRT_Start VGND VGND VPWR VPWR _0874_ sky130_fd_sc_hd__mux2_1
X_2143_ _1399_ B_reg\[1\] _1398_ VGND VGND VPWR VPWR _1402_ sky130_fd_sc_hd__mux2_1
XFILLER_27_809 VPWR VGND VPWR VGND sky130_ef_sc_hd__decap_12
XANTENNA__3223__D Encode_EN VGND VGND VPWR VPWR sky130_fd_sc_hd__diode_2
XTAP_TAPCELL_ROW_68_1418 VGND VPWR sky130_fd_sc_hd__tapvpwrvgnd_1
XFILLER_66_477 VPWR VGND VPWR VGND sky130_ef_sc_hd__decap_12
XFILLER_53_105 VGND VGND VPWR VPWR sky130_fd_sc_hd__decap_6
X_2074_ _1333_ _1334_ _1335_ VGND VGND VPWR VPWR _1336_ sky130_fd_sc_hd__a21oi_2
XFILLER_53_116 VPWR VGND VPWR VGND sky130_ef_sc_hd__decap_12
XFILLER_19_393 VPWR VGND VPWR VGND sky130_ef_sc_hd__decap_12
XPHY_EDGE_ROW_93_Left_247 VGND VGND VPWR VPWR sky130_fd_sc_hd__decap_3
XFILLER_35_853 VPWR VGND VPWR VGND sky130_ef_sc_hd__decap_12
XTAP_TAPCELL_ROW_81_1629 VGND VPWR sky130_fd_sc_hd__tapvpwrvgnd_1
XFILLER_22_525 VGND VGND VPWR VPWR sky130_fd_sc_hd__decap_6
XFILLER_35_897 VGND VGND VPWR VPWR sky130_fd_sc_hd__decap_8
XANTENNA__2851__S _0383_ VGND VGND VPWR VPWR sky130_fd_sc_hd__diode_2
XFILLER_50_867 VGND VGND VPWR VPWR sky130_fd_sc_hd__fill_1
XFILLER_14_29 VPWR VGND VPWR VGND sky130_ef_sc_hd__decap_12
XFILLER_22_569 VPWR VGND VPWR VGND sky130_ef_sc_hd__decap_12
XANTENNA__3223__CLK clknet_3_4__leaf_clk VGND VGND VPWR VPWR sky130_fd_sc_hd__diode_2
X_2976_ _0580_ _0607_ VGND VGND VPWR VPWR _0664_ sky130_fd_sc_hd__nor2_1
XFILLER_148_755 VGND VGND VPWR VPWR sky130_fd_sc_hd__fill_1
XANTENNA__2052__B1 B_reg\[5\] VGND VGND VPWR VPWR sky130_fd_sc_hd__diode_2
X_1927_ _1172_ _1180_ _1183_ VGND VGND VPWR VPWR _1192_ sky130_fd_sc_hd__o21a_1
XFILLER_135_405 VPWR VGND VPWR VGND sky130_ef_sc_hd__decap_12
X_1858_ A_reg\[9\] _1124_ _1125_ VGND VGND VPWR VPWR _1128_ sky130_fd_sc_hd__o21a_1
XFILLER_151_909 VGND VGND VPWR VPWR sky130_fd_sc_hd__fill_1
XFILLER_135_449 VPWR VGND VPWR VGND sky130_ef_sc_hd__decap_12
XTAP_TAPCELL_ROW_112_2117 VGND VPWR sky130_fd_sc_hd__tapvpwrvgnd_1
XTAP_TAPCELL_ROW_96_1872 VGND VPWR sky130_fd_sc_hd__tapvpwrvgnd_1
XTAP_TAPCELL_ROW_96_1861 VGND VPWR sky130_fd_sc_hd__tapvpwrvgnd_1
XFILLER_150_419 VGND VGND VPWR VPWR sky130_fd_sc_hd__fill_1
XTAP_TAPCELL_ROW_112_2128 VGND VPWR sky130_fd_sc_hd__tapvpwrvgnd_1
XFILLER_89_503 VGND VGND VPWR VPWR sky130_fd_sc_hd__fill_1
X_1789_ _1056_ _1061_ VGND VGND VPWR VPWR _1062_ sky130_fd_sc_hd__nor2_1
XANTENNA__3308__RESET_B net36 VGND VGND VPWR VPWR sky130_fd_sc_hd__diode_2
XFILLER_104_825 VPWR VGND VPWR VGND sky130_ef_sc_hd__decap_12
XFILLER_89_547 VPWR VGND VPWR VGND sky130_ef_sc_hd__decap_12
XFILLER_1_429 VPWR VGND VPWR VGND sky130_ef_sc_hd__decap_12
XFILLER_39_15 VPWR VGND VPWR VGND sky130_ef_sc_hd__decap_12
XFILLER_130_121 VPWR VGND VPWR VGND sky130_ef_sc_hd__decap_12
XFILLER_104_869 VPWR VGND VPWR VGND sky130_ef_sc_hd__decap_12
XFILLER_103_335 VGND VGND VPWR VPWR sky130_fd_sc_hd__fill_1
XFILLER_130_165 VPWR VGND VPWR VGND sky130_ef_sc_hd__decap_12
XFILLER_69_260 VPWR VGND VPWR VGND sky130_ef_sc_hd__decap_12
XFILLER_85_753 VPWR VGND VPWR VGND sky130_ef_sc_hd__decap_12
XFILLER_29_113 VPWR VGND VPWR VGND sky130_ef_sc_hd__decap_12
XTAP_TAPCELL_ROW_127_2371 VGND VPWR sky130_fd_sc_hd__tapvpwrvgnd_1
XTAP_TAPCELL_ROW_127_2360 VGND VPWR sky130_fd_sc_hd__tapvpwrvgnd_1
XFILLER_85_797 VPWR VGND VPWR VGND sky130_ef_sc_hd__decap_12
XFILLER_45_617 VGND VGND VPWR VPWR sky130_fd_sc_hd__fill_2
XFILLER_84_274 VPWR VGND VPWR VGND sky130_ef_sc_hd__decap_12
XFILLER_55_69 VGND VGND VPWR VPWR sky130_fd_sc_hd__decap_4
XTAP_TAPCELL_ROW_140_2571 VGND VPWR sky130_fd_sc_hd__tapvpwrvgnd_1
XFILLER_52_193 VGND VGND VPWR VPWR sky130_fd_sc_hd__decap_3
XFILLER_71_57 VPWR VGND VPWR VGND sky130_ef_sc_hd__decap_12
XFILLER_9_529 VPWR VGND VPWR VGND sky130_ef_sc_hd__decap_12
XFILLER_40_377 VGND VGND VPWR VPWR sky130_fd_sc_hd__decap_8
XFILLER_139_777 VGND VGND VPWR VPWR sky130_fd_sc_hd__decap_6
XFILLER_138_221 VPWR VGND VPWR VGND sky130_ef_sc_hd__decap_12
XFILLER_138_265 VPWR VGND VPWR VGND sky130_ef_sc_hd__decap_12
XFILLER_142_909 VGND VGND VPWR VPWR sky130_fd_sc_hd__fill_1
XFILLER_107_641 VPWR VGND VPWR VGND sky130_ef_sc_hd__decap_12
XFILLER_107_685 VPWR VGND VPWR VGND sky130_ef_sc_hd__decap_12
XFILLER_4_289 VGND VGND VPWR VPWR sky130_fd_sc_hd__decap_3
XFILLER_20_83 VGND VGND VPWR VPWR sky130_fd_sc_hd__fill_1
XFILLER_136_83 VGND VGND VPWR VPWR sky130_fd_sc_hd__fill_1
XFILLER_106_195 VGND VGND VPWR VPWR sky130_fd_sc_hd__fill_1
XFILLER_122_699 VGND VGND VPWR VPWR sky130_fd_sc_hd__fill_1
XFILLER_96_65 VPWR VGND VPWR VGND sky130_ef_sc_hd__decap_12
XANTENNA__2649__A2 a_r3\[0\] VGND VGND VPWR VPWR sky130_fd_sc_hd__diode_2
XFILLER_76_742 VPWR VGND VPWR VGND sky130_ef_sc_hd__decap_12
XFILLER_48_433 VGND VGND VPWR VPWR sky130_fd_sc_hd__decap_6
XFILLER_76_786 VPWR VGND VPWR VGND sky130_ef_sc_hd__decap_12
XFILLER_48_477 VPWR VGND VPWR VGND sky130_ef_sc_hd__decap_12
XFILLER_29_81 VPWR VGND VPWR VGND sky130_ef_sc_hd__decap_12
XFILLER_90_211 VGND VGND VPWR VPWR sky130_fd_sc_hd__decap_6
XFILLER_35_105 VGND VGND VPWR VPWR sky130_fd_sc_hd__decap_6
XANTENNA__3246__CLK clknet_3_6__leaf_clk VGND VGND VPWR VPWR sky130_fd_sc_hd__diode_2
XFILLER_51_609 VGND VGND VPWR VPWR sky130_fd_sc_hd__decap_6
XFILLER_17_853 VPWR VGND VPWR VGND sky130_ef_sc_hd__decap_12
XFILLER_35_149 VPWR VGND VPWR VGND sky130_ef_sc_hd__decap_12
XFILLER_16_363 VGND VGND VPWR VPWR sky130_fd_sc_hd__fill_1
XFILLER_17_897 VPWR VGND VPWR VGND sky130_ef_sc_hd__decap_12
XFILLER_32_834 VPWR VGND VPWR VGND sky130_ef_sc_hd__decap_12
XTAP_TAPCELL_ROW_63_1337 VGND VPWR sky130_fd_sc_hd__tapvpwrvgnd_1
X_2830_ net41 X_crt\[12\] _0553_ VGND VGND VPWR VPWR _0053_ sky130_fd_sc_hd__mux2_1
XTAP_TAPCELL_ROW_14_553 VGND VPWR sky130_fd_sc_hd__tapvpwrvgnd_1
X_2761_ _0469_ _0483_ _0493_ _0497_ VGND VGND VPWR VPWR _0501_ sky130_fd_sc_hd__a31o_1
XFILLER_12_591 VPWR VGND VPWR VGND sky130_ef_sc_hd__decap_12
XFILLER_117_405 VPWR VGND VPWR VGND sky130_ef_sc_hd__decap_12
X_2692_ _0384_ _0412_ _0429_ VGND VGND VPWR VPWR _0432_ sky130_fd_sc_hd__or3_1
X_1712_ _0895_ _0987_ VGND VGND VPWR VPWR _0988_ sky130_fd_sc_hd__nor2_1
XFILLER_133_909 VGND VGND VPWR VPWR sky130_fd_sc_hd__fill_1
XFILLER_117_449 VPWR VGND VPWR VGND sky130_ef_sc_hd__decap_12
X_1643_ _0916_ _0918_ A_reg\[12\] VGND VGND VPWR VPWR _0919_ sky130_fd_sc_hd__o21ai_2
XFILLER_6_41 VPWR VGND VPWR VGND sky130_ef_sc_hd__decap_12
XANTENNA_1 net13 VGND VGND VPWR VPWR sky130_fd_sc_hd__diode_2
XFILLER_132_419 VGND VGND VPWR VPWR sky130_fd_sc_hd__fill_1
XTAP_TAPCELL_ROW_78_1580 VGND VPWR sky130_fd_sc_hd__tapvpwrvgnd_1
XFILLER_6_85 VPWR VGND VPWR VGND sky130_ef_sc_hd__decap_12
XFILLER_112_121 VPWR VGND VPWR VGND sky130_ef_sc_hd__decap_12
XFILLER_99_889 VGND VGND VPWR VPWR sky130_fd_sc_hd__decap_6
X_3313_ clknet_3_7__leaf_clk _0096_ net36 VGND VGND VPWR VPWR X_crt\[7\] sky130_fd_sc_hd__dfrtp_1
XFILLER_112_165 VPWR VGND VPWR VGND sky130_ef_sc_hd__decap_12
XFILLER_101_839 VGND VGND VPWR VPWR sky130_fd_sc_hd__fill_1
XFILLER_98_377 VPWR VGND VPWR VGND sky130_ef_sc_hd__decap_12
XTAP_TAPCELL_ROW_91_1791 VGND VPWR sky130_fd_sc_hd__tapvpwrvgnd_1
XTAP_TAPCELL_ROW_91_1780 VGND VPWR sky130_fd_sc_hd__tapvpwrvgnd_1
XFILLER_86_528 VGND VGND VPWR VPWR sky130_fd_sc_hd__decap_4
XFILLER_67_720 VGND VGND VPWR VPWR sky130_fd_sc_hd__fill_2
X_3244_ clknet_3_6__leaf_clk _0029_ net36 VGND VGND VPWR VPWR u_crt.r1\[0\] sky130_fd_sc_hd__dfrtp_1
XANTENNA__2846__S _0383_ VGND VGND VPWR VPWR sky130_fd_sc_hd__diode_2
XFILLER_82_701 VGND VGND VPWR VPWR sky130_fd_sc_hd__decap_8
X_3175_ _0831_ _0860_ VGND VGND VPWR VPWR _0862_ sky130_fd_sc_hd__xnor2_1
XFILLER_27_617 VPWR VGND VPWR VGND sky130_ef_sc_hd__decap_12
X_2126_ B_reg\[6\] _1381_ _1382_ VGND VGND VPWR VPWR _1385_ sky130_fd_sc_hd__o21ai_1
XFILLER_67_797 VPWR VGND VPWR VGND sky130_ef_sc_hd__decap_12
XFILLER_39_499 VGND VGND VPWR VPWR sky130_fd_sc_hd__decap_4
X_2057_ _1300_ _1311_ VGND VGND VPWR VPWR _1319_ sky130_fd_sc_hd__nor2_1
XFILLER_22_300 VGND VGND VPWR VPWR sky130_fd_sc_hd__decap_8
XFILLER_25_39 VPWR VGND VPWR VGND sky130_ef_sc_hd__decap_12
XTAP_TAPCELL_ROW_122_2290 VGND VPWR sky130_fd_sc_hd__tapvpwrvgnd_1
XFILLER_22_333 VGND VGND VPWR VPWR sky130_fd_sc_hd__fill_1
XFILLER_22_355 VGND VGND VPWR VPWR sky130_fd_sc_hd__decap_8
XFILLER_22_377 VPWR VGND VPWR VGND sky130_ef_sc_hd__decap_12
XFILLER_23_889 VGND VGND VPWR VPWR sky130_fd_sc_hd__decap_6
XTAP_TAPCELL_ROW_33_862 VGND VPWR sky130_fd_sc_hd__tapvpwrvgnd_1
XTAP_TAPCELL_ROW_98_1901 VGND VPWR sky130_fd_sc_hd__tapvpwrvgnd_1
X_2959_ _0570_ _0574_ _0580_ VGND VGND VPWR VPWR _0647_ sky130_fd_sc_hd__a21oi_1
XFILLER_41_27 VPWR VGND VPWR VGND sky130_ef_sc_hd__decap_12
XFILLER_136_725 VPWR VGND VPWR VGND sky130_ef_sc_hd__decap_12
XFILLER_136_769 VPWR VGND VPWR VGND sky130_ef_sc_hd__decap_12
XFILLER_124_909 VGND VGND VPWR VPWR sky130_fd_sc_hd__fill_1
XFILLER_108_438 VPWR VGND VPWR VGND sky130_ef_sc_hd__decap_12
XFILLER_108_427 VGND VGND VPWR VPWR sky130_fd_sc_hd__decap_6
XANTENNA__1784__C1 A_reg\[6\] VGND VGND VPWR VPWR sky130_fd_sc_hd__diode_2
XFILLER_135_279 VGND VGND VPWR VPWR sky130_fd_sc_hd__fill_1
XFILLER_2_749 VGND VGND VPWR VPWR sky130_fd_sc_hd__decap_6
XFILLER_131_441 VGND VGND VPWR VPWR sky130_fd_sc_hd__decap_6
XTAP_TAPCELL_ROW_129_2400 VGND VPWR sky130_fd_sc_hd__tapvpwrvgnd_1
XFILLER_106_20 VGND VGND VPWR VPWR sky130_fd_sc_hd__decap_8
XFILLER_89_333 VGND VGND VPWR VPWR sky130_fd_sc_hd__decap_3
XFILLER_1_237 VPWR VGND VPWR VGND sky130_ef_sc_hd__decap_12
XFILLER_131_485 VPWR VGND VPWR VGND sky130_ef_sc_hd__decap_12
XFILLER_106_53 VPWR VGND VPWR VGND sky130_ef_sc_hd__decap_12
XFILLER_104_699 VGND VGND VPWR VPWR sky130_fd_sc_hd__fill_1
XFILLER_89_366 VGND VGND VPWR VPWR sky130_fd_sc_hd__fill_1
XFILLER_77_517 VPWR VGND VPWR VGND sky130_ef_sc_hd__decap_12
XFILLER_58_720 VPWR VGND VPWR VGND sky130_ef_sc_hd__decap_12
XTAP_TAPCELL_ROW_142_2611 VGND VPWR sky130_fd_sc_hd__tapvpwrvgnd_1
XTAP_TAPCELL_ROW_142_2600 VGND VPWR sky130_fd_sc_hd__tapvpwrvgnd_1
XFILLER_106_97 VPWR VGND VPWR VGND sky130_ef_sc_hd__decap_12
XFILLER_100_861 VGND VGND VPWR VPWR sky130_fd_sc_hd__decap_6
XFILLER_85_561 VPWR VGND VPWR VGND sky130_ef_sc_hd__decap_12
XANTENNA__3269__CLK clknet_3_5__leaf_clk VGND VGND VPWR VPWR sky130_fd_sc_hd__diode_2
XFILLER_122_41 VPWR VGND VPWR VGND sky130_ef_sc_hd__decap_12
XFILLER_17_105 VGND VGND VPWR VPWR sky130_fd_sc_hd__decap_6
XFILLER_72_233 VPWR VGND VPWR VGND sky130_ef_sc_hd__decap_12
XFILLER_17_149 VPWR VGND VPWR VGND sky130_ef_sc_hd__decap_12
XFILLER_45_447 VGND VGND VPWR VPWR sky130_fd_sc_hd__fill_1
XFILLER_45_469 VGND VGND VPWR VPWR sky130_fd_sc_hd__fill_2
XFILLER_122_85 VPWR VGND VPWR VGND sky130_ef_sc_hd__decap_12
XFILLER_13_300 VPWR VGND VPWR VGND sky130_ef_sc_hd__decap_12
XFILLER_14_867 VGND VGND VPWR VPWR sky130_fd_sc_hd__fill_1
XFILLER_25_193 VPWR VGND VPWR VGND sky130_ef_sc_hd__decap_12
XTAP_TAPCELL_ROW_45_1045 VGND VPWR sky130_fd_sc_hd__tapvpwrvgnd_1
XFILLER_13_344 VPWR VGND VPWR VGND sky130_ef_sc_hd__decap_12
XFILLER_40_141 VPWR VGND VPWR VGND sky130_ef_sc_hd__decap_12
XFILLER_41_653 VGND VGND VPWR VPWR sky130_fd_sc_hd__decap_8
XTAP_TAPCELL_ROW_45_1056 VGND VPWR sky130_fd_sc_hd__tapvpwrvgnd_1
XPHY_EDGE_ROW_149_Left_303 VGND VGND VPWR VPWR sky130_fd_sc_hd__decap_3
XFILLER_139_541 VPWR VGND VPWR VGND sky130_ef_sc_hd__decap_12
XTAP_TAPCELL_ROW_11_501 VGND VPWR sky130_fd_sc_hd__tapvpwrvgnd_1
XFILLER_9_337 VPWR VGND VPWR VGND sky130_ef_sc_hd__decap_12
XTAP_TAPCELL_ROW_11_512 VGND VPWR sky130_fd_sc_hd__tapvpwrvgnd_1
XFILLER_139_585 VPWR VGND VPWR VGND sky130_ef_sc_hd__decap_12
XTAP_TAPCELL_ROW_153_2773 VGND VPWR sky130_fd_sc_hd__tapvpwrvgnd_1
XTAP_TAPCELL_ROW_153_2795 VGND VPWR sky130_fd_sc_hd__tapvpwrvgnd_1
XTAP_TAPCELL_ROW_153_2784 VGND VPWR sky130_fd_sc_hd__tapvpwrvgnd_1
XFILLER_115_909 VGND VGND VPWR VPWR sky130_fd_sc_hd__fill_1
XFILLER_31_93 VPWR VGND VPWR VGND sky130_ef_sc_hd__decap_12
XFILLER_147_93 VPWR VGND VPWR VGND sky130_ef_sc_hd__decap_12
XFILLER_141_205 VPWR VGND VPWR VGND sky130_ef_sc_hd__decap_12
XPHY_EDGE_ROW_128_Right_128 VGND VGND VPWR VPWR sky130_fd_sc_hd__decap_3
XFILLER_114_419 VGND VGND VPWR VPWR sky130_fd_sc_hd__fill_1
XANTENNA__2520__A _0187_ VGND VGND VPWR VPWR sky130_fd_sc_hd__diode_2
XFILLER_141_249 VPWR VGND VPWR VGND sky130_ef_sc_hd__decap_12
XFILLER_110_625 VPWR VGND VPWR VGND sky130_ef_sc_hd__decap_12
XFILLER_96_837 VPWR VGND VPWR VGND sky130_ef_sc_hd__decap_12
XFILLER_95_314 VGND VGND VPWR VPWR sky130_fd_sc_hd__fill_2
XFILLER_0_281 VPWR VGND VPWR VGND sky130_ef_sc_hd__decap_12
XFILLER_110_669 VPWR VGND VPWR VGND sky130_ef_sc_hd__decap_12
XFILLER_64_701 VPWR VGND VPWR VGND sky130_ef_sc_hd__decap_12
XTAP_TAPCELL_ROW_19_634 VGND VPWR sky130_fd_sc_hd__tapvpwrvgnd_1
XFILLER_91_597 VPWR VGND VPWR VGND sky130_ef_sc_hd__decap_12
XFILLER_149_305 VPWR VGND VPWR VGND sky130_ef_sc_hd__decap_12
XFILLER_149_349 VPWR VGND VPWR VGND sky130_ef_sc_hd__decap_12
X_2813_ u_crt.r3\[2\] _0910_ _0184_ _0550_ VGND VGND VPWR VPWR _0039_ sky130_fd_sc_hd__a22o_1
XFILLER_20_837 VPWR VGND VPWR VGND sky130_ef_sc_hd__decap_12
XTAP_TAPCELL_ROW_30_810 VGND VPWR sky130_fd_sc_hd__tapvpwrvgnd_1
XFILLER_118_725 VPWR VGND VPWR VGND sky130_ef_sc_hd__decap_12
X_2744_ _0469_ _0482_ _0187_ VGND VGND VPWR VPWR _0484_ sky130_fd_sc_hd__o21ai_1
XFILLER_118_769 VPWR VGND VPWR VGND sky130_ef_sc_hd__decap_12
XFILLER_106_909 VGND VGND VPWR VPWR sky130_fd_sc_hd__fill_1
XTAP_TAPCELL_ROW_93_1820 VGND VPWR sky130_fd_sc_hd__tapvpwrvgnd_1
X_2675_ b_r3\[0\] a_r3\[1\] b_r3\[1\] a_r3\[0\] VGND VGND VPWR VPWR _0415_ sky130_fd_sc_hd__a22oi_1
XFILLER_117_279 VGND VGND VPWR VPWR sky130_fd_sc_hd__fill_1
X_1626_ B_reg\[4\] VGND VGND VPWR VPWR _0906_ sky130_fd_sc_hd__inv_2
XFILLER_113_441 VGND VGND VPWR VPWR sky130_fd_sc_hd__decap_6
XFILLER_99_653 VPWR VGND VPWR VGND sky130_ef_sc_hd__decap_12
XFILLER_141_783 VGND VGND VPWR VPWR sky130_fd_sc_hd__fill_1
XANTENNA__2730__A1 a_r3\[3\] VGND VGND VPWR VPWR sky130_fd_sc_hd__diode_2
XFILLER_99_697 VPWR VGND VPWR VGND sky130_ef_sc_hd__decap_12
XFILLER_98_141 VPWR VGND VPWR VGND sky130_ef_sc_hd__decap_12
XFILLER_59_517 VPWR VGND VPWR VGND sky130_ef_sc_hd__decap_12
XFILLER_113_485 VPWR VGND VPWR VGND sky130_ef_sc_hd__decap_12
XFILLER_86_347 VPWR VGND VPWR VGND sky130_ef_sc_hd__decap_12
XFILLER_67_561 VPWR VGND VPWR VGND sky130_ef_sc_hd__decap_12
X_3227_ clknet_3_3__leaf_clk _0014_ net36 VGND VGND VPWR VPWR b_r1\[0\] sky130_fd_sc_hd__dfrtp_4
XTAP_TAPCELL_ROW_107_2049 VGND VPWR sky130_fd_sc_hd__tapvpwrvgnd_1
XTAP_TAPCELL_ROW_107_2038 VGND VPWR sky130_fd_sc_hd__tapvpwrvgnd_1
XFILLER_55_712 VGND VGND VPWR VPWR sky130_fd_sc_hd__decap_8
XFILLER_36_27 VGND VGND VPWR VPWR sky130_fd_sc_hd__fill_1
XTAP_TAPCELL_ROW_38_932 VGND VPWR sky130_fd_sc_hd__tapvpwrvgnd_1
X_3158_ _0837_ _0843_ _0844_ VGND VGND VPWR VPWR _0846_ sky130_fd_sc_hd__and3_1
XFILLER_82_531 VGND VGND VPWR VPWR sky130_fd_sc_hd__fill_1
X_2109_ _1366_ _1367_ B_reg\[10\] VGND VGND VPWR VPWR _1368_ sky130_fd_sc_hd__o21ai_1
XFILLER_54_233 VGND VGND VPWR VPWR sky130_fd_sc_hd__decap_8
XFILLER_15_609 VGND VGND VPWR VPWR sky130_fd_sc_hd__decap_6
XFILLER_27_436 VGND VGND VPWR VPWR sky130_fd_sc_hd__decap_8
XTAP_TAPCELL_ROW_38_943 VGND VPWR sky130_fd_sc_hd__tapvpwrvgnd_1
XFILLER_82_575 VPWR VGND VPWR VGND sky130_ef_sc_hd__decap_12
XFILLER_70_737 VGND VGND VPWR VPWR sky130_fd_sc_hd__fill_2
X_3089_ _0746_ _0776_ VGND VGND VPWR VPWR _0777_ sky130_fd_sc_hd__xnor2_2
XTAP_TAPCELL_ROW_120_2249 VGND VPWR sky130_fd_sc_hd__tapvpwrvgnd_1
XFILLER_70_748 VGND VGND VPWR VPWR sky130_fd_sc_hd__decap_8
XFILLER_52_15 VGND VGND VPWR VPWR sky130_fd_sc_hd__fill_2
XFILLER_22_141 VPWR VGND VPWR VGND sky130_ef_sc_hd__decap_12
XFILLER_23_653 VPWR VGND VPWR VGND sky130_ef_sc_hd__decap_12
XTAP_TAPCELL_ROW_102_1971 VGND VPWR sky130_fd_sc_hd__tapvpwrvgnd_1
XTAP_TAPCELL_ROW_102_1960 VGND VPWR sky130_fd_sc_hd__tapvpwrvgnd_1
XFILLER_23_697 VPWR VGND VPWR VGND sky130_ef_sc_hd__decap_12
XFILLER_136_533 VPWR VGND VPWR VGND sky130_ef_sc_hd__decap_12
XFILLER_151_503 VGND VGND VPWR VPWR sky130_fd_sc_hd__fill_1
XTAP_TAPCELL_ROW_135_2492 VGND VPWR sky130_fd_sc_hd__tapvpwrvgnd_1
XFILLER_123_205 VPWR VGND VPWR VGND sky130_ef_sc_hd__decap_12
XFILLER_123_249 VPWR VGND VPWR VGND sky130_ef_sc_hd__decap_12
XFILLER_2_535 VGND VGND VPWR VPWR sky130_fd_sc_hd__fill_1
XFILLER_78_837 VPWR VGND VPWR VGND sky130_ef_sc_hd__decap_12
XFILLER_77_303 VGND VGND VPWR VPWR sky130_fd_sc_hd__fill_1
XFILLER_131_293 VPWR VGND VPWR VGND sky130_ef_sc_hd__decap_12
XFILLER_46_701 VPWR VGND VPWR VGND sky130_ef_sc_hd__decap_12
XFILLER_133_51 VGND VGND VPWR VPWR sky130_fd_sc_hd__decap_4
XFILLER_92_339 VGND VGND VPWR VPWR sky130_fd_sc_hd__fill_1
XFILLER_86_881 VPWR VGND VPWR VGND sky130_ef_sc_hd__decap_12
XFILLER_85_391 VGND VGND VPWR VPWR sky130_fd_sc_hd__fill_1
XFILLER_73_553 VGND VGND VPWR VPWR sky130_fd_sc_hd__decap_6
XFILLER_46_789 VGND VGND VPWR VPWR sky130_fd_sc_hd__fill_1
XFILLER_33_417 VPWR VGND VPWR VGND sky130_ef_sc_hd__decap_12
XFILLER_73_597 VPWR VGND VPWR VGND sky130_ef_sc_hd__decap_12
XFILLER_147_809 VPWR VGND VPWR VGND sky130_ef_sc_hd__decap_12
XFILLER_41_461 VPWR VGND VPWR VGND sky130_ef_sc_hd__decap_12
XFILLER_9_167 VGND VGND VPWR VPWR sky130_fd_sc_hd__fill_1
XFILLER_139_393 VPWR VGND VPWR VGND sky130_ef_sc_hd__decap_12
XFILLER_10_881 VPWR VGND VPWR VGND sky130_ef_sc_hd__decap_12
XFILLER_142_525 VGND VGND VPWR VPWR sky130_fd_sc_hd__decap_6
X_2460_ OpSel_reg\[0\] _0194_ _0207_ _0209_ VGND VGND VPWR VPWR _0210_ sky130_fd_sc_hd__a31o_1
XTAP_TAPCELL_ROW_58_1258 VGND VPWR sky130_fd_sc_hd__tapvpwrvgnd_1
XFILLER_142_569 VPWR VGND VPWR VGND sky130_ef_sc_hd__decap_12
XFILLER_123_783 VGND VGND VPWR VPWR sky130_fd_sc_hd__fill_1
X_2391_ _0143_ _0144_ VGND VGND VPWR VPWR _0145_ sky130_fd_sc_hd__nor2_1
XFILLER_96_601 VPWR VGND VPWR VGND sky130_ef_sc_hd__decap_12
XFILLER_110_433 VPWR VGND VPWR VGND sky130_ef_sc_hd__decap_12
XFILLER_96_645 VPWR VGND VPWR VGND sky130_ef_sc_hd__decap_12
XFILLER_95_111 VGND VGND VPWR VPWR sky130_fd_sc_hd__fill_1
XTAP_TAPCELL_ROW_71_1469 VGND VPWR sky130_fd_sc_hd__tapvpwrvgnd_1
XFILLER_68_336 VGND VGND VPWR VPWR sky130_fd_sc_hd__decap_8
XFILLER_83_339 VGND VGND VPWR VPWR sky130_fd_sc_hd__fill_1
XFILLER_83_328 VGND VGND VPWR VPWR sky130_fd_sc_hd__fill_1
X_3012_ _0570_ _0579_ VGND VGND VPWR VPWR _0700_ sky130_fd_sc_hd__or2_1
XFILLER_64_564 VPWR VGND VPWR VGND sky130_ef_sc_hd__decap_12
XFILLER_24_417 VGND VGND VPWR VPWR sky130_fd_sc_hd__decap_3
XFILLER_36_277 VPWR VGND VPWR VGND sky130_ef_sc_hd__decap_12
XFILLER_52_737 VGND VGND VPWR VPWR sky130_fd_sc_hd__decap_4
XFILLER_51_225 VPWR VGND VPWR VGND sky130_ef_sc_hd__decap_12
XFILLER_149_113 VPWR VGND VPWR VGND sky130_ef_sc_hd__decap_12
XFILLER_60_781 VPWR VGND VPWR VGND sky130_ef_sc_hd__decap_12
XFILLER_20_601 VPWR VGND VPWR VGND sky130_ef_sc_hd__decap_12
XFILLER_20_645 VPWR VGND VPWR VGND sky130_ef_sc_hd__decap_12
XFILLER_22_29 VPWR VGND VPWR VGND sky130_ef_sc_hd__decap_12
XFILLER_138_29 VPWR VGND VPWR VGND sky130_ef_sc_hd__decap_12
XFILLER_118_533 VPWR VGND VPWR VGND sky130_ef_sc_hd__decap_12
X_2727_ _0465_ _0466_ VGND VGND VPWR VPWR _0467_ sky130_fd_sc_hd__nor2_1
XFILLER_145_385 VGND VGND VPWR VPWR sky130_fd_sc_hd__decap_6
XFILLER_133_503 VGND VGND VPWR VPWR sky130_fd_sc_hd__fill_1
XFILLER_105_205 VPWR VGND VPWR VGND sky130_ef_sc_hd__decap_12
XANTENNA__2160__A A_reg\[11\] VGND VGND VPWR VPWR sky130_fd_sc_hd__diode_2
XFILLER_121_709 VPWR VGND VPWR VGND sky130_ef_sc_hd__decap_12
XFILLER_105_249 VPWR VGND VPWR VGND sky130_ef_sc_hd__decap_12
X_2658_ _0393_ _0397_ VGND VGND VPWR VPWR _0398_ sky130_fd_sc_hd__and2b_1
XFILLER_99_461 VPWR VGND VPWR VGND sky130_ef_sc_hd__decap_12
X_2589_ b_r2\[1\] _0327_ _0331_ VGND VGND VPWR VPWR _0334_ sky130_fd_sc_hd__nand3_1
X_1609_ A_reg\[10\] VGND VGND VPWR VPWR _0889_ sky130_fd_sc_hd__inv_2
XFILLER_86_100 VPWR VGND VPWR VGND sky130_ef_sc_hd__decap_12
XFILLER_113_293 VPWR VGND VPWR VGND sky130_ef_sc_hd__decap_12
XFILLER_101_455 VPWR VGND VPWR VGND sky130_ef_sc_hd__decap_12
XANTENNA_input1_A A_in[0] VGND VGND VPWR VPWR sky130_fd_sc_hd__diode_2
XFILLER_47_15 VPWR VGND VPWR VGND sky130_ef_sc_hd__decap_12
XFILLER_68_881 VPWR VGND VPWR VGND sky130_ef_sc_hd__decap_12
XFILLER_28_701 VPWR VGND VPWR VGND sky130_ef_sc_hd__decap_12
XANTENNA__2467__B1 _0910_ VGND VGND VPWR VPWR sky130_fd_sc_hd__diode_2
XTAP_TAPCELL_ROW_2_365 VGND VPWR sky130_fd_sc_hd__tapvpwrvgnd_1
XFILLER_83_895 VGND VGND VPWR VPWR sky130_fd_sc_hd__fill_1
XFILLER_15_417 VPWR VGND VPWR VGND sky130_ef_sc_hd__decap_12
XFILLER_27_266 VGND VGND VPWR VPWR sky130_fd_sc_hd__decap_3
XFILLER_82_394 VPWR VGND VPWR VGND sky130_ef_sc_hd__decap_12
XANTENNA__3307__CLK clknet_3_7__leaf_clk VGND VGND VPWR VPWR sky130_fd_sc_hd__diode_2
XFILLER_63_69 VGND VGND VPWR VPWR sky130_fd_sc_hd__decap_6
XFILLER_129_809 VPWR VGND VPWR VGND sky130_ef_sc_hd__decap_12
XFILLER_70_589 VPWR VGND VPWR VGND sky130_ef_sc_hd__decap_12
XFILLER_11_601 VPWR VGND VPWR VGND sky130_ef_sc_hd__decap_12
XFILLER_23_461 VPWR VGND VPWR VGND sky130_ef_sc_hd__decap_12
XTAP_TAPCELL_ROW_42_1004 VGND VPWR sky130_fd_sc_hd__tapvpwrvgnd_1
XTAP_TAPCELL_ROW_137_2521 VGND VPWR sky130_fd_sc_hd__tapvpwrvgnd_1
XFILLER_137_3 VPWR VGND VPWR VGND sky130_ef_sc_hd__decap_12
XFILLER_10_133 VGND VGND VPWR VPWR sky130_fd_sc_hd__decap_6
XFILLER_10_177 VPWR VGND VPWR VGND sky130_ef_sc_hd__decap_12
XTAP_TAPCELL_ROW_21_662 VGND VPWR sky130_fd_sc_hd__tapvpwrvgnd_1
XTAP_TAPCELL_ROW_21_673 VGND VPWR sky130_fd_sc_hd__tapvpwrvgnd_1
XFILLER_137_853 VPWR VGND VPWR VGND sky130_ef_sc_hd__decap_12
XANTENNA__1893__B _0911_ VGND VGND VPWR VPWR sky130_fd_sc_hd__diode_2
XTAP_TAPCELL_ROW_150_2732 VGND VPWR sky130_fd_sc_hd__tapvpwrvgnd_1
XFILLER_137_897 VPWR VGND VPWR VGND sky130_ef_sc_hd__decap_12
XFILLER_136_363 VGND VGND VPWR VPWR sky130_fd_sc_hd__fill_1
XFILLER_124_525 VGND VGND VPWR VPWR sky130_fd_sc_hd__decap_6
XANTENNA__2070__A B_reg\[3\] VGND VGND VPWR VPWR sky130_fd_sc_hd__diode_2
XFILLER_152_867 VGND VGND VPWR VPWR sky130_fd_sc_hd__fill_1
XFILLER_3_833 VGND VGND VPWR VPWR sky130_fd_sc_hd__decap_6
XFILLER_2_321 VPWR VGND VPWR VGND sky130_ef_sc_hd__decap_12
XFILLER_124_569 VPWR VGND VPWR VGND sky130_ef_sc_hd__decap_12
XFILLER_3_877 VPWR VGND VPWR VGND sky130_ef_sc_hd__decap_12
XFILLER_105_783 VGND VGND VPWR VPWR sky130_fd_sc_hd__fill_1
XFILLER_78_645 VGND VGND VPWR VPWR sky130_fd_sc_hd__decap_4
XFILLER_78_634 VGND VGND VPWR VPWR sky130_fd_sc_hd__decap_8
XFILLER_144_83 VGND VGND VPWR VPWR sky130_fd_sc_hd__fill_1
XTAP_TAPCELL_ROW_53_1177 VGND VPWR sky130_fd_sc_hd__tapvpwrvgnd_1
XTAP_TAPCELL_ROW_148_2694 VGND VPWR sky130_fd_sc_hd__tapvpwrvgnd_1
XFILLER_77_166 VGND VGND VPWR VPWR sky130_fd_sc_hd__fill_2
XANTENNA__2458__B1 OpSel_reg\[0\] VGND VGND VPWR VPWR sky130_fd_sc_hd__diode_2
XANTENNA_input12_X net12 VGND VGND VPWR VPWR sky130_fd_sc_hd__diode_2
XFILLER_46_531 VGND VGND VPWR VPWR sky130_fd_sc_hd__fill_1
XFILLER_18_233 VPWR VGND VPWR VGND sky130_ef_sc_hd__decap_12
XFILLER_80_309 VPWR VGND VPWR VGND sky130_ef_sc_hd__decap_12
XFILLER_18_277 VPWR VGND VPWR VGND sky130_ef_sc_hd__decap_12
XFILLER_37_81 VPWR VGND VPWR VGND sky130_ef_sc_hd__decap_12
XTAP_TAPCELL_ROW_29_795 VGND VPWR sky130_fd_sc_hd__tapvpwrvgnd_1
XFILLER_33_225 VPWR VGND VPWR VGND sky130_ef_sc_hd__decap_12
XFILLER_34_737 VPWR VGND VPWR VGND sky130_ef_sc_hd__decap_12
XANTENNA__3245__RESET_B net36 VGND VGND VPWR VPWR sky130_fd_sc_hd__diode_2
XANTENNA_clkbuf_3_7__f_clk_X clknet_3_7__leaf_clk VGND VGND VPWR VPWR sky130_fd_sc_hd__diode_2
X_1960_ _1222_ _1224_ B_reg\[4\] VGND VGND VPWR VPWR _1225_ sky130_fd_sc_hd__o21ai_1
XFILLER_14_461 VPWR VGND VPWR VGND sky130_ef_sc_hd__decap_12
XFILLER_42_792 VGND VGND VPWR VPWR sky130_fd_sc_hd__fill_1
XFILLER_147_617 VPWR VGND VPWR VGND sky130_ef_sc_hd__decap_12
X_1891_ _1156_ _1158_ _1157_ VGND VGND VPWR VPWR _1160_ sky130_fd_sc_hd__o21a_1
XTAP_TAPCELL_ROW_40_971 VGND VPWR sky130_fd_sc_hd__tapvpwrvgnd_1
XFILLER_127_385 VGND VGND VPWR VPWR sky130_fd_sc_hd__decap_6
XFILLER_115_503 VGND VGND VPWR VPWR sky130_fd_sc_hd__fill_1
XFILLER_52_3 VPWR VGND VPWR VGND sky130_ef_sc_hd__decap_12
X_2512_ a_r1\[1\] b_r1\[2\] b_r1\[1\] a_r1\[2\] VGND VGND VPWR VPWR _0260_ sky130_fd_sc_hd__a22o_1
XFILLER_142_333 VPWR VGND VPWR VGND sky130_ef_sc_hd__decap_12
XFILLER_5_181 VPWR VGND VPWR VGND sky130_ef_sc_hd__decap_12
XFILLER_143_889 VGND VGND VPWR VPWR sky130_fd_sc_hd__decap_6
XFILLER_142_377 VPWR VGND VPWR VGND sky130_ef_sc_hd__decap_12
XFILLER_103_709 VPWR VGND VPWR VGND sky130_ef_sc_hd__decap_12
X_2443_ a_r0\[0\] a_r0\[1\] VGND VGND VPWR VPWR _0193_ sky130_fd_sc_hd__nand2_1
XFILLER_69_601 VGND VGND VPWR VPWR sky130_fd_sc_hd__fill_1
X_2374_ _0119_ _0122_ _0113_ VGND VGND VPWR VPWR _0128_ sky130_fd_sc_hd__o21ai_1
XFILLER_111_753 VPWR VGND VPWR VGND sky130_ef_sc_hd__decap_12
XFILLER_111_797 VPWR VGND VPWR VGND sky130_ef_sc_hd__decap_12
XFILLER_96_475 VGND VGND VPWR VPWR sky130_fd_sc_hd__fill_1
XFILLER_68_177 VGND VGND VPWR VPWR sky130_fd_sc_hd__decap_6
XFILLER_57_829 VGND VGND VPWR VPWR sky130_fd_sc_hd__decap_4
XTAP_TAPCELL_ROW_88_1741 VGND VPWR sky130_fd_sc_hd__tapvpwrvgnd_1
XFILLER_83_125 VPWR VGND VPWR VGND sky130_ef_sc_hd__decap_12
XFILLER_83_169 VGND VGND VPWR VPWR sky130_fd_sc_hd__decap_4
XANTENNA__2854__S _0383_ VGND VGND VPWR VPWR sky130_fd_sc_hd__diode_2
XFILLER_64_361 VGND VGND VPWR VPWR sky130_fd_sc_hd__decap_3
XFILLER_64_350 VGND VGND VPWR VPWR sky130_fd_sc_hd__fill_1
XFILLER_37_575 VPWR VGND VPWR VGND sky130_ef_sc_hd__decap_12
XFILLER_92_681 VPWR VGND VPWR VGND sky130_ef_sc_hd__decap_12
XFILLER_65_895 VGND VGND VPWR VPWR sky130_fd_sc_hd__fill_1
XFILLER_52_545 VGND VGND VPWR VPWR sky130_fd_sc_hd__decap_8
XFILLER_52_589 VPWR VGND VPWR VGND sky130_ef_sc_hd__decap_12
XFILLER_33_39 VPWR VGND VPWR VGND sky130_ef_sc_hd__decap_12
XFILLER_40_729 VGND VGND VPWR VPWR sky130_fd_sc_hd__fill_1
XFILLER_149_39 VPWR VGND VPWR VGND sky130_ef_sc_hd__decap_12
XFILLER_137_105 VGND VGND VPWR VPWR sky130_fd_sc_hd__decap_6
XTAP_TAPCELL_ROW_119_2240 VGND VPWR sky130_fd_sc_hd__tapvpwrvgnd_1
XFILLER_137_149 VPWR VGND VPWR VGND sky130_ef_sc_hd__decap_12
XFILLER_119_853 VPWR VGND VPWR VGND sky130_ef_sc_hd__decap_12
XPHY_EDGE_ROW_104_Left_258 VGND VGND VPWR VPWR sky130_fd_sc_hd__decap_3
XTAP_TAPCELL_ROW_132_2440 VGND VPWR sky130_fd_sc_hd__tapvpwrvgnd_1
XFILLER_119_897 VPWR VGND VPWR VGND sky130_ef_sc_hd__decap_12
XFILLER_118_363 VGND VGND VPWR VPWR sky130_fd_sc_hd__fill_1
XFILLER_106_525 VGND VGND VPWR VPWR sky130_fd_sc_hd__decap_6
XANTENNA__1727__A2 _0911_ VGND VGND VPWR VPWR sky130_fd_sc_hd__diode_2
XFILLER_4_608 VPWR VGND VPWR VGND sky130_ef_sc_hd__decap_12
XFILLER_145_193 VPWR VGND VPWR VGND sky130_ef_sc_hd__decap_12
XFILLER_134_867 VGND VGND VPWR VPWR sky130_fd_sc_hd__fill_1
XTAP_TAPCELL_ROW_132_2451 VGND VPWR sky130_fd_sc_hd__tapvpwrvgnd_1
XFILLER_121_517 VPWR VGND VPWR VGND sky130_ef_sc_hd__decap_12
XFILLER_59_111 VGND VGND VPWR VPWR sky130_fd_sc_hd__fill_1
XTAP_TAPCELL_ROW_7_446 VGND VPWR sky130_fd_sc_hd__tapvpwrvgnd_1
XFILLER_0_825 VPWR VGND VPWR VGND sky130_ef_sc_hd__decap_12
XFILLER_99_291 VPWR VGND VPWR VGND sky130_ef_sc_hd__decap_12
XFILLER_58_58 VPWR VGND VPWR VGND sky130_ef_sc_hd__decap_12
XFILLER_0_869 VPWR VGND VPWR VGND sky130_ef_sc_hd__decap_12
XANTENNA__2152__A2 A_reg\[13\] VGND VGND VPWR VPWR sky130_fd_sc_hd__diode_2
XFILLER_87_497 VGND VGND VPWR VPWR sky130_fd_sc_hd__decap_6
XFILLER_59_188 VPWR VGND VPWR VGND sky130_ef_sc_hd__decap_12
XFILLER_47_317 VPWR VGND VPWR VGND sky130_ef_sc_hd__decap_12
XFILLER_114_53 VPWR VGND VPWR VGND sky130_ef_sc_hd__decap_12
XPHY_EDGE_ROW_113_Left_267 VGND VGND VPWR VPWR sky130_fd_sc_hd__decap_3
XFILLER_28_531 VGND VGND VPWR VPWR sky130_fd_sc_hd__fill_1
XFILLER_114_97 VPWR VGND VPWR VGND sky130_ef_sc_hd__decap_12
XFILLER_71_821 VPWR VGND VPWR VGND sky130_ef_sc_hd__decap_12
XFILLER_15_225 VGND VGND VPWR VPWR sky130_fd_sc_hd__decap_8
XFILLER_16_737 VPWR VGND VPWR VGND sky130_ef_sc_hd__decap_12
XFILLER_130_41 VPWR VGND VPWR VGND sky130_ef_sc_hd__decap_12
XANTENNA__2065__A B_reg\[3\] VGND VGND VPWR VPWR sky130_fd_sc_hd__diode_2
XFILLER_71_865 VPWR VGND VPWR VGND sky130_ef_sc_hd__decap_12
XTAP_TAPCELL_ROW_26_743 VGND VPWR sky130_fd_sc_hd__tapvpwrvgnd_1
XTAP_TAPCELL_ROW_26_754 VGND VPWR sky130_fd_sc_hd__tapvpwrvgnd_1
XFILLER_130_85 VPWR VGND VPWR VGND sky130_ef_sc_hd__decap_12
XFILLER_90_34 VPWR VGND VPWR VGND sky130_ef_sc_hd__decap_12
XFILLER_24_781 VPWR VGND VPWR VGND sky130_ef_sc_hd__decap_12
XFILLER_30_217 VGND VGND VPWR VPWR sky130_fd_sc_hd__fill_1
XFILLER_31_729 VPWR VGND VPWR VGND sky130_ef_sc_hd__decap_12
XFILLER_129_617 VPWR VGND VPWR VGND sky130_ef_sc_hd__decap_12
XFILLER_11_442 VGND VGND VPWR VPWR sky130_fd_sc_hd__decap_6
XPHY_EDGE_ROW_122_Left_276 VGND VGND VPWR VPWR sky130_fd_sc_hd__decap_3
XANTENNA__2915__A1 _0554_ VGND VGND VPWR VPWR sky130_fd_sc_hd__diode_2
XFILLER_124_333 VPWR VGND VPWR VGND sky130_ef_sc_hd__decap_12
XFILLER_109_385 VGND VGND VPWR VPWR sky130_fd_sc_hd__decap_6
XTAP_TAPCELL_ROW_55_1206 VGND VPWR sky130_fd_sc_hd__tapvpwrvgnd_1
XFILLER_125_889 VGND VGND VPWR VPWR sky130_fd_sc_hd__decap_6
XFILLER_124_377 VPWR VGND VPWR VGND sky130_ef_sc_hd__decap_12
XFILLER_112_517 VPWR VGND VPWR VGND sky130_ef_sc_hd__decap_12
XTAP_TAPCELL_ROW_55_1217 VGND VPWR sky130_fd_sc_hd__tapvpwrvgnd_1
XFILLER_3_663 VGND VGND VPWR VPWR sky130_fd_sc_hd__decap_8
XFILLER_140_837 VPWR VGND VPWR VGND sky130_ef_sc_hd__decap_12
XFILLER_3_685 VPWR VGND VPWR VGND sky130_ef_sc_hd__decap_12
XFILLER_2_195 VGND VGND VPWR VPWR sky130_fd_sc_hd__fill_1
XPHY_EDGE_ROW_131_Left_285 VGND VGND VPWR VPWR sky130_fd_sc_hd__decap_3
XFILLER_78_475 VGND VGND VPWR VPWR sky130_fd_sc_hd__fill_1
XFILLER_66_637 VGND VGND VPWR VPWR sky130_fd_sc_hd__decap_6
XFILLER_65_103 VGND VGND VPWR VPWR sky130_fd_sc_hd__decap_8
X_2090_ _1350_ _1351_ b_r1\[0\] Encode_EN VGND VGND VPWR VPWR _0014_ sky130_fd_sc_hd__o2bb2a_1
XFILLER_93_489 VGND VGND VPWR VPWR sky130_fd_sc_hd__fill_1
XFILLER_81_629 VPWR VGND VPWR VGND sky130_ef_sc_hd__decap_12
XFILLER_65_169 VPWR VGND VPWR VGND sky130_ef_sc_hd__decap_12
XFILLER_19_553 VGND VGND VPWR VPWR sky130_fd_sc_hd__decap_6
XANTENNA__1654__A1 A_reg\[11\] VGND VGND VPWR VPWR sky130_fd_sc_hd__diode_2
XFILLER_19_597 VPWR VGND VPWR VGND sky130_ef_sc_hd__decap_12
XTAP_TAPCELL_ROW_83_1660 VGND VPWR sky130_fd_sc_hd__tapvpwrvgnd_1
X_2992_ _0677_ _0678_ VGND VGND VPWR VPWR _0680_ sky130_fd_sc_hd__xnor2_1
XFILLER_21_217 VGND VGND VPWR VPWR sky130_fd_sc_hd__decap_6
XFILLER_34_589 VPWR VGND VPWR VGND sky130_ef_sc_hd__decap_12
XPHY_EDGE_ROW_140_Left_294 VGND VGND VPWR VPWR sky130_fd_sc_hd__decap_3
X_1943_ _1207_ VGND VGND VPWR VPWR _1208_ sky130_fd_sc_hd__inv_2
XFILLER_119_105 VGND VGND VPWR VPWR sky130_fd_sc_hd__decap_6
XFILLER_147_447 VGND VGND VPWR VPWR sky130_fd_sc_hd__fill_1
XFILLER_135_609 VGND VGND VPWR VPWR sky130_fd_sc_hd__decap_6
XFILLER_119_149 VPWR VGND VPWR VGND sky130_ef_sc_hd__decap_12
X_1874_ _1140_ _1143_ A_reg\[4\] VGND VGND VPWR VPWR _1144_ sky130_fd_sc_hd__o21ai_1
XFILLER_127_193 VPWR VGND VPWR VGND sky130_ef_sc_hd__decap_12
XFILLER_143_653 VPWR VGND VPWR VGND sky130_ef_sc_hd__decap_12
XFILLER_142_141 VPWR VGND VPWR VGND sky130_ef_sc_hd__decap_12
XFILLER_116_867 VGND VGND VPWR VPWR sky130_fd_sc_hd__fill_1
XFILLER_103_517 VPWR VGND VPWR VGND sky130_ef_sc_hd__decap_12
XFILLER_89_729 VPWR VGND VPWR VGND sky130_ef_sc_hd__decap_12
XANTENNA__2849__S _0383_ VGND VGND VPWR VPWR sky130_fd_sc_hd__diode_2
XFILLER_143_697 VPWR VGND VPWR VGND sky130_ef_sc_hd__decap_12
X_2426_ _0168_ _0177_ VGND VGND VPWR VPWR _0179_ sky130_fd_sc_hd__xnor2_1
XTAP_TAPCELL_ROW_110_2089 VGND VPWR sky130_fd_sc_hd__tapvpwrvgnd_1
XFILLER_111_561 VPWR VGND VPWR VGND sky130_ef_sc_hd__decap_12
XFILLER_111_550 VGND VGND VPWR VPWR sky130_fd_sc_hd__decap_8
XFILLER_84_401 VPWR VGND VPWR VGND sky130_ef_sc_hd__decap_12
X_2357_ _1597_ _0110_ _1600_ VGND VGND VPWR VPWR _0111_ sky130_fd_sc_hd__a21bo_1
XFILLER_57_604 VPWR VGND VPWR VGND sky130_ef_sc_hd__decap_12
XFILLER_84_445 VPWR VGND VPWR VGND sky130_ef_sc_hd__decap_12
XFILLER_69_497 VGND VGND VPWR VPWR sky130_fd_sc_hd__decap_6
X_2288_ _1531_ _1542_ VGND VGND VPWR VPWR _1544_ sky130_fd_sc_hd__xnor2_1
XANTENNA__2437__X _0187_ VGND VGND VPWR VPWR sky130_fd_sc_hd__diode_2
XFILLER_84_489 VPWR VGND VPWR VGND sky130_ef_sc_hd__decap_12
XFILLER_44_309 VPWR VGND VPWR VGND sky130_ef_sc_hd__decap_12
XFILLER_53_821 VPWR VGND VPWR VGND sky130_ef_sc_hd__decap_12
XFILLER_53_865 VGND VGND VPWR VPWR sky130_fd_sc_hd__decap_8
XFILLER_44_27 VGND VGND VPWR VPWR sky130_fd_sc_hd__fill_1
XFILLER_13_729 VPWR VGND VPWR VGND sky130_ef_sc_hd__decap_12
XTAP_TAPCELL_ROW_23_702 VGND VPWR sky130_fd_sc_hd__tapvpwrvgnd_1
XFILLER_40_526 VGND VGND VPWR VPWR sky130_fd_sc_hd__decap_6
XFILLER_100_77 VGND VGND VPWR VPWR sky130_fd_sc_hd__decap_6
XFILLER_138_469 VGND VGND VPWR VPWR sky130_fd_sc_hd__decap_6
XFILLER_153_417 VGND VGND VPWR VPWR sky130_fd_sc_hd__decap_3
XFILLER_4_416 VGND VGND VPWR VPWR sky130_fd_sc_hd__decap_4
XFILLER_106_333 VPWR VGND VPWR VGND sky130_ef_sc_hd__decap_12
XFILLER_107_889 VGND VGND VPWR VPWR sky130_fd_sc_hd__decap_6
XFILLER_69_57 VPWR VGND VPWR VGND sky130_ef_sc_hd__decap_12
XFILLER_69_46 VGND VGND VPWR VPWR sky130_fd_sc_hd__decap_8
XFILLER_122_837 VPWR VGND VPWR VGND sky130_ef_sc_hd__decap_12
XFILLER_130_881 VPWR VGND VPWR VGND sky130_ef_sc_hd__decap_12
XFILLER_102_561 VGND VGND VPWR VPWR sky130_fd_sc_hd__decap_3
XFILLER_94_209 VPWR VGND VPWR VGND sky130_ef_sc_hd__decap_12
XTAP_TAPCELL_ROW_50_1136 VGND VPWR sky130_fd_sc_hd__tapvpwrvgnd_1
XTAP_TAPCELL_ROW_50_1125 VGND VPWR sky130_fd_sc_hd__tapvpwrvgnd_1
XTAP_TAPCELL_ROW_145_2653 VGND VPWR sky130_fd_sc_hd__tapvpwrvgnd_1
XFILLER_47_125 VPWR VGND VPWR VGND sky130_ef_sc_hd__decap_12
XFILLER_63_629 VPWR VGND VPWR VGND sky130_ef_sc_hd__decap_12
XFILLER_47_169 VPWR VGND VPWR VGND sky130_ef_sc_hd__decap_12
XFILLER_141_51 VGND VGND VPWR VPWR sky130_fd_sc_hd__decap_4
XFILLER_62_139 VGND VGND VPWR VPWR sky130_fd_sc_hd__fill_1
XFILLER_56_681 VPWR VGND VPWR VGND sky130_ef_sc_hd__decap_12
XFILLER_16_501 VPWR VGND VPWR VGND sky130_ef_sc_hd__decap_12
XFILLER_18_83 VGND VGND VPWR VPWR sky130_fd_sc_hd__fill_1
XFILLER_29_895 VGND VGND VPWR VPWR sky130_fd_sc_hd__fill_1
XFILLER_55_191 VPWR VGND VPWR VGND sky130_ef_sc_hd__decap_12
XFILLER_16_545 VPWR VGND VPWR VGND sky130_ef_sc_hd__decap_12
XFILLER_71_673 VPWR VGND VPWR VGND sky130_ef_sc_hd__decap_12
XFILLER_70_172 VPWR VGND VPWR VGND sky130_ef_sc_hd__decap_12
XTAP_TAPCELL_ROW_48_1098 VGND VPWR sky130_fd_sc_hd__tapvpwrvgnd_1
XFILLER_16_589 VPWR VGND VPWR VGND sky130_ef_sc_hd__decap_12
XFILLER_31_548 VPWR VGND VPWR VGND sky130_ef_sc_hd__decap_12
XANTENNA__1838__S Encode_EN VGND VGND VPWR VPWR sky130_fd_sc_hd__diode_2
XFILLER_129_447 VGND VGND VPWR VPWR sky130_fd_sc_hd__fill_1
XFILLER_117_609 VGND VGND VPWR VPWR sky130_fd_sc_hd__decap_6
XFILLER_79_8 VPWR VGND VPWR VGND sky130_ef_sc_hd__decap_12
XFILLER_11_261 VGND VGND VPWR VPWR sky130_fd_sc_hd__fill_1
XFILLER_8_755 VGND VGND VPWR VPWR sky130_fd_sc_hd__fill_1
XFILLER_140_601 VPWR VGND VPWR VGND sky130_ef_sc_hd__decap_12
XFILLER_125_653 VPWR VGND VPWR VGND sky130_ef_sc_hd__decap_12
XFILLER_124_141 VPWR VGND VPWR VGND sky130_ef_sc_hd__decap_12
XFILLER_109_193 VPWR VGND VPWR VGND sky130_ef_sc_hd__decap_12
XFILLER_125_697 VPWR VGND VPWR VGND sky130_ef_sc_hd__decap_12
XFILLER_140_645 VPWR VGND VPWR VGND sky130_ef_sc_hd__decap_12
X_3260_ clknet_3_7__leaf_clk _0043_ net36 VGND VGND VPWR VPWR net46 sky130_fd_sc_hd__dfrtp_1
X_3191_ X_crt\[5\] CRT_Start _0872_ _0873_ VGND VGND VPWR VPWR _0094_ sky130_fd_sc_hd__o22a_1
X_2211_ A_reg\[7\] _1455_ _1462_ VGND VGND VPWR VPWR _1468_ sky130_fd_sc_hd__and3_1
XFILLER_39_615 VGND VGND VPWR VPWR sky130_fd_sc_hd__fill_1
X_2142_ _1400_ VGND VGND VPWR VPWR _1401_ sky130_fd_sc_hd__inv_2
XFILLER_66_445 VPWR VGND VPWR VGND sky130_ef_sc_hd__decap_12
XFILLER_15_3 VPWR VGND VPWR VGND sky130_ef_sc_hd__decap_12
XANTENNA__1875__A1 A_reg\[4\] VGND VGND VPWR VPWR sky130_fd_sc_hd__diode_2
X_2073_ _1315_ _1324_ _1327_ VGND VGND VPWR VPWR _1335_ sky130_fd_sc_hd__mux2_1
XFILLER_82_905 VGND VGND VPWR VPWR sky130_fd_sc_hd__decap_4
XTAP_TAPCELL_ROW_68_1419 VGND VPWR sky130_fd_sc_hd__tapvpwrvgnd_1
XFILLER_54_618 VPWR VGND VPWR VGND sky130_ef_sc_hd__decap_12
XFILLER_26_309 VGND VGND VPWR VPWR sky130_fd_sc_hd__decap_4
XANTENNA__3260__RESET_B net36 VGND VGND VPWR VPWR sky130_fd_sc_hd__diode_2
XFILLER_66_489 VPWR VGND VPWR VGND sky130_ef_sc_hd__decap_12
XFILLER_53_128 VPWR VGND VPWR VGND sky130_ef_sc_hd__decap_12
XFILLER_35_865 VPWR VGND VPWR VGND sky130_ef_sc_hd__decap_12
XFILLER_62_695 VGND VGND VPWR VPWR sky130_fd_sc_hd__fill_1
XFILLER_50_813 VPWR VGND VPWR VGND sky130_ef_sc_hd__decap_12
XFILLER_34_353 VGND VGND VPWR VPWR sky130_fd_sc_hd__fill_2
XFILLER_148_701 VPWR VGND VPWR VGND sky130_ef_sc_hd__decap_12
XFILLER_61_194 VGND VGND VPWR VPWR sky130_fd_sc_hd__fill_1
X_2975_ _0646_ _0661_ VGND VGND VPWR VPWR _0663_ sky130_fd_sc_hd__xnor2_1
X_1926_ B_reg\[9\] _1186_ _1190_ VGND VGND VPWR VPWR _1191_ sky130_fd_sc_hd__nand3_1
XFILLER_135_417 VPWR VGND VPWR VGND sky130_ef_sc_hd__decap_12
X_1857_ A_reg\[9\] _1123_ _1126_ VGND VGND VPWR VPWR _1127_ sky130_fd_sc_hd__a21oi_1
XFILLER_30_29 VPWR VGND VPWR VGND sky130_ef_sc_hd__decap_12
XFILLER_146_29 VPWR VGND VPWR VGND sky130_ef_sc_hd__decap_12
XTAP_TAPCELL_ROW_112_2118 VGND VPWR sky130_fd_sc_hd__tapvpwrvgnd_1
XTAP_TAPCELL_ROW_96_1862 VGND VPWR sky130_fd_sc_hd__tapvpwrvgnd_1
XTAP_TAPCELL_ROW_112_2129 VGND VPWR sky130_fd_sc_hd__tapvpwrvgnd_1
XTAP_TAPCELL_ROW_96_1873 VGND VPWR sky130_fd_sc_hd__tapvpwrvgnd_1
XFILLER_2_909 VGND VGND VPWR VPWR sky130_fd_sc_hd__fill_1
X_1788_ _1057_ _1058_ _1060_ VGND VGND VPWR VPWR _1061_ sky130_fd_sc_hd__a21oi_1
XFILLER_143_461 VPWR VGND VPWR VGND sky130_ef_sc_hd__decap_12
XFILLER_104_837 VPWR VGND VPWR VGND sky130_ef_sc_hd__decap_12
XFILLER_130_133 VGND VGND VPWR VPWR sky130_fd_sc_hd__decap_6
XFILLER_89_559 VGND VGND VPWR VPWR sky130_fd_sc_hd__fill_1
XFILLER_39_27 VPWR VGND VPWR VGND sky130_ef_sc_hd__decap_12
XFILLER_130_177 VPWR VGND VPWR VGND sky130_ef_sc_hd__decap_12
XFILLER_112_881 VPWR VGND VPWR VGND sky130_ef_sc_hd__decap_12
X_2409_ _0159_ _0162_ VGND VGND VPWR VPWR _0163_ sky130_fd_sc_hd__nand2_1
XFILLER_76_209 VPWR VGND VPWR VGND sky130_ef_sc_hd__decap_12
XFILLER_111_391 VGND VGND VPWR VPWR sky130_fd_sc_hd__fill_1
XFILLER_69_272 VGND VGND VPWR VPWR sky130_fd_sc_hd__fill_1
XFILLER_29_125 VPWR VGND VPWR VGND sky130_ef_sc_hd__decap_12
XTAP_TAPCELL_ROW_127_2361 VGND VPWR sky130_fd_sc_hd__tapvpwrvgnd_1
XFILLER_85_765 VPWR VGND VPWR VGND sky130_ef_sc_hd__decap_12
XFILLER_29_169 VPWR VGND VPWR VGND sky130_ef_sc_hd__decap_12
XFILLER_84_286 VPWR VGND VPWR VGND sky130_ef_sc_hd__decap_12
XFILLER_38_681 VPWR VGND VPWR VGND sky130_ef_sc_hd__decap_12
XFILLER_44_139 VGND VGND VPWR VPWR sky130_fd_sc_hd__fill_1
XTAP_TAPCELL_ROW_140_2572 VGND VPWR sky130_fd_sc_hd__tapvpwrvgnd_1
XFILLER_53_673 VPWR VGND VPWR VGND sky130_ef_sc_hd__decap_12
XFILLER_41_835 VGND VGND VPWR VPWR sky130_fd_sc_hd__decap_4
XFILLER_13_559 VGND VGND VPWR VPWR sky130_fd_sc_hd__fill_1
XFILLER_25_397 VGND VGND VPWR VPWR sky130_fd_sc_hd__fill_1
XFILLER_71_69 VPWR VGND VPWR VGND sky130_ef_sc_hd__decap_12
XFILLER_138_233 VPWR VGND VPWR VGND sky130_ef_sc_hd__decap_12
XPHY_EDGE_ROW_109_Right_109 VGND VGND VPWR VPWR sky130_fd_sc_hd__decap_3
XFILLER_138_277 VPWR VGND VPWR VGND sky130_ef_sc_hd__decap_12
XFILLER_153_225 VPWR VGND VPWR VGND sky130_ef_sc_hd__decap_12
XFILLER_107_653 VPWR VGND VPWR VGND sky130_ef_sc_hd__decap_12
XFILLER_106_141 VPWR VGND VPWR VGND sky130_ef_sc_hd__decap_12
XFILLER_122_601 VPWR VGND VPWR VGND sky130_ef_sc_hd__decap_12
XFILLER_107_697 VPWR VGND VPWR VGND sky130_ef_sc_hd__decap_12
XFILLER_122_645 VPWR VGND VPWR VGND sky130_ef_sc_hd__decap_12
XFILLER_121_111 VGND VGND VPWR VPWR sky130_fd_sc_hd__fill_1
XFILLER_96_77 VGND VGND VPWR VPWR sky130_fd_sc_hd__decap_6
XFILLER_76_754 VGND VGND VPWR VPWR sky130_fd_sc_hd__fill_2
XANTENNA__1857__A1 A_reg\[9\] VGND VGND VPWR VPWR sky130_fd_sc_hd__diode_2
XFILLER_64_905 VGND VGND VPWR VPWR sky130_fd_sc_hd__decap_4
XFILLER_29_93 VPWR VGND VPWR VGND sky130_ef_sc_hd__decap_12
XFILLER_152_83 VGND VGND VPWR VPWR sky130_fd_sc_hd__fill_1
XFILLER_76_798 VPWR VGND VPWR VGND sky130_ef_sc_hd__decap_12
XFILLER_48_489 VPWR VGND VPWR VGND sky130_ef_sc_hd__decap_12
XFILLER_17_821 VPWR VGND VPWR VGND sky130_ef_sc_hd__decap_12
XFILLER_17_865 VPWR VGND VPWR VGND sky130_ef_sc_hd__decap_12
XFILLER_50_109 VGND VGND VPWR VPWR sky130_fd_sc_hd__fill_1
XFILLER_43_161 VGND VGND VPWR VPWR sky130_fd_sc_hd__decap_4
XFILLER_45_81 VPWR VGND VPWR VGND sky130_ef_sc_hd__decap_12
XTAP_TAPCELL_ROW_63_1338 VGND VPWR sky130_fd_sc_hd__tapvpwrvgnd_1
XFILLER_31_334 VGND VGND VPWR VPWR sky130_fd_sc_hd__fill_2
XFILLER_32_846 VGND VGND VPWR VPWR sky130_fd_sc_hd__decap_8
XFILLER_43_194 VGND VGND VPWR VPWR sky130_fd_sc_hd__decap_8
XTAP_TAPCELL_ROW_14_554 VGND VPWR sky130_fd_sc_hd__tapvpwrvgnd_1
X_2760_ _0484_ _0495_ _0496_ _0493_ VGND VGND VPWR VPWR _0500_ sky130_fd_sc_hd__or4b_1
XFILLER_117_417 VPWR VGND VPWR VGND sky130_ef_sc_hd__decap_12
X_2691_ _0385_ _0411_ _0428_ _0430_ VGND VGND VPWR VPWR _0431_ sky130_fd_sc_hd__a211o_1
X_1711_ _0979_ _0984_ _0986_ VGND VGND VPWR VPWR _0987_ sky130_fd_sc_hd__a21oi_1
X_1642_ A_reg\[15\] A_reg\[14\] A_reg\[13\] VGND VGND VPWR VPWR _0918_ sky130_fd_sc_hd__and3b_1
XANTENNA_2 u_crt.start_d VGND VGND VPWR VPWR sky130_fd_sc_hd__diode_2
XTAP_TAPCELL_ROW_78_1581 VGND VPWR sky130_fd_sc_hd__tapvpwrvgnd_1
XFILLER_6_53 VPWR VGND VPWR VGND sky130_ef_sc_hd__decap_12
XFILLER_153_781 VGND VGND VPWR VPWR sky130_fd_sc_hd__decap_3
XFILLER_125_461 VPWR VGND VPWR VGND sky130_ef_sc_hd__decap_12
XFILLER_6_97 VPWR VGND VPWR VGND sky130_ef_sc_hd__decap_12
XFILLER_112_133 VGND VGND VPWR VPWR sky130_fd_sc_hd__decap_6
X_3312_ clknet_3_7__leaf_clk _0095_ net36 VGND VGND VPWR VPWR X_crt\[6\] sky130_fd_sc_hd__dfrtp_1
XFILLER_140_475 VGND VGND VPWR VPWR sky130_fd_sc_hd__fill_1
XFILLER_112_177 VPWR VGND VPWR VGND sky130_ef_sc_hd__decap_12
XFILLER_98_389 VPWR VGND VPWR VGND sky130_ef_sc_hd__decap_12
XTAP_TAPCELL_ROW_91_1792 VGND VPWR sky130_fd_sc_hd__tapvpwrvgnd_1
XTAP_TAPCELL_ROW_91_1781 VGND VPWR sky130_fd_sc_hd__tapvpwrvgnd_1
X_3243_ clknet_3_6__leaf_clk _0028_ net36 VGND VGND VPWR VPWR u_crt.r0\[1\] sky130_fd_sc_hd__dfrtp_1
XFILLER_58_209 VPWR VGND VPWR VGND sky130_ef_sc_hd__decap_12
XANTENNA__1848__A1 A_reg\[11\] VGND VGND VPWR VPWR sky130_fd_sc_hd__diode_2
XFILLER_67_754 VGND VGND VPWR VPWR sky130_fd_sc_hd__decap_4
XFILLER_66_253 VPWR VGND VPWR VGND sky130_ef_sc_hd__decap_12
X_3174_ _0912_ _0859_ _0860_ _0861_ VGND VGND VPWR VPWR _0089_ sky130_fd_sc_hd__o31ai_1
XTAP_TAPCELL_ROW_109_2080 VGND VPWR sky130_fd_sc_hd__tapvpwrvgnd_1
X_2125_ B_reg\[5\] _1383_ VGND VGND VPWR VPWR _1384_ sky130_fd_sc_hd__nand2_1
XFILLER_82_724 VPWR VGND VPWR VGND sky130_ef_sc_hd__decap_12
XFILLER_27_629 VPWR VGND VPWR VGND sky130_ef_sc_hd__decap_12
X_2056_ _1311_ _1314_ VGND VGND VPWR VPWR _1318_ sky130_fd_sc_hd__xor2_1
XFILLER_82_757 VPWR VGND VPWR VGND sky130_ef_sc_hd__decap_12
XFILLER_81_223 VGND VGND VPWR VPWR sky130_fd_sc_hd__fill_1
XFILLER_26_139 VGND VGND VPWR VPWR sky130_fd_sc_hd__fill_1
XANTENNA__2862__S _0383_ VGND VGND VPWR VPWR sky130_fd_sc_hd__diode_2
XFILLER_35_673 VPWR VGND VPWR VGND sky130_ef_sc_hd__decap_12
XTAP_TAPCELL_ROW_122_2291 VGND VPWR sky130_fd_sc_hd__tapvpwrvgnd_1
XTAP_TAPCELL_ROW_122_2280 VGND VPWR sky130_fd_sc_hd__tapvpwrvgnd_1
XANTENNA__2434__Y _0184_ VGND VGND VPWR VPWR sky130_fd_sc_hd__diode_2
XTAP_TAPCELL_ROW_33_852 VGND VPWR sky130_fd_sc_hd__tapvpwrvgnd_1
XTAP_TAPCELL_ROW_33_863 VGND VPWR sky130_fd_sc_hd__tapvpwrvgnd_1
XFILLER_148_531 VGND VGND VPWR VPWR sky130_fd_sc_hd__fill_1
XTAP_TAPCELL_ROW_98_1902 VGND VPWR sky130_fd_sc_hd__tapvpwrvgnd_1
X_2958_ _0645_ _0627_ VGND VGND VPWR VPWR _0646_ sky130_fd_sc_hd__nand2b_1
XFILLER_22_389 VPWR VGND VPWR VGND sky130_ef_sc_hd__decap_12
XFILLER_41_39 VPWR VGND VPWR VGND sky130_ef_sc_hd__decap_12
XFILLER_108_417 VGND VGND VPWR VPWR sky130_fd_sc_hd__decap_3
X_1909_ B_reg\[13\] B_reg\[12\] VGND VGND VPWR VPWR _1174_ sky130_fd_sc_hd__nand2_1
XFILLER_136_737 VPWR VGND VPWR VGND sky130_ef_sc_hd__decap_12
XFILLER_135_225 VPWR VGND VPWR VGND sky130_ef_sc_hd__decap_12
X_2889_ _0573_ _0575_ VGND VGND VPWR VPWR _0577_ sky130_fd_sc_hd__xnor2_1
XFILLER_151_729 VPWR VGND VPWR VGND sky130_ef_sc_hd__decap_12
XFILLER_144_781 VPWR VGND VPWR VGND sky130_ef_sc_hd__decap_12
XFILLER_104_601 VPWR VGND VPWR VGND sky130_ef_sc_hd__decap_12
XFILLER_89_301 VPWR VGND VPWR VGND sky130_ef_sc_hd__decap_12
XFILLER_1_205 VPWR VGND VPWR VGND sky130_ef_sc_hd__decap_12
XFILLER_104_645 VPWR VGND VPWR VGND sky130_ef_sc_hd__decap_12
XFILLER_103_111 VGND VGND VPWR VPWR sky130_fd_sc_hd__fill_1
XFILLER_1_249 VPWR VGND VPWR VGND sky130_ef_sc_hd__decap_12
XTAP_TAPCELL_ROW_129_2401 VGND VPWR sky130_fd_sc_hd__tapvpwrvgnd_1
XFILLER_77_529 VPWR VGND VPWR VGND sky130_ef_sc_hd__decap_12
XFILLER_131_497 VGND VGND VPWR VPWR sky130_fd_sc_hd__decap_6
XFILLER_106_65 VPWR VGND VPWR VGND sky130_ef_sc_hd__decap_12
XFILLER_58_732 VPWR VGND VPWR VGND sky130_ef_sc_hd__decap_12
XTAP_TAPCELL_ROW_142_2601 VGND VPWR sky130_fd_sc_hd__tapvpwrvgnd_1
XFILLER_85_540 VPWR VGND VPWR VGND sky130_ef_sc_hd__decap_12
XFILLER_85_573 VPWR VGND VPWR VGND sky130_ef_sc_hd__decap_12
XFILLER_122_53 VPWR VGND VPWR VGND sky130_ef_sc_hd__decap_12
XFILLER_72_245 VGND VGND VPWR VPWR sky130_fd_sc_hd__decap_6
XFILLER_45_437 VGND VGND VPWR VPWR sky130_fd_sc_hd__fill_2
XFILLER_122_97 VPWR VGND VPWR VGND sky130_ef_sc_hd__decap_12
XFILLER_14_813 VPWR VGND VPWR VGND sky130_ef_sc_hd__decap_12
XFILLER_32_109 VPWR VGND VPWR VGND sky130_ef_sc_hd__decap_12
XFILLER_13_312 VGND VGND VPWR VPWR sky130_fd_sc_hd__decap_8
XFILLER_25_161 VGND VGND VPWR VPWR sky130_fd_sc_hd__decap_6
XTAP_TAPCELL_ROW_45_1046 VGND VPWR sky130_fd_sc_hd__tapvpwrvgnd_1
XFILLER_9_305 VPWR VGND VPWR VGND sky130_ef_sc_hd__decap_12
XFILLER_13_356 VPWR VGND VPWR VGND sky130_ef_sc_hd__decap_12
XFILLER_15_51 VGND VGND VPWR VPWR sky130_fd_sc_hd__decap_4
XFILLER_40_153 VGND VGND VPWR VPWR sky130_fd_sc_hd__fill_1
XTAP_TAPCELL_ROW_45_1057 VGND VPWR sky130_fd_sc_hd__tapvpwrvgnd_1
XTAP_TAPCELL_ROW_11_502 VGND VPWR sky130_fd_sc_hd__tapvpwrvgnd_1
XFILLER_9_349 VPWR VGND VPWR VGND sky130_ef_sc_hd__decap_12
XTAP_TAPCELL_ROW_11_513 VGND VPWR sky130_fd_sc_hd__tapvpwrvgnd_1
XFILLER_139_553 VGND VGND VPWR VPWR sky130_fd_sc_hd__decap_6
XFILLER_40_197 VPWR VGND VPWR VGND sky130_ef_sc_hd__decap_12
XTAP_TAPCELL_ROW_153_2774 VGND VPWR sky130_fd_sc_hd__tapvpwrvgnd_1
XFILLER_139_597 VPWR VGND VPWR VGND sky130_ef_sc_hd__decap_12
XTAP_TAPCELL_ROW_153_2796 VGND VPWR sky130_fd_sc_hd__tapvpwrvgnd_1
XTAP_TAPCELL_ROW_153_2785 VGND VPWR sky130_fd_sc_hd__tapvpwrvgnd_1
XFILLER_141_217 VGND VGND VPWR VPWR sky130_fd_sc_hd__decap_6
XFILLER_96_805 VGND VGND VPWR VPWR sky130_fd_sc_hd__decap_6
Xoutput50 net50 VGND VGND VPWR VPWR X_out[6] sky130_fd_sc_hd__buf_1
XFILLER_122_475 VGND VGND VPWR VPWR sky130_fd_sc_hd__fill_1
XFILLER_110_637 VGND VGND VPWR VPWR sky130_fd_sc_hd__decap_6
XFILLER_96_849 VPWR VGND VPWR VGND sky130_ef_sc_hd__decap_12
XFILLER_95_337 VPWR VGND VPWR VGND sky130_ef_sc_hd__decap_12
XANTENNA__3213__CLK clknet_3_1__leaf_clk VGND VGND VPWR VPWR sky130_fd_sc_hd__diode_2
XFILLER_1_783 VGND VGND VPWR VPWR sky130_fd_sc_hd__fill_1
XFILLER_49_776 VGND VGND VPWR VPWR sky130_fd_sc_hd__fill_2
XFILLER_48_253 VPWR VGND VPWR VGND sky130_ef_sc_hd__decap_12
XFILLER_0_293 VPWR VGND VPWR VGND sky130_ef_sc_hd__decap_12
XFILLER_64_713 VPWR VGND VPWR VGND sky130_ef_sc_hd__decap_12
XFILLER_64_757 VGND VGND VPWR VPWR sky130_fd_sc_hd__fill_2
XTAP_TAPCELL_ROW_19_635 VGND VPWR sky130_fd_sc_hd__tapvpwrvgnd_1
XFILLER_17_673 VPWR VGND VPWR VGND sky130_ef_sc_hd__decap_12
XFILLER_149_317 VPWR VGND VPWR VGND sky130_ef_sc_hd__decap_12
XFILLER_20_805 VGND VGND VPWR VPWR sky130_fd_sc_hd__decap_6
XFILLER_32_643 VGND VGND VPWR VPWR sky130_fd_sc_hd__fill_1
X_2812_ _0421_ _0549_ VGND VGND VPWR VPWR _0550_ sky130_fd_sc_hd__nand2_1
XFILLER_82_3 VPWR VGND VPWR VGND sky130_ef_sc_hd__decap_12
XFILLER_20_849 VPWR VGND VPWR VGND sky130_ef_sc_hd__decap_12
XTAP_TAPCELL_ROW_30_811 VGND VPWR sky130_fd_sc_hd__tapvpwrvgnd_1
X_2743_ _0482_ _0187_ _0481_ VGND VGND VPWR VPWR _0483_ sky130_fd_sc_hd__and3b_1
XFILLER_118_737 VPWR VGND VPWR VGND sky130_ef_sc_hd__decap_12
XFILLER_117_225 VPWR VGND VPWR VGND sky130_ef_sc_hd__decap_12
X_2674_ _0412_ _0413_ _0187_ _0404_ VGND VGND VPWR VPWR _0414_ sky130_fd_sc_hd__a211o_1
XFILLER_133_729 VPWR VGND VPWR VGND sky130_ef_sc_hd__decap_12
XFILLER_126_781 VPWR VGND VPWR VGND sky130_ef_sc_hd__decap_12
X_1625_ B_reg\[5\] VGND VGND VPWR VPWR _0905_ sky130_fd_sc_hd__inv_2
XTAP_TAPCELL_ROW_93_1821 VGND VPWR sky130_fd_sc_hd__tapvpwrvgnd_1
XFILLER_99_665 VGND VGND VPWR VPWR sky130_fd_sc_hd__decap_6
XFILLER_98_153 VPWR VGND VPWR VGND sky130_ef_sc_hd__decap_12
XANTENNA__2857__S _0383_ VGND VGND VPWR VPWR sky130_fd_sc_hd__diode_2
XFILLER_59_529 VPWR VGND VPWR VGND sky130_ef_sc_hd__decap_12
XFILLER_113_497 VGND VGND VPWR VPWR sky130_fd_sc_hd__decap_6
XFILLER_98_197 VGND VGND VPWR VPWR sky130_fd_sc_hd__fill_1
XFILLER_86_359 VGND VGND VPWR VPWR sky130_fd_sc_hd__decap_4
X_3226_ clknet_3_3__leaf_clk _0013_ net36 VGND VGND VPWR VPWR b_r2\[2\] sky130_fd_sc_hd__dfrtp_4
XFILLER_28_905 VGND VGND VPWR VPWR sky130_fd_sc_hd__decap_4
XFILLER_39_242 VPWR VGND VPWR VGND sky130_ef_sc_hd__decap_12
XTAP_TAPCELL_ROW_124_2320 VGND VPWR sky130_fd_sc_hd__tapvpwrvgnd_1
XTAP_TAPCELL_ROW_107_2039 VGND VPWR sky130_fd_sc_hd__tapvpwrvgnd_1
XFILLER_67_573 VPWR VGND VPWR VGND sky130_ef_sc_hd__decap_12
XFILLER_55_724 VGND VGND VPWR VPWR sky130_fd_sc_hd__decap_4
X_3157_ _0837_ _0844_ VGND VGND VPWR VPWR _0845_ sky130_fd_sc_hd__nand2_1
XFILLER_94_392 VPWR VGND VPWR VGND sky130_ef_sc_hd__decap_12
X_2108_ _1363_ _0899_ _1364_ VGND VGND VPWR VPWR _1367_ sky130_fd_sc_hd__mux2_1
XTAP_TAPCELL_ROW_38_933 VGND VPWR sky130_fd_sc_hd__tapvpwrvgnd_1
XTAP_TAPCELL_ROW_38_944 VGND VPWR sky130_fd_sc_hd__tapvpwrvgnd_1
XFILLER_82_587 VGND VGND VPWR VPWR sky130_fd_sc_hd__fill_1
X_3088_ _0744_ _0753_ VGND VGND VPWR VPWR _0776_ sky130_fd_sc_hd__nand2_1
XFILLER_14_109 VPWR VGND VPWR VGND sky130_ef_sc_hd__decap_12
X_2039_ B_reg\[7\] _1292_ _1297_ _1299_ B_reg\[6\] VGND VGND VPWR VPWR _1301_ sky130_fd_sc_hd__a311o_1
XFILLER_23_665 VGND VGND VPWR VPWR sky130_fd_sc_hd__decap_6
XTAP_TAPCELL_ROW_102_1961 VGND VPWR sky130_fd_sc_hd__tapvpwrvgnd_1
XFILLER_22_153 VPWR VGND VPWR VGND sky130_ef_sc_hd__decap_12
XFILLER_136_501 VPWR VGND VPWR VGND sky130_ef_sc_hd__decap_12
XFILLER_7_809 VPWR VGND VPWR VGND sky130_ef_sc_hd__decap_12
XFILLER_22_197 VPWR VGND VPWR VGND sky130_ef_sc_hd__decap_12
XFILLER_149_895 VGND VGND VPWR VPWR sky130_fd_sc_hd__fill_1
XFILLER_136_545 VPWR VGND VPWR VGND sky130_ef_sc_hd__decap_12
XTAP_TAPCELL_ROW_135_2493 VGND VPWR sky130_fd_sc_hd__tapvpwrvgnd_1
XFILLER_136_589 VPWR VGND VPWR VGND sky130_ef_sc_hd__decap_12
XFILLER_123_217 VGND VGND VPWR VPWR sky130_fd_sc_hd__decap_6
XANTENNA__3236__CLK clknet_3_3__leaf_clk VGND VGND VPWR VPWR sky130_fd_sc_hd__diode_2
XFILLER_151_559 VGND VGND VPWR VPWR sky130_fd_sc_hd__fill_1
XFILLER_78_805 VGND VGND VPWR VPWR sky130_fd_sc_hd__decap_6
XFILLER_131_261 VPWR VGND VPWR VGND sky130_ef_sc_hd__decap_12
XFILLER_104_475 VGND VGND VPWR VPWR sky130_fd_sc_hd__fill_1
XFILLER_78_849 VPWR VGND VPWR VGND sky130_ef_sc_hd__decap_12
XFILLER_77_337 VPWR VGND VPWR VGND sky130_ef_sc_hd__decap_12
XFILLER_77_57 VPWR VGND VPWR VGND sky130_ef_sc_hd__decap_12
XFILLER_92_307 VGND VGND VPWR VPWR sky130_fd_sc_hd__fill_1
XFILLER_100_681 VPWR VGND VPWR VGND sky130_ef_sc_hd__decap_12
XFILLER_86_893 VPWR VGND VPWR VGND sky130_ef_sc_hd__decap_12
XFILLER_46_713 VPWR VGND VPWR VGND sky130_ef_sc_hd__decap_12
XANTENNA__2485__A1 a_r1\[0\] VGND VGND VPWR VPWR sky130_fd_sc_hd__diode_2
XFILLER_46_757 VPWR VGND VPWR VGND sky130_ef_sc_hd__decap_12
XFILLER_26_83 VGND VGND VPWR VPWR sky130_fd_sc_hd__fill_1
XFILLER_33_429 VPWR VGND VPWR VGND sky130_ef_sc_hd__decap_12
XFILLER_14_643 VGND VGND VPWR VPWR sky130_fd_sc_hd__fill_1
XFILLER_9_113 VPWR VGND VPWR VGND sky130_ef_sc_hd__decap_12
XFILLER_41_473 VPWR VGND VPWR VGND sky130_ef_sc_hd__decap_12
XFILLER_146_309 VPWR VGND VPWR VGND sky130_ef_sc_hd__decap_12
XFILLER_139_361 VPWR VGND VPWR VGND sky130_ef_sc_hd__decap_12
XFILLER_10_893 VPWR VGND VPWR VGND sky130_ef_sc_hd__decap_12
XFILLER_115_729 VPWR VGND VPWR VGND sky130_ef_sc_hd__decap_12
XFILLER_108_781 VPWR VGND VPWR VGND sky130_ef_sc_hd__decap_12
XTAP_TAPCELL_ROW_58_1259 VGND VPWR sky130_fd_sc_hd__tapvpwrvgnd_1
X_2390_ _0907_ _0141_ _0142_ VGND VGND VPWR VPWR _0144_ sky130_fd_sc_hd__and3_1
XFILLER_96_613 VPWR VGND VPWR VGND sky130_ef_sc_hd__decap_12
XFILLER_150_581 VGND VGND VPWR VPWR sky130_fd_sc_hd__decap_6
XFILLER_110_401 VPWR VGND VPWR VGND sky130_ef_sc_hd__decap_12
XFILLER_110_445 VGND VGND VPWR VPWR sky130_fd_sc_hd__decap_8
XFILLER_96_657 VPWR VGND VPWR VGND sky130_ef_sc_hd__decap_12
XFILLER_95_167 VGND VGND VPWR VPWR sky130_fd_sc_hd__fill_1
X_3011_ _0567_ _0568_ _0569_ _0579_ VGND VGND VPWR VPWR _0699_ sky130_fd_sc_hd__nor4_1
XFILLER_64_510 VPWR VGND VPWR VGND sky130_ef_sc_hd__decap_12
XFILLER_64_576 VPWR VGND VPWR VGND sky130_ef_sc_hd__decap_12
XFILLER_51_237 VGND VGND VPWR VPWR sky130_fd_sc_hd__fill_2
XANTENNA__1610__A A_reg\[9\] VGND VGND VPWR VPWR sky130_fd_sc_hd__diode_2
XFILLER_36_289 VGND VGND VPWR VPWR sky130_fd_sc_hd__decap_4
XFILLER_149_125 VPWR VGND VPWR VGND sky130_ef_sc_hd__decap_12
XFILLER_60_793 VPWR VGND VPWR VGND sky130_ef_sc_hd__decap_12
XFILLER_20_613 VPWR VGND VPWR VGND sky130_ef_sc_hd__decap_12
XFILLER_149_169 VPWR VGND VPWR VGND sky130_ef_sc_hd__decap_12
XPHY_EDGE_ROW_17_Left_171 VGND VGND VPWR VPWR sky130_fd_sc_hd__decap_3
XFILLER_20_657 VPWR VGND VPWR VGND sky130_ef_sc_hd__decap_12
XFILLER_118_501 VPWR VGND VPWR VGND sky130_ef_sc_hd__decap_12
XANTENNA__3259__CLK clknet_3_7__leaf_clk VGND VGND VPWR VPWR sky130_fd_sc_hd__diode_2
XFILLER_118_545 VPWR VGND VPWR VGND sky130_ef_sc_hd__decap_12
X_2726_ _0462_ _0464_ VGND VGND VPWR VPWR _0466_ sky130_fd_sc_hd__nor2_1
XANTENNA__2441__A _0186_ VGND VGND VPWR VPWR sky130_fd_sc_hd__diode_2
XFILLER_118_589 VPWR VGND VPWR VGND sky130_ef_sc_hd__decap_12
XFILLER_105_217 VGND VGND VPWR VPWR sky130_fd_sc_hd__decap_6
X_2657_ a_r3\[2\] _0392_ VGND VGND VPWR VPWR _0397_ sky130_fd_sc_hd__or2_1
XFILLER_133_559 VGND VGND VPWR VPWR sky130_fd_sc_hd__fill_1
X_1608_ A_reg\[11\] VGND VGND VPWR VPWR _0888_ sky130_fd_sc_hd__inv_2
XFILLER_120_209 VPWR VGND VPWR VGND sky130_ef_sc_hd__decap_12
X_2588_ _0332_ VGND VGND VPWR VPWR _0333_ sky130_fd_sc_hd__inv_2
XFILLER_113_261 VPWR VGND VPWR VGND sky130_ef_sc_hd__decap_12
XFILLER_99_473 VGND VGND VPWR VPWR sky130_fd_sc_hd__decap_4
XFILLER_86_112 VPWR VGND VPWR VGND sky130_ef_sc_hd__decap_12
XFILLER_59_337 VPWR VGND VPWR VGND sky130_ef_sc_hd__decap_12
XPHY_EDGE_ROW_26_Left_180 VGND VGND VPWR VPWR sky130_fd_sc_hd__decap_3
XFILLER_47_27 VPWR VGND VPWR VGND sky130_ef_sc_hd__decap_12
XFILLER_101_489 VGND VGND VPWR VPWR sky130_fd_sc_hd__decap_8
XFILLER_101_467 VGND VGND VPWR VPWR sky130_fd_sc_hd__decap_8
XFILLER_74_307 VGND VGND VPWR VPWR sky130_fd_sc_hd__fill_1
XFILLER_68_893 VPWR VGND VPWR VGND sky130_ef_sc_hd__decap_12
X_3209_ X_crt\[13\] _0912_ VGND VGND VPWR VPWR _0102_ sky130_fd_sc_hd__and2_1
XFILLER_28_713 VPWR VGND VPWR VGND sky130_ef_sc_hd__decap_12
XFILLER_83_841 VPWR VGND VPWR VGND sky130_ef_sc_hd__decap_12
XFILLER_27_234 VPWR VGND VPWR VGND sky130_ef_sc_hd__decap_12
XFILLER_28_757 VPWR VGND VPWR VGND sky130_ef_sc_hd__decap_12
XFILLER_103_55 VGND VGND VPWR VPWR sky130_fd_sc_hd__fill_1
XFILLER_55_554 VGND VGND VPWR VPWR sky130_fd_sc_hd__decap_6
XTAP_TAPCELL_ROW_2_366 VGND VPWR sky130_fd_sc_hd__tapvpwrvgnd_1
XFILLER_43_727 VGND VGND VPWR VPWR sky130_fd_sc_hd__fill_1
XFILLER_15_429 VGND VGND VPWR VPWR sky130_fd_sc_hd__decap_8
XFILLER_27_278 VGND VGND VPWR VPWR sky130_fd_sc_hd__fill_2
XANTENNA__2219__A1 A_reg\[6\] VGND VGND VPWR VPWR sky130_fd_sc_hd__diode_2
XFILLER_11_613 VGND VGND VPWR VPWR sky130_fd_sc_hd__decap_3
XFILLER_23_473 VPWR VGND VPWR VGND sky130_ef_sc_hd__decap_12
XTAP_TAPCELL_ROW_42_1005 VGND VPWR sky130_fd_sc_hd__tapvpwrvgnd_1
XTAP_TAPCELL_ROW_137_2522 VGND VPWR sky130_fd_sc_hd__tapvpwrvgnd_1
XFILLER_128_309 VPWR VGND VPWR VGND sky130_ef_sc_hd__decap_12
XFILLER_137_821 VPWR VGND VPWR VGND sky130_ef_sc_hd__decap_12
XFILLER_109_512 VGND VGND VPWR VPWR sky130_fd_sc_hd__decap_6
XFILLER_7_617 VPWR VGND VPWR VGND sky130_ef_sc_hd__decap_12
XTAP_TAPCELL_ROW_21_663 VGND VPWR sky130_fd_sc_hd__tapvpwrvgnd_1
XFILLER_137_865 VPWR VGND VPWR VGND sky130_ef_sc_hd__decap_12
XFILLER_10_189 VGND VGND VPWR VPWR sky130_fd_sc_hd__decap_6
XFILLER_12_41 VPWR VGND VPWR VGND sky130_ef_sc_hd__decap_12
XTAP_TAPCELL_ROW_21_674 VGND VPWR sky130_fd_sc_hd__tapvpwrvgnd_1
XFILLER_152_813 VPWR VGND VPWR VGND sky130_ef_sc_hd__decap_12
XTAP_TAPCELL_ROW_150_2733 VGND VPWR sky130_fd_sc_hd__tapvpwrvgnd_1
XFILLER_128_41 VPWR VGND VPWR VGND sky130_ef_sc_hd__decap_12
XFILLER_12_85 VPWR VGND VPWR VGND sky130_ef_sc_hd__decap_12
XFILLER_128_85 VPWR VGND VPWR VGND sky130_ef_sc_hd__decap_12
XFILLER_3_889 VGND VGND VPWR VPWR sky130_fd_sc_hd__decap_6
XFILLER_2_333 VPWR VGND VPWR VGND sky130_ef_sc_hd__decap_12
XFILLER_132_581 VGND VGND VPWR VPWR sky130_fd_sc_hd__decap_6
XFILLER_78_657 VGND VGND VPWR VPWR sky130_fd_sc_hd__fill_2
XTAP_TAPCELL_ROW_53_1178 VGND VPWR sky130_fd_sc_hd__tapvpwrvgnd_1
XTAP_TAPCELL_ROW_148_2695 VGND VPWR sky130_fd_sc_hd__tapvpwrvgnd_1
XFILLER_46_565 VPWR VGND VPWR VGND sky130_ef_sc_hd__decap_12
XPHY_EDGE_ROW_16_Right_16 VGND VGND VPWR VPWR sky130_fd_sc_hd__decap_3
XFILLER_18_245 VGND VGND VPWR VPWR sky130_fd_sc_hd__decap_6
XFILLER_37_93 VPWR VGND VPWR VGND sky130_ef_sc_hd__decap_12
XFILLER_18_289 VPWR VGND VPWR VGND sky130_ef_sc_hd__decap_12
XTAP_TAPCELL_ROW_29_796 VGND VPWR sky130_fd_sc_hd__tapvpwrvgnd_1
XFILLER_34_749 VGND VGND VPWR VPWR sky130_fd_sc_hd__decap_6
XFILLER_33_237 VPWR VGND VPWR VGND sky130_ef_sc_hd__decap_12
XFILLER_53_81 VPWR VGND VPWR VGND sky130_ef_sc_hd__decap_12
XFILLER_14_473 VGND VGND VPWR VPWR sky130_fd_sc_hd__decap_3
X_1890_ a_r0\[0\] _1159_ Encode_EN VGND VGND VPWR VPWR _0006_ sky130_fd_sc_hd__mux2_1
XANTENNA__3285__RESET_B net36 VGND VGND VPWR VPWR sky130_fd_sc_hd__diode_2
XFILLER_41_270 VGND VGND VPWR VPWR sky130_fd_sc_hd__decap_8
XFILLER_41_281 VGND VGND VPWR VPWR sky130_fd_sc_hd__decap_6
XFILLER_147_629 VPWR VGND VPWR VGND sky130_ef_sc_hd__decap_12
XTAP_TAPCELL_ROW_40_972 VGND VPWR sky130_fd_sc_hd__tapvpwrvgnd_1
XFILLER_146_139 VGND VGND VPWR VPWR sky130_fd_sc_hd__fill_1
XANTENNA__3214__RESET_B net36 VGND VGND VPWR VPWR sky130_fd_sc_hd__diode_2
XPHY_EDGE_ROW_25_Right_25 VGND VGND VPWR VPWR sky130_fd_sc_hd__decap_3
XFILLER_142_301 VGND VGND VPWR VPWR sky130_fd_sc_hd__decap_6
X_2511_ b_r1\[0\] a_r1\[2\] _0222_ _0252_ VGND VGND VPWR VPWR _0259_ sky130_fd_sc_hd__a31o_1
XFILLER_115_559 VGND VGND VPWR VPWR sky130_fd_sc_hd__fill_1
XFILLER_142_345 VPWR VGND VPWR VGND sky130_ef_sc_hd__decap_12
XFILLER_102_209 VPWR VGND VPWR VGND sky130_ef_sc_hd__decap_12
X_2442_ _0191_ VGND VGND VPWR VPWR _0192_ sky130_fd_sc_hd__inv_2
XFILLER_5_193 VPWR VGND VPWR VGND sky130_ef_sc_hd__decap_12
XFILLER_45_3 VPWR VGND VPWR VGND sky130_ef_sc_hd__decap_12
XFILLER_142_389 VPWR VGND VPWR VGND sky130_ef_sc_hd__decap_12
XFILLER_111_721 VGND VGND VPWR VPWR sky130_fd_sc_hd__decap_6
X_2373_ _0117_ _0123_ VGND VGND VPWR VPWR _0127_ sky130_fd_sc_hd__xnor2_1
XFILLER_96_421 VPWR VGND VPWR VGND sky130_ef_sc_hd__decap_12
XFILLER_69_635 VGND VGND VPWR VPWR sky130_fd_sc_hd__decap_4
XFILLER_111_765 VPWR VGND VPWR VGND sky130_ef_sc_hd__decap_12
XFILLER_69_657 VPWR VGND VPWR VGND sky130_ef_sc_hd__decap_12
XFILLER_110_253 VPWR VGND VPWR VGND sky130_ef_sc_hd__decap_12
XFILLER_56_307 VGND VGND VPWR VPWR sky130_fd_sc_hd__fill_1
XTAP_TAPCELL_ROW_88_1742 VGND VPWR sky130_fd_sc_hd__tapvpwrvgnd_1
XFILLER_83_137 VPWR VGND VPWR VGND sky130_ef_sc_hd__decap_12
XFILLER_77_690 VGND VGND VPWR VPWR sky130_fd_sc_hd__fill_1
XFILLER_65_841 VPWR VGND VPWR VGND sky130_ef_sc_hd__decap_12
XPHY_EDGE_ROW_34_Right_34 VGND VGND VPWR VPWR sky130_fd_sc_hd__decap_3
XFILLER_80_811 VGND VGND VPWR VPWR sky130_fd_sc_hd__fill_1
XFILLER_92_693 VGND VGND VPWR VPWR sky130_fd_sc_hd__decap_6
XANTENNA__2436__A OpSel_reg\[0\] VGND VGND VPWR VPWR sky130_fd_sc_hd__diode_2
XFILLER_25_727 VGND VGND VPWR VPWR sky130_fd_sc_hd__fill_1
XFILLER_37_587 VPWR VGND VPWR VGND sky130_ef_sc_hd__decap_12
XTAP_TAPCELL_ROW_119_2230 VGND VPWR sky130_fd_sc_hd__tapvpwrvgnd_1
XFILLER_20_432 VPWR VGND VPWR VGND sky130_ef_sc_hd__decap_12
XFILLER_119_821 VPWR VGND VPWR VGND sky130_ef_sc_hd__decap_12
XTAP_TAPCELL_ROW_119_2241 VGND VPWR sky130_fd_sc_hd__tapvpwrvgnd_1
XPHY_EDGE_ROW_43_Right_43 VGND VGND VPWR VPWR sky130_fd_sc_hd__decap_3
XFILLER_119_865 VPWR VGND VPWR VGND sky130_ef_sc_hd__decap_12
XFILLER_152_109 VPWR VGND VPWR VGND sky130_ef_sc_hd__decap_12
XFILLER_145_161 VGND VGND VPWR VPWR sky130_fd_sc_hd__decap_6
XFILLER_134_813 VPWR VGND VPWR VGND sky130_ef_sc_hd__decap_12
XTAP_TAPCELL_ROW_132_2441 VGND VPWR sky130_fd_sc_hd__tapvpwrvgnd_1
X_2709_ _0384_ _0429_ VGND VGND VPWR VPWR _0449_ sky130_fd_sc_hd__or2_1
XFILLER_121_529 VPWR VGND VPWR VGND sky130_ef_sc_hd__decap_12
XFILLER_114_581 VGND VGND VPWR VPWR sky130_fd_sc_hd__decap_6
XFILLER_58_15 VGND VGND VPWR VPWR sky130_fd_sc_hd__fill_2
XTAP_TAPCELL_ROW_7_447 VGND VPWR sky130_fd_sc_hd__tapvpwrvgnd_1
XTAP_TAPCELL_ROW_7_436 VGND VPWR sky130_fd_sc_hd__tapvpwrvgnd_1
XFILLER_0_837 VGND VGND VPWR VPWR sky130_fd_sc_hd__decap_3
XFILLER_48_819 VGND VGND VPWR VPWR sky130_fd_sc_hd__fill_1
XPHY_EDGE_ROW_52_Right_52 VGND VGND VPWR VPWR sky130_fd_sc_hd__decap_3
XFILLER_47_329 VGND VGND VPWR VPWR sky130_fd_sc_hd__decap_6
XFILLER_114_65 VPWR VGND VPWR VGND sky130_ef_sc_hd__decap_12
XFILLER_83_671 VGND VGND VPWR VPWR sky130_fd_sc_hd__fill_1
XFILLER_71_833 VGND VGND VPWR VPWR sky130_fd_sc_hd__decap_6
XFILLER_70_321 VPWR VGND VPWR VGND sky130_ef_sc_hd__decap_12
XFILLER_16_749 VGND VGND VPWR VPWR sky130_fd_sc_hd__decap_6
XFILLER_28_587 VGND VGND VPWR VPWR sky130_fd_sc_hd__fill_1
XFILLER_130_53 VPWR VGND VPWR VGND sky130_ef_sc_hd__decap_12
XFILLER_71_877 VPWR VGND VPWR VGND sky130_ef_sc_hd__decap_12
XTAP_TAPCELL_ROW_26_744 VGND VPWR sky130_fd_sc_hd__tapvpwrvgnd_1
XTAP_TAPCELL_ROW_26_755 VGND VPWR sky130_fd_sc_hd__tapvpwrvgnd_1
XFILLER_130_97 VPWR VGND VPWR VGND sky130_ef_sc_hd__decap_12
XFILLER_90_46 VPWR VGND VPWR VGND sky130_ef_sc_hd__decap_12
XFILLER_70_365 VPWR VGND VPWR VGND sky130_ef_sc_hd__decap_12
XPHY_EDGE_ROW_61_Right_61 VGND VGND VPWR VPWR sky130_fd_sc_hd__decap_3
XFILLER_24_793 VPWR VGND VPWR VGND sky130_ef_sc_hd__decap_12
XFILLER_129_629 VPWR VGND VPWR VGND sky130_ef_sc_hd__decap_12
XFILLER_11_454 VGND VGND VPWR VPWR sky130_fd_sc_hd__fill_1
XFILLER_23_51 VGND VGND VPWR VPWR sky130_fd_sc_hd__decap_4
XFILLER_139_51 VGND VGND VPWR VPWR sky130_fd_sc_hd__decap_4
XFILLER_128_139 VGND VGND VPWR VPWR sky130_fd_sc_hd__fill_1
XFILLER_137_673 VPWR VGND VPWR VGND sky130_ef_sc_hd__decap_12
XFILLER_124_301 VGND VGND VPWR VPWR sky130_fd_sc_hd__decap_6
XFILLER_99_55 VGND VGND VPWR VPWR sky130_fd_sc_hd__fill_1
XFILLER_152_643 VGND VGND VPWR VPWR sky130_fd_sc_hd__fill_1
XTAP_TAPCELL_ROW_55_1207 VGND VPWR sky130_fd_sc_hd__tapvpwrvgnd_1
XFILLER_140_805 VGND VGND VPWR VPWR sky130_fd_sc_hd__decap_6
XFILLER_124_345 VPWR VGND VPWR VGND sky130_ef_sc_hd__decap_12
XTAP_TAPCELL_ROW_55_1218 VGND VPWR sky130_fd_sc_hd__tapvpwrvgnd_1
XFILLER_140_849 VPWR VGND VPWR VGND sky130_ef_sc_hd__decap_12
XFILLER_124_389 VPWR VGND VPWR VGND sky130_ef_sc_hd__decap_12
XFILLER_112_529 VGND VGND VPWR VPWR sky130_fd_sc_hd__decap_3
XFILLER_78_421 VPWR VGND VPWR VGND sky130_ef_sc_hd__decap_12
XPHY_EDGE_ROW_70_Right_70 VGND VGND VPWR VPWR sky130_fd_sc_hd__decap_3
XFILLER_3_697 VPWR VGND VPWR VGND sky130_ef_sc_hd__decap_12
XFILLER_2_141 VPWR VGND VPWR VGND sky130_ef_sc_hd__decap_12
XFILLER_47_841 VGND VGND VPWR VPWR sky130_fd_sc_hd__decap_4
XANTENNA__2851__A1 B_reg\[1\] VGND VGND VPWR VPWR sky130_fd_sc_hd__diode_2
XFILLER_62_811 VGND VGND VPWR VPWR sky130_fd_sc_hd__fill_1
XFILLER_61_310 VPWR VGND VPWR VGND sky130_ef_sc_hd__decap_12
XFILLER_73_181 VGND VGND VPWR VPWR sky130_fd_sc_hd__fill_2
XTAP_TAPCELL_ROW_83_1661 VGND VPWR sky130_fd_sc_hd__tapvpwrvgnd_1
X_2991_ _0677_ _0678_ VGND VGND VPWR VPWR _0679_ sky130_fd_sc_hd__and2_1
XFILLER_34_579 VGND VGND VPWR VPWR sky130_fd_sc_hd__decap_8
XFILLER_148_905 VGND VGND VPWR VPWR sky130_fd_sc_hd__decap_4
X_1942_ _0903_ _1205_ VGND VGND VPWR VPWR _1207_ sky130_fd_sc_hd__xnor2_2
X_1873_ _1142_ VGND VGND VPWR VPWR _1143_ sky130_fd_sc_hd__inv_2
XFILLER_134_109 VPWR VGND VPWR VGND sky130_ef_sc_hd__decap_12
XFILLER_116_813 VPWR VGND VPWR VGND sky130_ef_sc_hd__decap_12
XFILLER_127_161 VGND VGND VPWR VPWR sky130_fd_sc_hd__decap_6
XTAP_TAPCELL_ROW_114_2160 VGND VPWR sky130_fd_sc_hd__tapvpwrvgnd_1
XFILLER_143_665 VGND VGND VPWR VPWR sky130_fd_sc_hd__decap_6
XFILLER_142_153 VPWR VGND VPWR VGND sky130_ef_sc_hd__decap_12
XFILLER_103_529 VPWR VGND VPWR VGND sky130_ef_sc_hd__decap_12
X_2425_ Encode_EN _0176_ _0177_ _0178_ VGND VGND VPWR VPWR _0023_ sky130_fd_sc_hd__a31o_1
XFILLER_142_197 VPWR VGND VPWR VGND sky130_ef_sc_hd__decap_12
XFILLER_97_741 VPWR VGND VPWR VGND sky130_ef_sc_hd__decap_12
XFILLER_69_421 VPWR VGND VPWR VGND sky130_ef_sc_hd__decap_12
XFILLER_111_573 VPWR VGND VPWR VGND sky130_ef_sc_hd__decap_12
XFILLER_97_785 VPWR VGND VPWR VGND sky130_ef_sc_hd__decap_12
XFILLER_96_251 VGND VGND VPWR VPWR sky130_fd_sc_hd__fill_1
XFILLER_84_413 VGND VGND VPWR VPWR sky130_fd_sc_hd__decap_6
X_2356_ _1598_ _1599_ _1595_ VGND VGND VPWR VPWR _0110_ sky130_fd_sc_hd__a21o_1
XFILLER_28_29 VPWR VGND VPWR VGND sky130_ef_sc_hd__decap_12
X_2287_ Encode_EN _1541_ _1542_ _1543_ VGND VGND VPWR VPWR _0019_ sky130_fd_sc_hd__a31o_1
XANTENNA__2865__S _0383_ VGND VGND VPWR VPWR sky130_fd_sc_hd__diode_2
XFILLER_84_457 VPWR VGND VPWR VGND sky130_ef_sc_hd__decap_12
XANTENNA__2456__A2_N _0186_ VGND VGND VPWR VPWR sky130_fd_sc_hd__diode_2
XFILLER_53_833 VGND VGND VPWR VPWR sky130_fd_sc_hd__decap_6
XANTENNA__2166__A A_reg\[13\] VGND VGND VPWR VPWR sky130_fd_sc_hd__diode_2
XFILLER_92_490 VPWR VGND VPWR VGND sky130_ef_sc_hd__decap_12
XFILLER_80_630 VPWR VGND VPWR VGND sky130_ef_sc_hd__decap_12
XANTENNA__2842__A1 A_reg\[8\] VGND VGND VPWR VPWR sky130_fd_sc_hd__diode_2
XFILLER_52_365 VPWR VGND VPWR VGND sky130_ef_sc_hd__decap_12
XFILLER_52_354 VGND VGND VPWR VPWR sky130_fd_sc_hd__decap_8
XTAP_TAPCELL_ROW_23_703 VGND VPWR sky130_fd_sc_hd__tapvpwrvgnd_1
XANTENNA__2055__C1 B_reg\[4\] VGND VGND VPWR VPWR sky130_fd_sc_hd__diode_2
XFILLER_21_741 VPWR VGND VPWR VGND sky130_ef_sc_hd__decap_12
XFILLER_20_251 VGND VGND VPWR VPWR sky130_fd_sc_hd__fill_1
XFILLER_60_49 VPWR VGND VPWR VGND sky130_ef_sc_hd__decap_12
XFILLER_21_785 VPWR VGND VPWR VGND sky130_ef_sc_hd__decap_12
XFILLER_119_673 VPWR VGND VPWR VGND sky130_ef_sc_hd__decap_12
Xclkbuf_3_0__f_clk clknet_0_clk VGND VGND VPWR VPWR clknet_3_0__leaf_clk sky130_fd_sc_hd__clkbuf_16
XFILLER_106_301 VGND VGND VPWR VPWR sky130_fd_sc_hd__decap_6
XFILLER_134_643 VGND VGND VPWR VPWR sky130_fd_sc_hd__fill_1
XFILLER_122_805 VGND VGND VPWR VPWR sky130_fd_sc_hd__decap_6
XFILLER_106_345 VPWR VGND VPWR VGND sky130_ef_sc_hd__decap_12
XFILLER_122_849 VPWR VGND VPWR VGND sky130_ef_sc_hd__decap_12
XFILLER_69_69 VGND VGND VPWR VPWR sky130_fd_sc_hd__decap_6
XFILLER_0_601 VPWR VGND VPWR VGND sky130_ef_sc_hd__decap_12
XFILLER_121_337 VPWR VGND VPWR VGND sky130_ef_sc_hd__decap_12
XFILLER_0_645 VPWR VGND VPWR VGND sky130_ef_sc_hd__decap_12
XTAP_TAPCELL_ROW_50_1137 VGND VPWR sky130_fd_sc_hd__tapvpwrvgnd_1
XTAP_TAPCELL_ROW_50_1126 VGND VPWR sky130_fd_sc_hd__tapvpwrvgnd_1
XTAP_TAPCELL_ROW_145_2654 VGND VPWR sky130_fd_sc_hd__tapvpwrvgnd_1
XFILLER_130_893 VPWR VGND VPWR VGND sky130_ef_sc_hd__decap_12
XFILLER_85_57 VPWR VGND VPWR VGND sky130_ef_sc_hd__decap_12
XANTENNA__3233__Q a_r3\[1\] VGND VGND VPWR VPWR sky130_fd_sc_hd__diode_2
XFILLER_29_841 VPWR VGND VPWR VGND sky130_ef_sc_hd__decap_12
XFILLER_47_137 VPWR VGND VPWR VGND sky130_ef_sc_hd__decap_12
XFILLER_56_693 VGND VGND VPWR VPWR sky130_fd_sc_hd__decap_6
XFILLER_16_513 VPWR VGND VPWR VGND sky130_ef_sc_hd__decap_12
XFILLER_44_811 VGND VGND VPWR VPWR sky130_fd_sc_hd__fill_1
XFILLER_16_557 VPWR VGND VPWR VGND sky130_ef_sc_hd__decap_12
XFILLER_71_685 VPWR VGND VPWR VGND sky130_ef_sc_hd__decap_12
XFILLER_31_505 VPWR VGND VPWR VGND sky130_ef_sc_hd__decap_12
XFILLER_43_354 VGND VGND VPWR VPWR sky130_fd_sc_hd__fill_1
XFILLER_70_184 VGND VGND VPWR VPWR sky130_fd_sc_hd__decap_4
XTAP_TAPCELL_ROW_48_1099 VGND VPWR sky130_fd_sc_hd__tapvpwrvgnd_1
XFILLER_8_701 VPWR VGND VPWR VGND sky130_ef_sc_hd__decap_12
XFILLER_34_83 VGND VGND VPWR VPWR sky130_fd_sc_hd__fill_1
XFILLER_116_109 VPWR VGND VPWR VGND sky130_ef_sc_hd__decap_12
XFILLER_109_161 VGND VGND VPWR VPWR sky130_fd_sc_hd__decap_6
XFILLER_50_82 VGND VGND VPWR VPWR sky130_fd_sc_hd__fill_2
XFILLER_125_665 VGND VGND VPWR VPWR sky130_fd_sc_hd__decap_6
XFILLER_140_613 VPWR VGND VPWR VGND sky130_ef_sc_hd__decap_12
XFILLER_124_153 VPWR VGND VPWR VGND sky130_ef_sc_hd__decap_12
XFILLER_3_472 VGND VGND VPWR VPWR sky130_fd_sc_hd__fill_1
XFILLER_140_657 VPWR VGND VPWR VGND sky130_ef_sc_hd__decap_12
XFILLER_124_197 VPWR VGND VPWR VGND sky130_ef_sc_hd__decap_12
X_2210_ A_reg\[6\] _1463_ VGND VGND VPWR VPWR _1467_ sky130_fd_sc_hd__nand2_1
XFILLER_79_785 VPWR VGND VPWR VGND sky130_ef_sc_hd__decap_12
XFILLER_78_251 VGND VGND VPWR VPWR sky130_fd_sc_hd__fill_1
XFILLER_78_240 VGND VGND VPWR VPWR sky130_fd_sc_hd__fill_1
X_3190_ _0834_ _0846_ _0864_ _0912_ VGND VGND VPWR VPWR _0873_ sky130_fd_sc_hd__a31o_1
XFILLER_94_755 VGND VGND VPWR VPWR sky130_fd_sc_hd__fill_1
X_2141_ B_reg\[1\] _1399_ VGND VGND VPWR VPWR _1400_ sky130_fd_sc_hd__and2_1
X_2072_ _1324_ _1328_ _1331_ _1326_ VGND VGND VPWR VPWR _1334_ sky130_fd_sc_hd__a22o_1
XFILLER_66_457 VPWR VGND VPWR VGND sky130_ef_sc_hd__decap_12
XFILLER_34_321 VPWR VGND VPWR VGND sky130_ef_sc_hd__decap_12
XFILLER_50_825 VPWR VGND VPWR VGND sky130_ef_sc_hd__decap_12
XFILLER_34_365 VPWR VGND VPWR VGND sky130_ef_sc_hd__decap_12
XFILLER_35_877 VPWR VGND VPWR VGND sky130_ef_sc_hd__decap_12
XANTENNA__2714__A a_r3\[3\] VGND VGND VPWR VPWR sky130_fd_sc_hd__diode_2
X_2974_ _0646_ _0661_ VGND VGND VPWR VPWR _0662_ sky130_fd_sc_hd__nand2b_1
XFILLER_50_869 VPWR VGND VPWR VGND sky130_ef_sc_hd__decap_12
XTAP_TAPCELL_ROW_17_596 VGND VPWR sky130_fd_sc_hd__tapvpwrvgnd_1
XFILLER_148_713 VPWR VGND VPWR VGND sky130_ef_sc_hd__decap_12
X_1925_ _0900_ _1185_ _1186_ _1187_ _1189_ VGND VGND VPWR VPWR _1190_ sky130_fd_sc_hd__a221oi_4
XFILLER_148_757 VPWR VGND VPWR VGND sky130_ef_sc_hd__decap_12
XFILLER_147_223 VGND VGND VPWR VPWR sky130_fd_sc_hd__fill_1
X_1856_ A_reg\[9\] _1124_ _1123_ VGND VGND VPWR VPWR _1126_ sky130_fd_sc_hd__a21oi_1
XFILLER_135_429 VPWR VGND VPWR VGND sky130_ef_sc_hd__decap_12
XTAP_TAPCELL_ROW_96_1863 VGND VPWR sky130_fd_sc_hd__tapvpwrvgnd_1
X_1787_ _1052_ _1059_ _1047_ VGND VGND VPWR VPWR _1060_ sky130_fd_sc_hd__mux2_1
XFILLER_116_643 VGND VGND VPWR VPWR sky130_fd_sc_hd__fill_1
XTAP_TAPCELL_ROW_112_2119 VGND VPWR sky130_fd_sc_hd__tapvpwrvgnd_1
XFILLER_104_805 VGND VGND VPWR VPWR sky130_fd_sc_hd__decap_6
XTAP_TAPCELL_ROW_96_1874 VGND VPWR sky130_fd_sc_hd__tapvpwrvgnd_1
XFILLER_89_505 VPWR VGND VPWR VGND sky130_ef_sc_hd__decap_12
XFILLER_143_473 VPWR VGND VPWR VGND sky130_ef_sc_hd__decap_12
XFILLER_104_849 VPWR VGND VPWR VGND sky130_ef_sc_hd__decap_12
XFILLER_103_337 VPWR VGND VPWR VGND sky130_ef_sc_hd__decap_12
XFILLER_39_39 VPWR VGND VPWR VGND sky130_ef_sc_hd__decap_12
X_2408_ _0909_ _0158_ _0160_ VGND VGND VPWR VPWR _0162_ sky130_fd_sc_hd__or3_1
XFILLER_130_189 VGND VGND VPWR VPWR sky130_fd_sc_hd__decap_6
XFILLER_112_893 VPWR VGND VPWR VGND sky130_ef_sc_hd__decap_12
XFILLER_84_221 VPWR VGND VPWR VGND sky130_ef_sc_hd__decap_12
X_2339_ _1590_ _1591_ VGND VGND VPWR VPWR _1592_ sky130_fd_sc_hd__nor2_1
XTAP_TAPCELL_ROW_127_2362 VGND VPWR sky130_fd_sc_hd__tapvpwrvgnd_1
XFILLER_85_777 VGND VGND VPWR VPWR sky130_fd_sc_hd__decap_6
XFILLER_57_446 VGND VGND VPWR VPWR sky130_fd_sc_hd__fill_2
XPHY_EDGE_ROW_2_Right_2 VGND VGND VPWR VPWR sky130_fd_sc_hd__decap_3
XFILLER_29_137 VPWR VGND VPWR VGND sky130_ef_sc_hd__decap_12
XFILLER_84_298 VGND VGND VPWR VPWR sky130_fd_sc_hd__decap_8
XANTENNA__3317__RESET_B net36 VGND VGND VPWR VPWR sky130_fd_sc_hd__diode_2
XFILLER_26_811 VGND VGND VPWR VPWR sky130_fd_sc_hd__fill_1
XFILLER_53_641 VGND VGND VPWR VPWR sky130_fd_sc_hd__decap_8
XFILLER_25_321 VGND VGND VPWR VPWR sky130_fd_sc_hd__fill_1
XFILLER_37_181 VPWR VGND VPWR VGND sky130_ef_sc_hd__decap_12
XFILLER_38_693 VGND VGND VPWR VPWR sky130_fd_sc_hd__decap_6
XTAP_TAPCELL_ROW_140_2573 VGND VPWR sky130_fd_sc_hd__tapvpwrvgnd_1
XFILLER_111_55 VGND VGND VPWR VPWR sky130_fd_sc_hd__fill_1
XFILLER_80_471 VGND VGND VPWR VPWR sky130_fd_sc_hd__decap_4
XFILLER_53_685 VPWR VGND VPWR VGND sky130_ef_sc_hd__decap_12
XPHY_EDGE_ROW_9_Left_163 VGND VGND VPWR VPWR sky130_fd_sc_hd__decap_3
XFILLER_13_505 VPWR VGND VPWR VGND sky130_ef_sc_hd__decap_12
XFILLER_41_814 VGND VGND VPWR VPWR sky130_fd_sc_hd__decap_3
XFILLER_71_15 VPWR VGND VPWR VGND sky130_ef_sc_hd__decap_12
XFILLER_25_387 VGND VGND VPWR VPWR sky130_fd_sc_hd__decap_4
XFILLER_138_245 VGND VGND VPWR VPWR sky130_fd_sc_hd__decap_6
XFILLER_153_237 VPWR VGND VPWR VGND sky130_ef_sc_hd__decap_12
XFILLER_138_289 VPWR VGND VPWR VGND sky130_ef_sc_hd__decap_12
XFILLER_112_3 VPWR VGND VPWR VGND sky130_ef_sc_hd__decap_12
XFILLER_107_665 VGND VGND VPWR VPWR sky130_fd_sc_hd__decap_6
XFILLER_20_41 VPWR VGND VPWR VGND sky130_ef_sc_hd__decap_12
XFILLER_136_41 VPWR VGND VPWR VGND sky130_ef_sc_hd__decap_12
XFILLER_122_613 VPWR VGND VPWR VGND sky130_ef_sc_hd__decap_12
XFILLER_106_153 VPWR VGND VPWR VGND sky130_ef_sc_hd__decap_12
XFILLER_20_85 VPWR VGND VPWR VGND sky130_ef_sc_hd__decap_12
XFILLER_136_85 VPWR VGND VPWR VGND sky130_ef_sc_hd__decap_12
XFILLER_122_657 VPWR VGND VPWR VGND sky130_ef_sc_hd__decap_12
XFILLER_106_197 VPWR VGND VPWR VGND sky130_ef_sc_hd__decap_12
XFILLER_121_167 VGND VGND VPWR VPWR sky130_fd_sc_hd__fill_1
XFILLER_95_519 VPWR VGND VPWR VGND sky130_ef_sc_hd__decap_12
XANTENNA_input32_A B_in[9] VGND VGND VPWR VPWR sky130_fd_sc_hd__diode_2
XFILLER_0_475 VGND VGND VPWR VPWR sky130_fd_sc_hd__fill_1
XFILLER_63_416 VPWR VGND VPWR VGND sky130_ef_sc_hd__decap_12
XFILLER_29_671 VGND VGND VPWR VPWR sky130_fd_sc_hd__fill_1
XFILLER_90_246 VGND VGND VPWR VPWR sky130_fd_sc_hd__decap_6
XFILLER_17_833 VGND VGND VPWR VPWR sky130_fd_sc_hd__decap_6
XFILLER_44_641 VGND VGND VPWR VPWR sky130_fd_sc_hd__decap_3
XFILLER_16_365 VPWR VGND VPWR VGND sky130_ef_sc_hd__decap_12
XFILLER_17_877 VPWR VGND VPWR VGND sky130_ef_sc_hd__decap_12
XFILLER_91_8 VGND VGND VPWR VPWR sky130_fd_sc_hd__decap_8
XTAP_TAPCELL_ROW_63_1339 VGND VPWR sky130_fd_sc_hd__tapvpwrvgnd_1
XFILLER_45_93 VPWR VGND VPWR VGND sky130_ef_sc_hd__decap_12
XTAP_TAPCELL_ROW_14_555 VGND VPWR sky130_fd_sc_hd__tapvpwrvgnd_1
XFILLER_32_869 VGND VGND VPWR VPWR sky130_fd_sc_hd__decap_8
XFILLER_129_223 VGND VGND VPWR VPWR sky130_fd_sc_hd__fill_1
XFILLER_8_531 VGND VGND VPWR VPWR sky130_fd_sc_hd__fill_1
XFILLER_145_727 VGND VGND VPWR VPWR sky130_fd_sc_hd__fill_1
X_2690_ _0429_ VGND VGND VPWR VPWR _0430_ sky130_fd_sc_hd__inv_2
X_1710_ _0972_ _0985_ VGND VGND VPWR VPWR _0986_ sky130_fd_sc_hd__xnor2_1
XFILLER_117_429 VPWR VGND VPWR VGND sky130_ef_sc_hd__decap_12
X_1641_ _0887_ A_reg\[14\] VGND VGND VPWR VPWR _0917_ sky130_fd_sc_hd__and2_1
XANTENNA__3292__CLK clknet_3_2__leaf_clk VGND VGND VPWR VPWR sky130_fd_sc_hd__diode_2
XTAP_TAPCELL_ROW_78_1582 VGND VPWR sky130_fd_sc_hd__tapvpwrvgnd_1
XFILLER_6_65 VPWR VGND VPWR VGND sky130_ef_sc_hd__decap_12
XFILLER_125_473 VPWR VGND VPWR VGND sky130_ef_sc_hd__decap_12
X_3311_ clknet_3_7__leaf_clk _0094_ net36 VGND VGND VPWR VPWR X_crt\[5\] sky130_fd_sc_hd__dfrtp_1
XFILLER_140_421 VPWR VGND VPWR VGND sky130_ef_sc_hd__decap_12
XFILLER_4_781 VPWR VGND VPWR VGND sky130_ef_sc_hd__decap_12
XFILLER_100_307 VGND VGND VPWR VPWR sky130_fd_sc_hd__fill_1
XTAP_TAPCELL_ROW_91_1793 VGND VPWR sky130_fd_sc_hd__tapvpwrvgnd_1
XTAP_TAPCELL_ROW_91_1782 VGND VPWR sky130_fd_sc_hd__tapvpwrvgnd_1
X_3242_ clknet_3_6__leaf_clk _0027_ net36 VGND VGND VPWR VPWR u_crt.r0\[0\] sky130_fd_sc_hd__dfrtp_1
XFILLER_67_700 VPWR VGND VPWR VGND sky130_ef_sc_hd__decap_12
XFILLER_112_189 VGND VGND VPWR VPWR sky130_fd_sc_hd__decap_6
X_3173_ X_crt\[0\] _0912_ VGND VGND VPWR VPWR _0861_ sky130_fd_sc_hd__nand2_1
XFILLER_39_424 VGND VGND VPWR VPWR sky130_fd_sc_hd__fill_2
XFILLER_39_435 VPWR VGND VPWR VGND sky130_ef_sc_hd__decap_12
XFILLER_94_563 VGND VGND VPWR VPWR sky130_fd_sc_hd__fill_1
X_2124_ _1380_ _1381_ B_reg\[6\] VGND VGND VPWR VPWR _1383_ sky130_fd_sc_hd__mux2_1
XANTENNA__1613__A A_reg\[6\] VGND VGND VPWR VPWR sky130_fd_sc_hd__diode_2
XTAP_TAPCELL_ROW_109_2081 VGND VPWR sky130_fd_sc_hd__tapvpwrvgnd_1
XTAP_TAPCELL_ROW_109_2070 VGND VPWR sky130_fd_sc_hd__tapvpwrvgnd_1
XFILLER_82_736 VPWR VGND VPWR VGND sky130_ef_sc_hd__decap_12
XFILLER_66_265 VPWR VGND VPWR VGND sky130_ef_sc_hd__decap_12
X_2055_ B_reg\[5\] _1307_ _1310_ _1314_ B_reg\[4\] VGND VGND VPWR VPWR _1317_ sky130_fd_sc_hd__a311o_1
XFILLER_82_769 VPWR VGND VPWR VGND sky130_ef_sc_hd__decap_12
XFILLER_70_909 VGND VGND VPWR VPWR sky130_fd_sc_hd__fill_1
XFILLER_19_181 VPWR VGND VPWR VGND sky130_ef_sc_hd__decap_12
XANTENNA__3250__D CRT_Start VGND VGND VPWR VPWR sky130_fd_sc_hd__diode_2
XFILLER_35_641 VPWR VGND VPWR VGND sky130_ef_sc_hd__decap_12
XFILLER_81_279 VGND VGND VPWR VPWR sky130_fd_sc_hd__fill_1
XTAP_TAPCELL_ROW_122_2281 VGND VPWR sky130_fd_sc_hd__tapvpwrvgnd_1
XFILLER_35_685 VPWR VGND VPWR VGND sky130_ef_sc_hd__decap_12
XFILLER_50_677 VGND VGND VPWR VPWR sky130_fd_sc_hd__fill_1
XTAP_TAPCELL_ROW_33_853 VGND VPWR sky130_fd_sc_hd__tapvpwrvgnd_1
XFILLER_34_195 VGND VGND VPWR VPWR sky130_fd_sc_hd__fill_1
XTAP_TAPCELL_ROW_33_864 VGND VPWR sky130_fd_sc_hd__tapvpwrvgnd_1
XTAP_TAPCELL_ROW_98_1903 VGND VPWR sky130_fd_sc_hd__tapvpwrvgnd_1
X_2957_ _0628_ _0643_ VGND VGND VPWR VPWR _0645_ sky130_fd_sc_hd__xnor2_1
XFILLER_50_699 VGND VGND VPWR VPWR sky130_fd_sc_hd__fill_1
X_2888_ _0573_ _0575_ VGND VGND VPWR VPWR _0576_ sky130_fd_sc_hd__nor2_1
X_1908_ B_reg\[12\] _1169_ _1171_ VGND VGND VPWR VPWR _1173_ sky130_fd_sc_hd__o21ai_1
XFILLER_148_587 VGND VGND VPWR VPWR sky130_fd_sc_hd__fill_1
XFILLER_136_749 VGND VGND VPWR VPWR sky130_fd_sc_hd__decap_6
XANTENNA__1784__A1 A_reg\[7\] VGND VGND VPWR VPWR sky130_fd_sc_hd__diode_2
X_1839_ _1102_ _1106_ _1103_ VGND VGND VPWR VPWR _1110_ sky130_fd_sc_hd__o21bai_1
XFILLER_135_237 VPWR VGND VPWR VGND sky130_ef_sc_hd__decap_12
XFILLER_104_613 VPWR VGND VPWR VGND sky130_ef_sc_hd__decap_12
XFILLER_89_313 VPWR VGND VPWR VGND sky130_ef_sc_hd__decap_12
XFILLER_144_793 VPWR VGND VPWR VGND sky130_ef_sc_hd__decap_12
XFILLER_143_281 VPWR VGND VPWR VGND sky130_ef_sc_hd__decap_12
XFILLER_104_657 VPWR VGND VPWR VGND sky130_ef_sc_hd__decap_12
XFILLER_1_217 VGND VGND VPWR VPWR sky130_fd_sc_hd__decap_6
XTAP_TAPCELL_ROW_129_2402 VGND VPWR sky130_fd_sc_hd__tapvpwrvgnd_1
XFILLER_103_167 VGND VGND VPWR VPWR sky130_fd_sc_hd__fill_1
XFILLER_106_77 VGND VGND VPWR VPWR sky130_fd_sc_hd__decap_6
XFILLER_58_744 VPWR VGND VPWR VGND sky130_ef_sc_hd__decap_12
XFILLER_57_210 VPWR VGND VPWR VGND sky130_ef_sc_hd__decap_12
XTAP_TAPCELL_ROW_142_2602 VGND VPWR sky130_fd_sc_hd__tapvpwrvgnd_1
XFILLER_85_552 VGND VGND VPWR VPWR sky130_fd_sc_hd__decap_8
XPHY_EDGE_ROW_142_Right_142 VGND VGND VPWR VPWR sky130_fd_sc_hd__decap_3
XFILLER_85_585 VPWR VGND VPWR VGND sky130_ef_sc_hd__decap_12
XFILLER_73_714 VPWR VGND VPWR VGND sky130_ef_sc_hd__decap_12
XFILLER_57_276 VGND VGND VPWR VPWR sky130_fd_sc_hd__decap_4
XFILLER_57_265 VGND VGND VPWR VPWR sky130_fd_sc_hd__fill_1
XFILLER_45_405 VPWR VGND VPWR VGND sky130_ef_sc_hd__decap_12
XFILLER_122_65 VPWR VGND VPWR VGND sky130_ef_sc_hd__decap_12
XFILLER_45_449 VPWR VGND VPWR VGND sky130_ef_sc_hd__decap_12
XFILLER_60_419 VGND VGND VPWR VPWR sky130_fd_sc_hd__fill_1
XFILLER_53_471 VGND VGND VPWR VPWR sky130_fd_sc_hd__fill_1
XFILLER_14_825 VPWR VGND VPWR VGND sky130_ef_sc_hd__decap_12
XFILLER_13_368 VPWR VGND VPWR VGND sky130_ef_sc_hd__decap_12
XFILLER_14_869 VPWR VGND VPWR VGND sky130_ef_sc_hd__decap_12
XFILLER_40_121 VPWR VGND VPWR VGND sky130_ef_sc_hd__decap_12
XFILLER_41_677 VGND VGND VPWR VPWR sky130_fd_sc_hd__fill_1
XTAP_TAPCELL_ROW_45_1047 VGND VPWR sky130_fd_sc_hd__tapvpwrvgnd_1
XTAP_TAPCELL_ROW_45_1058 VGND VPWR sky130_fd_sc_hd__tapvpwrvgnd_1
XTAP_TAPCELL_ROW_11_503 VGND VPWR sky130_fd_sc_hd__tapvpwrvgnd_1
XFILLER_9_317 VPWR VGND VPWR VGND sky130_ef_sc_hd__decap_12
XTAP_TAPCELL_ROW_11_514 VGND VPWR sky130_fd_sc_hd__tapvpwrvgnd_1
XFILLER_41_688 VPWR VGND VPWR VGND sky130_ef_sc_hd__decap_12
XANTENNA__2641__X _0383_ VGND VGND VPWR VPWR sky130_fd_sc_hd__diode_2
XFILLER_127_727 VGND VGND VPWR VPWR sky130_fd_sc_hd__fill_1
XFILLER_31_51 VGND VGND VPWR VPWR sky130_fd_sc_hd__decap_4
XTAP_TAPCELL_ROW_153_2797 VGND VPWR sky130_fd_sc_hd__tapvpwrvgnd_1
XTAP_TAPCELL_ROW_153_2786 VGND VPWR sky130_fd_sc_hd__tapvpwrvgnd_1
XTAP_TAPCELL_ROW_153_2775 VGND VPWR sky130_fd_sc_hd__tapvpwrvgnd_1
XFILLER_147_51 VGND VGND VPWR VPWR sky130_fd_sc_hd__decap_4
XFILLER_122_421 VPWR VGND VPWR VGND sky130_ef_sc_hd__decap_12
Xoutput40 net40 VGND VGND VPWR VPWR X_out[11] sky130_fd_sc_hd__buf_1
Xoutput51 net51 VGND VGND VPWR VPWR X_out[7] sky130_fd_sc_hd__buf_1
XFILLER_95_305 VGND VGND VPWR VPWR sky130_fd_sc_hd__decap_4
XANTENNA__3239__RESET_B net36 VGND VGND VPWR VPWR sky130_fd_sc_hd__diode_2
XANTENNA_input35_X net35 VGND VGND VPWR VPWR sky130_fd_sc_hd__diode_2
XFILLER_95_349 VPWR VGND VPWR VGND sky130_ef_sc_hd__decap_12
XFILLER_48_221 VPWR VGND VPWR VGND sky130_ef_sc_hd__decap_12
XFILLER_64_725 VPWR VGND VPWR VGND sky130_ef_sc_hd__decap_12
XFILLER_48_265 VPWR VGND VPWR VGND sky130_ef_sc_hd__decap_12
XFILLER_17_641 VPWR VGND VPWR VGND sky130_ef_sc_hd__decap_12
XTAP_TAPCELL_ROW_19_636 VGND VPWR sky130_fd_sc_hd__tapvpwrvgnd_1
XFILLER_63_279 VGND VGND VPWR VPWR sky130_fd_sc_hd__fill_1
XFILLER_17_685 VPWR VGND VPWR VGND sky130_ef_sc_hd__decap_12
XFILLER_16_195 VGND VGND VPWR VPWR sky130_fd_sc_hd__fill_1
XFILLER_149_329 VGND VGND VPWR VPWR sky130_fd_sc_hd__decap_6
X_2811_ _0537_ _0542_ _0547_ _0548_ VGND VGND VPWR VPWR _0549_ sky130_fd_sc_hd__a22o_1
XTAP_TAPCELL_ROW_30_812 VGND VPWR sky130_fd_sc_hd__tapvpwrvgnd_1
XFILLER_32_699 VGND VGND VPWR VPWR sky130_fd_sc_hd__fill_1
X_2742_ _0477_ _0478_ _0479_ _0480_ VGND VGND VPWR VPWR _0482_ sky130_fd_sc_hd__o31a_1
XFILLER_118_749 VGND VGND VPWR VPWR sky130_fd_sc_hd__decap_6
XFILLER_9_895 VGND VGND VPWR VPWR sky130_fd_sc_hd__fill_1
XFILLER_117_237 VPWR VGND VPWR VGND sky130_ef_sc_hd__decap_12
X_2673_ a_r3\[1\] b_r3\[1\] _0384_ VGND VGND VPWR VPWR _0413_ sky130_fd_sc_hd__o21a_1
XANTENNA__1608__A A_reg\[11\] VGND VGND VPWR VPWR sky130_fd_sc_hd__diode_2
XTAP_TAPCELL_ROW_93_1822 VGND VPWR sky130_fd_sc_hd__tapvpwrvgnd_1
X_1624_ B_reg\[6\] VGND VGND VPWR VPWR _0904_ sky130_fd_sc_hd__inv_2
XFILLER_141_741 VPWR VGND VPWR VGND sky130_ef_sc_hd__decap_12
XFILLER_126_793 VPWR VGND VPWR VGND sky130_ef_sc_hd__decap_12
XFILLER_125_281 VPWR VGND VPWR VGND sky130_ef_sc_hd__decap_12
XPHY_EDGE_ROW_99_Right_99 VGND VGND VPWR VPWR sky130_fd_sc_hd__decap_3
XFILLER_98_121 VPWR VGND VPWR VGND sky130_ef_sc_hd__decap_12
XFILLER_140_251 VGND VGND VPWR VPWR sky130_fd_sc_hd__fill_1
XFILLER_98_165 VPWR VGND VPWR VGND sky130_ef_sc_hd__decap_12
XFILLER_141_785 VPWR VGND VPWR VGND sky130_ef_sc_hd__decap_12
XFILLER_87_839 VGND VGND VPWR VPWR sky130_fd_sc_hd__fill_1
X_3225_ clknet_3_3__leaf_clk _0012_ net36 VGND VGND VPWR VPWR b_r2\[1\] sky130_fd_sc_hd__dfrtp_4
XFILLER_67_541 VPWR VGND VPWR VGND sky130_ef_sc_hd__decap_12
XTAP_TAPCELL_ROW_124_2321 VGND VPWR sky130_fd_sc_hd__tapvpwrvgnd_1
XTAP_TAPCELL_ROW_124_2310 VGND VPWR sky130_fd_sc_hd__tapvpwrvgnd_1
XFILLER_67_585 VGND VGND VPWR VPWR sky130_fd_sc_hd__decap_6
XFILLER_39_254 VGND VGND VPWR VPWR sky130_fd_sc_hd__decap_4
X_3156_ _0790_ _0806_ VGND VGND VPWR VPWR _0844_ sky130_fd_sc_hd__xor2_1
XFILLER_82_533 VGND VGND VPWR VPWR sky130_fd_sc_hd__decap_4
X_2107_ B_reg\[11\] _1364_ _1365_ _1363_ VGND VGND VPWR VPWR _1366_ sky130_fd_sc_hd__a211oi_1
XFILLER_36_29 VPWR VGND VPWR VGND sky130_ef_sc_hd__decap_12
XTAP_TAPCELL_ROW_38_934 VGND VPWR sky130_fd_sc_hd__tapvpwrvgnd_1
XTAP_TAPCELL_ROW_38_945 VGND VPWR sky130_fd_sc_hd__tapvpwrvgnd_1
X_3087_ _0757_ _0774_ VGND VGND VPWR VPWR _0775_ sky130_fd_sc_hd__nor2_1
XFILLER_43_909 VGND VGND VPWR VPWR sky130_fd_sc_hd__fill_1
X_2038_ B_reg\[7\] _1292_ _1297_ _1299_ VGND VGND VPWR VPWR _1300_ sky130_fd_sc_hd__a31o_1
XANTENNA__1630__X _0910_ VGND VGND VPWR VPWR sky130_fd_sc_hd__diode_2
XFILLER_42_419 VGND VGND VPWR VPWR sky130_fd_sc_hd__fill_1
XFILLER_22_121 VPWR VGND VPWR VGND sky130_ef_sc_hd__decap_12
XFILLER_149_841 VPWR VGND VPWR VGND sky130_ef_sc_hd__decap_12
XTAP_TAPCELL_ROW_102_1962 VGND VPWR sky130_fd_sc_hd__tapvpwrvgnd_1
XFILLER_11_839 VGND VGND VPWR VPWR sky130_fd_sc_hd__fill_1
XFILLER_22_165 VPWR VGND VPWR VGND sky130_ef_sc_hd__decap_12
XPHY_EDGE_ROW_99_Left_253 VGND VGND VPWR VPWR sky130_fd_sc_hd__decap_3
XFILLER_136_513 VPWR VGND VPWR VGND sky130_ef_sc_hd__decap_12
XFILLER_109_727 VGND VGND VPWR VPWR sky130_fd_sc_hd__fill_1
XFILLER_6_309 VPWR VGND VPWR VGND sky130_ef_sc_hd__decap_12
XFILLER_136_557 VPWR VGND VPWR VGND sky130_ef_sc_hd__decap_12
XFILLER_151_505 VPWR VGND VPWR VGND sky130_ef_sc_hd__decap_12
XTAP_TAPCELL_ROW_135_2494 VGND VPWR sky130_fd_sc_hd__tapvpwrvgnd_1
XFILLER_104_421 VPWR VGND VPWR VGND sky130_ef_sc_hd__decap_12
XFILLER_131_273 VGND VGND VPWR VPWR sky130_fd_sc_hd__decap_6
XFILLER_77_69 VGND VGND VPWR VPWR sky130_fd_sc_hd__decap_8
XFILLER_93_809 VPWR VGND VPWR VGND sky130_ef_sc_hd__decap_12
XFILLER_86_861 VGND VGND VPWR VPWR sky130_fd_sc_hd__decap_6
XFILLER_77_349 VPWR VGND VPWR VGND sky130_ef_sc_hd__decap_12
XFILLER_73_500 VGND VGND VPWR VPWR sky130_fd_sc_hd__decap_4
XFILLER_58_563 VGND VGND VPWR VPWR sky130_fd_sc_hd__fill_1
XFILLER_46_725 VPWR VGND VPWR VGND sky130_ef_sc_hd__decap_12
XFILLER_100_693 VGND VGND VPWR VPWR sky130_fd_sc_hd__decap_6
XFILLER_93_57 VPWR VGND VPWR VGND sky130_ef_sc_hd__decap_12
XFILLER_85_393 VPWR VGND VPWR VGND sky130_ef_sc_hd__decap_12
XFILLER_46_769 VPWR VGND VPWR VGND sky130_ef_sc_hd__decap_12
XFILLER_45_235 VGND VGND VPWR VPWR sky130_fd_sc_hd__fill_1
XFILLER_54_780 VPWR VGND VPWR VGND sky130_ef_sc_hd__decap_12
XFILLER_45_279 VGND VGND VPWR VPWR sky130_fd_sc_hd__fill_1
XFILLER_9_125 VPWR VGND VPWR VGND sky130_ef_sc_hd__decap_12
XFILLER_14_699 VGND VGND VPWR VPWR sky130_fd_sc_hd__fill_1
XFILLER_41_485 VPWR VGND VPWR VGND sky130_ef_sc_hd__decap_12
XFILLER_139_373 VPWR VGND VPWR VGND sky130_ef_sc_hd__decap_12
XFILLER_10_861 VGND VGND VPWR VPWR sky130_fd_sc_hd__decap_6
XFILLER_9_169 VPWR VGND VPWR VGND sky130_ef_sc_hd__decap_12
XFILLER_42_83 VGND VGND VPWR VPWR sky130_fd_sc_hd__fill_1
XFILLER_5_331 VGND VGND VPWR VPWR sky130_fd_sc_hd__decap_4
XTAP_TAPCELL_ROW_75_1530 VGND VPWR sky130_fd_sc_hd__tapvpwrvgnd_1
XFILLER_5_353 VPWR VGND VPWR VGND sky130_ef_sc_hd__decap_12
XFILLER_108_793 VPWR VGND VPWR VGND sky130_ef_sc_hd__decap_12
XFILLER_107_281 VPWR VGND VPWR VGND sky130_ef_sc_hd__decap_12
XFILLER_123_741 VPWR VGND VPWR VGND sky130_ef_sc_hd__decap_12
XFILLER_123_785 VPWR VGND VPWR VGND sky130_ef_sc_hd__decap_12
XFILLER_122_251 VGND VGND VPWR VPWR sky130_fd_sc_hd__fill_1
XFILLER_110_413 VGND VGND VPWR VPWR sky130_fd_sc_hd__decap_6
XFILLER_96_625 VPWR VGND VPWR VGND sky130_ef_sc_hd__decap_12
XFILLER_95_113 VPWR VGND VPWR VGND sky130_ef_sc_hd__decap_12
XFILLER_69_839 VGND VGND VPWR VPWR sky130_fd_sc_hd__fill_1
XFILLER_68_305 VGND VGND VPWR VPWR sky130_fd_sc_hd__decap_3
XFILLER_3_55 VGND VGND VPWR VPWR sky130_fd_sc_hd__fill_1
XFILLER_96_669 VPWR VGND VPWR VGND sky130_ef_sc_hd__decap_12
XFILLER_49_541 VPWR VGND VPWR VGND sky130_ef_sc_hd__decap_12
X_3010_ _0695_ _0696_ VGND VGND VPWR VPWR _0698_ sky130_fd_sc_hd__xnor2_1
XFILLER_49_574 VPWR VGND VPWR VGND sky130_ef_sc_hd__decap_12
XFILLER_64_522 VGND VGND VPWR VPWR sky130_fd_sc_hd__fill_2
XFILLER_25_909 VGND VGND VPWR VPWR sky130_fd_sc_hd__fill_1
XFILLER_149_137 VPWR VGND VPWR VGND sky130_ef_sc_hd__decap_12
XFILLER_20_625 VPWR VGND VPWR VGND sky130_ef_sc_hd__decap_12
XFILLER_146_811 VGND VGND VPWR VPWR sky130_fd_sc_hd__fill_1
XFILLER_118_513 VPWR VGND VPWR VGND sky130_ef_sc_hd__decap_12
XFILLER_20_669 VPWR VGND VPWR VGND sky130_ef_sc_hd__decap_12
XFILLER_118_557 VPWR VGND VPWR VGND sky130_ef_sc_hd__decap_12
X_2725_ _0462_ _0464_ VGND VGND VPWR VPWR _0465_ sky130_fd_sc_hd__and2_1
XFILLER_133_505 VPWR VGND VPWR VGND sky130_ef_sc_hd__decap_12
X_2656_ b_r3\[3\] _0395_ VGND VGND VPWR VPWR _0396_ sky130_fd_sc_hd__xnor2_1
X_1607_ A_reg\[15\] VGND VGND VPWR VPWR _0887_ sky130_fd_sc_hd__inv_2
XFILLER_99_441 VGND VGND VPWR VPWR sky130_fd_sc_hd__decap_6
X_2587_ _0327_ _0331_ b_r2\[1\] VGND VGND VPWR VPWR _0332_ sky130_fd_sc_hd__a21oi_1
XFILLER_113_273 VGND VGND VPWR VPWR sky130_fd_sc_hd__decap_6
XFILLER_87_614 VGND VGND VPWR VPWR sky130_fd_sc_hd__fill_2
XFILLER_86_124 VPWR VGND VPWR VGND sky130_ef_sc_hd__decap_12
XFILLER_75_809 VPWR VGND VPWR VGND sky130_ef_sc_hd__decap_12
XFILLER_59_349 VPWR VGND VPWR VGND sky130_ef_sc_hd__decap_12
XFILLER_68_861 VGND VGND VPWR VPWR sky130_fd_sc_hd__decap_6
X_3208_ X_crt\[12\] _0912_ VGND VGND VPWR VPWR _0101_ sky130_fd_sc_hd__and2_1
XFILLER_28_725 VPWR VGND VPWR VGND sky130_ef_sc_hd__decap_12
XFILLER_47_39 VPWR VGND VPWR VGND sky130_ef_sc_hd__decap_12
XFILLER_83_853 VPWR VGND VPWR VGND sky130_ef_sc_hd__decap_12
XFILLER_67_393 VPWR VGND VPWR VGND sky130_ef_sc_hd__decap_12
XFILLER_67_382 VGND VGND VPWR VPWR sky130_fd_sc_hd__decap_8
XFILLER_55_511 VGND VGND VPWR VPWR sky130_fd_sc_hd__fill_1
X_3139_ _0826_ VGND VGND VPWR VPWR _0827_ sky130_fd_sc_hd__inv_2
XTAP_TAPCELL_ROW_2_356 VGND VPWR sky130_fd_sc_hd__tapvpwrvgnd_1
XFILLER_27_213 VGND VGND VPWR VPWR sky130_fd_sc_hd__decap_3
XFILLER_82_330 VGND VGND VPWR VPWR sky130_fd_sc_hd__decap_8
XFILLER_70_503 VPWR VGND VPWR VGND sky130_ef_sc_hd__decap_12
XTAP_TAPCELL_ROW_2_367 VGND VPWR sky130_fd_sc_hd__tapvpwrvgnd_1
XFILLER_16_909 VGND VGND VPWR VPWR sky130_fd_sc_hd__fill_1
XFILLER_27_246 VPWR VGND VPWR VGND sky130_ef_sc_hd__decap_12
XFILLER_28_769 VPWR VGND VPWR VGND sky130_ef_sc_hd__decap_12
XFILLER_83_897 VPWR VGND VPWR VGND sky130_ef_sc_hd__decap_12
XFILLER_70_558 VGND VGND VPWR VPWR sky130_fd_sc_hd__fill_1
XANTENNA__1978__A1 B_reg\[1\] VGND VGND VPWR VPWR sky130_fd_sc_hd__diode_2
XFILLER_51_783 VGND VGND VPWR VPWR sky130_fd_sc_hd__fill_1
XTAP_TAPCELL_ROW_42_1006 VGND VPWR sky130_fd_sc_hd__tapvpwrvgnd_1
XTAP_TAPCELL_ROW_137_2523 VGND VPWR sky130_fd_sc_hd__tapvpwrvgnd_1
XFILLER_23_485 VPWR VGND VPWR VGND sky130_ef_sc_hd__decap_12
XFILLER_149_671 VGND VGND VPWR VPWR sky130_fd_sc_hd__fill_1
XFILLER_137_833 VGND VGND VPWR VPWR sky130_fd_sc_hd__decap_6
XFILLER_7_629 VPWR VGND VPWR VGND sky130_ef_sc_hd__decap_12
XTAP_TAPCELL_ROW_21_664 VGND VPWR sky130_fd_sc_hd__tapvpwrvgnd_1
XFILLER_136_321 VPWR VGND VPWR VGND sky130_ef_sc_hd__decap_12
XFILLER_6_139 VGND VGND VPWR VPWR sky130_fd_sc_hd__fill_1
XFILLER_12_53 VPWR VGND VPWR VGND sky130_ef_sc_hd__decap_12
XTAP_TAPCELL_ROW_21_675 VGND VPWR sky130_fd_sc_hd__tapvpwrvgnd_1
XFILLER_152_825 VPWR VGND VPWR VGND sky130_ef_sc_hd__decap_12
XTAP_TAPCELL_ROW_150_2734 VGND VPWR sky130_fd_sc_hd__tapvpwrvgnd_1
XFILLER_137_877 VPWR VGND VPWR VGND sky130_ef_sc_hd__decap_12
XFILLER_136_365 VPWR VGND VPWR VGND sky130_ef_sc_hd__decap_12
XFILLER_128_53 VPWR VGND VPWR VGND sky130_ef_sc_hd__decap_12
XFILLER_12_97 VPWR VGND VPWR VGND sky130_ef_sc_hd__decap_12
XFILLER_151_335 VGND VGND VPWR VPWR sky130_fd_sc_hd__fill_1
XFILLER_128_97 VPWR VGND VPWR VGND sky130_ef_sc_hd__decap_12
XFILLER_152_869 VPWR VGND VPWR VGND sky130_ef_sc_hd__decap_12
XFILLER_105_741 VPWR VGND VPWR VGND sky130_ef_sc_hd__decap_12
XFILLER_5_3 VPWR VGND VPWR VGND sky130_ef_sc_hd__decap_12
XFILLER_2_345 VGND VGND VPWR VPWR sky130_fd_sc_hd__decap_8
XFILLER_144_41 VPWR VGND VPWR VGND sky130_ef_sc_hd__decap_12
XFILLER_105_785 VPWR VGND VPWR VGND sky130_ef_sc_hd__decap_12
XFILLER_104_251 VGND VGND VPWR VPWR sky130_fd_sc_hd__fill_1
XFILLER_77_113 VPWR VGND VPWR VGND sky130_ef_sc_hd__decap_12
XFILLER_2_367 VPWR VGND VPWR VGND sky130_ef_sc_hd__decap_12
XFILLER_120_755 VGND VGND VPWR VPWR sky130_fd_sc_hd__fill_1
XFILLER_66_809 VGND VGND VPWR VPWR sky130_fd_sc_hd__decap_3
XTAP_TAPCELL_ROW_53_1179 VGND VPWR sky130_fd_sc_hd__tapvpwrvgnd_1
XTAP_TAPCELL_ROW_148_2696 VGND VPWR sky130_fd_sc_hd__tapvpwrvgnd_1
XFILLER_144_85 VPWR VGND VPWR VGND sky130_ef_sc_hd__decap_12
XFILLER_46_533 VPWR VGND VPWR VGND sky130_ef_sc_hd__decap_12
XFILLER_46_577 VGND VGND VPWR VPWR sky130_fd_sc_hd__decap_8
XTAP_TAPCELL_ROW_29_797 VGND VPWR sky130_fd_sc_hd__tapvpwrvgnd_1
XFILLER_33_205 VGND VGND VPWR VPWR sky130_fd_sc_hd__decap_8
XFILLER_33_249 VGND VGND VPWR VPWR sky130_fd_sc_hd__decap_8
XFILLER_42_750 VGND VGND VPWR VPWR sky130_fd_sc_hd__decap_6
XFILLER_53_93 VPWR VGND VPWR VGND sky130_ef_sc_hd__decap_12
XFILLER_128_811 VGND VGND VPWR VPWR sky130_fd_sc_hd__fill_1
XTAP_TAPCELL_ROW_40_973 VGND VPWR sky130_fd_sc_hd__tapvpwrvgnd_1
XFILLER_139_181 VPWR VGND VPWR VGND sky130_ef_sc_hd__decap_12
XFILLER_115_505 VPWR VGND VPWR VGND sky130_ef_sc_hd__decap_12
X_2510_ _0244_ _0257_ _0234_ VGND VGND VPWR VPWR _0258_ sky130_fd_sc_hd__o21a_1
XANTENNA__3254__RESET_B net36 VGND VGND VPWR VPWR sky130_fd_sc_hd__diode_2
X_2441_ _0186_ _0190_ VGND VGND VPWR VPWR _0191_ sky130_fd_sc_hd__xnor2_2
XFILLER_5_161 VGND VGND VPWR VPWR sky130_fd_sc_hd__decap_6
XFILLER_142_357 VGND VGND VPWR VPWR sky130_fd_sc_hd__decap_6
X_2372_ _0906_ _0123_ _0124_ VGND VGND VPWR VPWR _0126_ sky130_fd_sc_hd__or3_1
XFILLER_38_3 VPWR VGND VPWR VGND sky130_ef_sc_hd__decap_12
XFILLER_110_221 VPWR VGND VPWR VGND sky130_ef_sc_hd__decap_12
XFILLER_96_433 VPWR VGND VPWR VGND sky130_ef_sc_hd__decap_12
XFILLER_69_669 VGND VGND VPWR VPWR sky130_fd_sc_hd__decap_3
XFILLER_111_777 VGND VGND VPWR VPWR sky130_fd_sc_hd__decap_6
XFILLER_110_265 VPWR VGND VPWR VGND sky130_ef_sc_hd__decap_12
XFILLER_96_488 VPWR VGND VPWR VGND sky130_ef_sc_hd__decap_12
XFILLER_96_477 VGND VGND VPWR VPWR sky130_fd_sc_hd__decap_6
XTAP_TAPCELL_ROW_88_1743 VGND VPWR sky130_fd_sc_hd__tapvpwrvgnd_1
XTAP_TAPCELL_ROW_88_1732 VGND VPWR sky130_fd_sc_hd__tapvpwrvgnd_1
XFILLER_49_393 VGND VGND VPWR VPWR sky130_fd_sc_hd__decap_4
XFILLER_83_149 VPWR VGND VPWR VGND sky130_ef_sc_hd__decap_12
XFILLER_65_853 VPWR VGND VPWR VGND sky130_ef_sc_hd__decap_12
XFILLER_65_897 VPWR VGND VPWR VGND sky130_ef_sc_hd__decap_12
XFILLER_37_599 VPWR VGND VPWR VGND sky130_ef_sc_hd__decap_12
XFILLER_91_182 VGND VGND VPWR VPWR sky130_fd_sc_hd__fill_2
XFILLER_80_867 VGND VGND VPWR VPWR sky130_fd_sc_hd__fill_1
XANTENNA__3226__CLK clknet_3_3__leaf_clk VGND VGND VPWR VPWR sky130_fd_sc_hd__diode_2
XFILLER_52_558 VPWR VGND VPWR VGND sky130_ef_sc_hd__decap_12
XANTENNA__2082__B1 B_reg\[1\] VGND VGND VPWR VPWR sky130_fd_sc_hd__diode_2
XTAP_TAPCELL_ROW_119_2242 VGND VPWR sky130_fd_sc_hd__tapvpwrvgnd_1
XTAP_TAPCELL_ROW_119_2231 VGND VPWR sky130_fd_sc_hd__tapvpwrvgnd_1
XFILLER_20_444 VPWR VGND VPWR VGND sky130_ef_sc_hd__decap_12
XFILLER_119_833 VGND VGND VPWR VPWR sky130_fd_sc_hd__decap_6
XFILLER_118_321 VPWR VGND VPWR VGND sky130_ef_sc_hd__decap_12
XFILLER_20_477 VPWR VGND VPWR VGND sky130_ef_sc_hd__decap_12
XFILLER_134_825 VPWR VGND VPWR VGND sky130_ef_sc_hd__decap_12
XFILLER_119_877 VPWR VGND VPWR VGND sky130_ef_sc_hd__decap_12
XFILLER_118_365 VPWR VGND VPWR VGND sky130_ef_sc_hd__decap_12
X_2708_ _0446_ _0447_ VGND VGND VPWR VPWR _0448_ sky130_fd_sc_hd__and2_1
XTAP_TAPCELL_ROW_132_2442 VGND VPWR sky130_fd_sc_hd__tapvpwrvgnd_1
XFILLER_133_335 VGND VGND VPWR VPWR sky130_fd_sc_hd__fill_1
XFILLER_134_869 VPWR VGND VPWR VGND sky130_ef_sc_hd__decap_12
X_2639_ _0373_ _0379_ _0374_ VGND VGND VPWR VPWR _0382_ sky130_fd_sc_hd__mux2_1
XTAP_TAPCELL_ROW_7_448 VGND VPWR sky130_fd_sc_hd__tapvpwrvgnd_1
XTAP_TAPCELL_ROW_7_437 VGND VPWR sky130_fd_sc_hd__tapvpwrvgnd_1
XFILLER_102_755 VGND VGND VPWR VPWR sky130_fd_sc_hd__fill_1
XFILLER_59_113 VGND VGND VPWR VPWR sky130_fd_sc_hd__decap_8
XANTENNA__1896__A0 net35 VGND VGND VPWR VPWR sky130_fd_sc_hd__diode_2
XFILLER_75_617 VPWR VGND VPWR VGND sky130_ef_sc_hd__decap_12
XFILLER_59_179 VGND VGND VPWR VPWR sky130_fd_sc_hd__fill_2
XFILLER_28_533 VPWR VGND VPWR VGND sky130_ef_sc_hd__decap_12
XFILLER_114_77 VGND VGND VPWR VPWR sky130_fd_sc_hd__decap_6
XFILLER_70_300 VGND VGND VPWR VPWR sky130_fd_sc_hd__decap_8
XFILLER_55_363 VGND VGND VPWR VPWR sky130_fd_sc_hd__fill_2
XFILLER_15_205 VPWR VGND VPWR VGND sky130_ef_sc_hd__decap_12
XFILLER_70_333 VPWR VGND VPWR VGND sky130_ef_sc_hd__decap_12
XTAP_TAPCELL_ROW_26_745 VGND VPWR sky130_fd_sc_hd__tapvpwrvgnd_1
XFILLER_31_709 VPWR VGND VPWR VGND sky130_ef_sc_hd__decap_12
XFILLER_130_65 VPWR VGND VPWR VGND sky130_ef_sc_hd__decap_12
XFILLER_71_889 VGND VGND VPWR VPWR sky130_fd_sc_hd__decap_6
XFILLER_142_3 VPWR VGND VPWR VGND sky130_ef_sc_hd__decap_12
XFILLER_90_58 VGND VGND VPWR VPWR sky130_fd_sc_hd__decap_8
XFILLER_8_905 VGND VGND VPWR VPWR sky130_fd_sc_hd__decap_4
XFILLER_7_404 VPWR VGND VPWR VGND sky130_ef_sc_hd__decap_12
XFILLER_137_641 VPWR VGND VPWR VGND sky130_ef_sc_hd__decap_12
XFILLER_137_685 VPWR VGND VPWR VGND sky130_ef_sc_hd__decap_12
XFILLER_136_195 VGND VGND VPWR VPWR sky130_fd_sc_hd__fill_1
XFILLER_124_357 VGND VGND VPWR VPWR sky130_fd_sc_hd__decap_6
XTAP_TAPCELL_ROW_55_1219 VGND VPWR sky130_fd_sc_hd__tapvpwrvgnd_1
XTAP_TAPCELL_ROW_55_1208 VGND VPWR sky130_fd_sc_hd__tapvpwrvgnd_1
XANTENNA__1706__A A_reg\[3\] VGND VGND VPWR VPWR sky130_fd_sc_hd__diode_2
XFILLER_152_699 VGND VGND VPWR VPWR sky130_fd_sc_hd__fill_1
XFILLER_78_400 VGND VGND VPWR VPWR sky130_fd_sc_hd__fill_1
XFILLER_2_153 VPWR VGND VPWR VGND sky130_ef_sc_hd__decap_12
XFILLER_78_433 VPWR VGND VPWR VGND sky130_ef_sc_hd__decap_12
XFILLER_2_197 VPWR VGND VPWR VGND sky130_ef_sc_hd__decap_12
XFILLER_39_809 VPWR VGND VPWR VGND sky130_ef_sc_hd__decap_12
XFILLER_78_477 VPWR VGND VPWR VGND sky130_ef_sc_hd__decap_12
XFILLER_93_447 VGND VGND VPWR VPWR sky130_fd_sc_hd__fill_1
XFILLER_59_691 VGND VGND VPWR VPWR sky130_fd_sc_hd__fill_1
XFILLER_93_458 VPWR VGND VPWR VGND sky130_ef_sc_hd__decap_12
XANTENNA__3249__CLK clknet_3_6__leaf_clk VGND VGND VPWR VPWR sky130_fd_sc_hd__diode_2
XPHY_EDGE_ROW_45_Left_199 VGND VGND VPWR VPWR sky130_fd_sc_hd__decap_3
XFILLER_74_683 VPWR VGND VPWR VGND sky130_ef_sc_hd__decap_12
XFILLER_47_897 VPWR VGND VPWR VGND sky130_ef_sc_hd__decap_12
XFILLER_46_363 VGND VGND VPWR VPWR sky130_fd_sc_hd__fill_1
XFILLER_62_845 VGND VGND VPWR VPWR sky130_fd_sc_hd__fill_1
XFILLER_61_322 VPWR VGND VPWR VGND sky130_ef_sc_hd__decap_12
XTAP_TAPCELL_ROW_83_1662 VGND VPWR sky130_fd_sc_hd__tapvpwrvgnd_1
X_2990_ _0627_ _0645_ VGND VGND VPWR VPWR _0678_ sky130_fd_sc_hd__xnor2_1
X_1941_ B_reg\[7\] _1205_ VGND VGND VPWR VPWR _1206_ sky130_fd_sc_hd__nand2_1
XFILLER_15_783 VGND VGND VPWR VPWR sky130_fd_sc_hd__fill_1
XFILLER_147_405 VPWR VGND VPWR VGND sky130_ef_sc_hd__decap_12
X_1872_ _1139_ _1141_ VGND VGND VPWR VPWR _1142_ sky130_fd_sc_hd__or2_1
XFILLER_147_449 VPWR VGND VPWR VGND sky130_ef_sc_hd__decap_12
XFILLER_116_825 VPWR VGND VPWR VGND sky130_ef_sc_hd__decap_12
XTAP_TAPCELL_ROW_114_2150 VGND VPWR sky130_fd_sc_hd__tapvpwrvgnd_1
XFILLER_142_121 VPWR VGND VPWR VGND sky130_ef_sc_hd__decap_12
XFILLER_116_869 VPWR VGND VPWR VGND sky130_ef_sc_hd__decap_12
XFILLER_115_335 VGND VGND VPWR VPWR sky130_fd_sc_hd__fill_1
XTAP_TAPCELL_ROW_114_2161 VGND VPWR sky130_fd_sc_hd__tapvpwrvgnd_1
XFILLER_89_709 VPWR VGND VPWR VGND sky130_ef_sc_hd__decap_12
XANTENNA__1616__A A_reg\[3\] VGND VGND VPWR VPWR sky130_fd_sc_hd__diode_2
XFILLER_142_165 VPWR VGND VPWR VGND sky130_ef_sc_hd__decap_12
XFILLER_131_839 VGND VGND VPWR VPWR sky130_fd_sc_hd__fill_1
X_2424_ b_r3\[0\] _0911_ VGND VGND VPWR VPWR _0178_ sky130_fd_sc_hd__and2_1
XFILLER_97_753 VPWR VGND VPWR VGND sky130_ef_sc_hd__decap_12
X_2355_ _1602_ _0106_ _0108_ VGND VGND VPWR VPWR _0109_ sky130_fd_sc_hd__a21o_1
XFILLER_69_433 VPWR VGND VPWR VGND sky130_ef_sc_hd__decap_12
XFILLER_57_617 VPWR VGND VPWR VGND sky130_ef_sc_hd__decap_12
XFILLER_29_319 VPWR VGND VPWR VGND sky130_ef_sc_hd__decap_12
XFILLER_111_585 VPWR VGND VPWR VGND sky130_ef_sc_hd__decap_12
XFILLER_97_797 VPWR VGND VPWR VGND sky130_ef_sc_hd__decap_12
X_2286_ a_r3\[0\] _0911_ VGND VGND VPWR VPWR _1543_ sky130_fd_sc_hd__and2_1
XFILLER_56_116 VPWR VGND VPWR VGND sky130_ef_sc_hd__decap_12
XFILLER_84_469 VGND VGND VPWR VPWR sky130_fd_sc_hd__decap_6
XFILLER_71_119 VGND VGND VPWR VPWR sky130_fd_sc_hd__fill_1
XFILLER_65_661 VGND VGND VPWR VPWR sky130_fd_sc_hd__decap_8
XFILLER_64_160 VPWR VGND VPWR VGND sky130_ef_sc_hd__decap_12
XANTENNA__2166__B A_reg\[11\] VGND VGND VPWR VPWR sky130_fd_sc_hd__diode_2
XFILLER_25_503 VGND VGND VPWR VPWR sky130_fd_sc_hd__fill_1
XFILLER_80_642 VGND VGND VPWR VPWR sky130_fd_sc_hd__fill_2
XFILLER_44_29 VPWR VGND VPWR VGND sky130_ef_sc_hd__decap_12
XFILLER_52_377 VPWR VGND VPWR VGND sky130_ef_sc_hd__decap_12
XFILLER_13_709 VPWR VGND VPWR VGND sky130_ef_sc_hd__decap_12
XTAP_TAPCELL_ROW_23_704 VGND VPWR sky130_fd_sc_hd__tapvpwrvgnd_1
XFILLER_21_753 VPWR VGND VPWR VGND sky130_ef_sc_hd__decap_12
XFILLER_21_797 VPWR VGND VPWR VGND sky130_ef_sc_hd__decap_12
XFILLER_119_641 VPWR VGND VPWR VGND sky130_ef_sc_hd__decap_12
XFILLER_4_407 VGND VGND VPWR VPWR sky130_fd_sc_hd__decap_6
XFILLER_119_685 VPWR VGND VPWR VGND sky130_ef_sc_hd__decap_12
XFILLER_109_55 VGND VGND VPWR VPWR sky130_fd_sc_hd__fill_1
XFILLER_118_195 VGND VGND VPWR VPWR sky130_fd_sc_hd__fill_1
XFILLER_106_357 VGND VGND VPWR VPWR sky130_fd_sc_hd__decap_6
XFILLER_134_699 VGND VGND VPWR VPWR sky130_fd_sc_hd__fill_1
XFILLER_121_305 VPWR VGND VPWR VGND sky130_ef_sc_hd__decap_12
XFILLER_0_613 VGND VGND VPWR VPWR sky130_fd_sc_hd__decap_3
XFILLER_121_349 VPWR VGND VPWR VGND sky130_ef_sc_hd__decap_12
XFILLER_102_530 VGND VGND VPWR VPWR sky130_fd_sc_hd__fill_2
XFILLER_130_861 VGND VGND VPWR VPWR sky130_fd_sc_hd__decap_6
XTAP_TAPCELL_ROW_50_1127 VGND VPWR sky130_fd_sc_hd__tapvpwrvgnd_1
XFILLER_0_657 VPWR VGND VPWR VGND sky130_ef_sc_hd__decap_12
XTAP_TAPCELL_ROW_145_2655 VGND VPWR sky130_fd_sc_hd__tapvpwrvgnd_1
XTAP_TAPCELL_ROW_145_2644 VGND VPWR sky130_fd_sc_hd__tapvpwrvgnd_1
XFILLER_87_296 VGND VGND VPWR VPWR sky130_fd_sc_hd__fill_1
XTAP_TAPCELL_ROW_50_1138 VGND VPWR sky130_fd_sc_hd__tapvpwrvgnd_1
XFILLER_47_105 VGND VGND VPWR VPWR sky130_fd_sc_hd__decap_6
XFILLER_85_69 VPWR VGND VPWR VGND sky130_ef_sc_hd__decap_12
XFILLER_75_447 VGND VGND VPWR VPWR sky130_fd_sc_hd__fill_1
XFILLER_63_609 VGND VGND VPWR VPWR sky130_fd_sc_hd__decap_6
XFILLER_18_41 VPWR VGND VPWR VGND sky130_ef_sc_hd__decap_12
XFILLER_29_853 VPWR VGND VPWR VGND sky130_ef_sc_hd__decap_12
XFILLER_47_149 VPWR VGND VPWR VGND sky130_ef_sc_hd__decap_12
XFILLER_90_406 VPWR VGND VPWR VGND sky130_ef_sc_hd__decap_12
XANTENNA__2294__B1 _0911_ VGND VGND VPWR VPWR sky130_fd_sc_hd__diode_2
XFILLER_16_525 VGND VGND VPWR VPWR sky130_fd_sc_hd__decap_6
XFILLER_18_85 VPWR VGND VPWR VGND sky130_ef_sc_hd__decap_12
XFILLER_28_363 VGND VGND VPWR VPWR sky130_fd_sc_hd__fill_1
XFILLER_29_897 VPWR VGND VPWR VGND sky130_ef_sc_hd__decap_12
XFILLER_28_385 VGND VGND VPWR VPWR sky130_fd_sc_hd__fill_1
XFILLER_44_867 VGND VGND VPWR VPWR sky130_fd_sc_hd__fill_1
XFILLER_16_569 VPWR VGND VPWR VGND sky130_ef_sc_hd__decap_12
XFILLER_31_517 VGND VGND VPWR VPWR sky130_fd_sc_hd__fill_2
XFILLER_71_697 VPWR VGND VPWR VGND sky130_ef_sc_hd__decap_12
XTAP_TAPCELL_ROW_65_1370 VGND VPWR sky130_fd_sc_hd__tapvpwrvgnd_1
XFILLER_129_405 VPWR VGND VPWR VGND sky130_ef_sc_hd__decap_12
XFILLER_8_713 VPWR VGND VPWR VGND sky130_ef_sc_hd__decap_12
XFILLER_145_909 VGND VGND VPWR VPWR sky130_fd_sc_hd__fill_1
XFILLER_129_449 VPWR VGND VPWR VGND sky130_ef_sc_hd__decap_12
XFILLER_7_223 VGND VGND VPWR VPWR sky130_fd_sc_hd__fill_1
XFILLER_144_419 VGND VGND VPWR VPWR sky130_fd_sc_hd__fill_1
XFILLER_50_50 VPWR VGND VPWR VGND sky130_ef_sc_hd__decap_12
XFILLER_8_757 VPWR VGND VPWR VGND sky130_ef_sc_hd__decap_12
XFILLER_124_121 VPWR VGND VPWR VGND sky130_ef_sc_hd__decap_12
XFILLER_140_625 VPWR VGND VPWR VGND sky130_ef_sc_hd__decap_12
XFILLER_124_165 VPWR VGND VPWR VGND sky130_ef_sc_hd__decap_12
XFILLER_113_839 VGND VGND VPWR VPWR sky130_fd_sc_hd__fill_1
XFILLER_98_528 VGND VGND VPWR VPWR sky130_fd_sc_hd__decap_4
XFILLER_140_669 VPWR VGND VPWR VGND sky130_ef_sc_hd__decap_12
XFILLER_94_701 VPWR VGND VPWR VGND sky130_ef_sc_hd__decap_12
XFILLER_59_81 VPWR VGND VPWR VGND sky130_ef_sc_hd__decap_12
XFILLER_39_617 VPWR VGND VPWR VGND sky130_ef_sc_hd__decap_12
X_2140_ _0908_ _1397_ VGND VGND VPWR VPWR _1399_ sky130_fd_sc_hd__xnor2_1
XFILLER_79_797 VPWR VGND VPWR VGND sky130_ef_sc_hd__decap_12
XPHY_EDGE_ROW_53_Left_207 VGND VGND VPWR VPWR sky130_fd_sc_hd__decap_3
X_2071_ B_reg\[2\] _1332_ VGND VGND VPWR VPWR _1333_ sky130_fd_sc_hd__or2_1
XFILLER_66_469 VGND VGND VPWR VPWR sky130_fd_sc_hd__decap_6
XANTENNA__2267__A A_reg\[2\] VGND VGND VPWR VPWR sky130_fd_sc_hd__diode_2
XFILLER_54_609 VGND VGND VPWR VPWR sky130_fd_sc_hd__decap_6
XFILLER_47_661 VGND VGND VPWR VPWR sky130_fd_sc_hd__decap_8
XFILLER_34_300 VGND VGND VPWR VPWR sky130_fd_sc_hd__decap_8
XFILLER_34_333 VPWR VGND VPWR VGND sky130_ef_sc_hd__decap_12
XFILLER_34_377 VPWR VGND VPWR VGND sky130_ef_sc_hd__decap_12
XFILLER_35_889 VGND VGND VPWR VPWR sky130_fd_sc_hd__decap_6
XANTENNA__2714__B b_r3\[3\] VGND VGND VPWR VPWR sky130_fd_sc_hd__diode_2
XANTENNA__2037__B1 B_reg\[7\] VGND VGND VPWR VPWR sky130_fd_sc_hd__diode_2
X_2973_ _0659_ _0660_ VGND VGND VPWR VPWR _0661_ sky130_fd_sc_hd__and2_1
XFILLER_50_837 VPWR VGND VPWR VGND sky130_ef_sc_hd__decap_12
XTAP_TAPCELL_ROW_17_597 VGND VPWR sky130_fd_sc_hd__tapvpwrvgnd_1
XFILLER_148_725 VPWR VGND VPWR VGND sky130_ef_sc_hd__decap_12
X_1924_ _0900_ _1185_ VGND VGND VPWR VPWR _1189_ sky130_fd_sc_hd__nor2_1
XFILLER_136_909 VGND VGND VPWR VPWR sky130_fd_sc_hd__fill_1
XPHY_EDGE_ROW_62_Left_216 VGND VGND VPWR VPWR sky130_fd_sc_hd__decap_3
XFILLER_148_769 VPWR VGND VPWR VGND sky130_ef_sc_hd__decap_12
X_1855_ _1123_ _1124_ A_reg\[9\] VGND VGND VPWR VPWR _1125_ sky130_fd_sc_hd__o21ai_1
XFILLER_147_279 VGND VGND VPWR VPWR sky130_fd_sc_hd__fill_1
X_1786_ _1050_ _1052_ VGND VGND VPWR VPWR _1059_ sky130_fd_sc_hd__nor2_1
XFILLER_143_441 VGND VGND VPWR VPWR sky130_fd_sc_hd__decap_6
XTAP_TAPCELL_ROW_96_1875 VGND VPWR sky130_fd_sc_hd__tapvpwrvgnd_1
XTAP_TAPCELL_ROW_96_1864 VGND VPWR sky130_fd_sc_hd__tapvpwrvgnd_1
XFILLER_143_485 VPWR VGND VPWR VGND sky130_ef_sc_hd__decap_12
XPHY_EDGE_ROW_123_Right_123 VGND VGND VPWR VPWR sky130_fd_sc_hd__decap_3
XFILLER_116_699 VGND VGND VPWR VPWR sky130_fd_sc_hd__fill_1
XFILLER_103_305 VPWR VGND VPWR VGND sky130_ef_sc_hd__decap_12
XFILLER_89_517 VGND VGND VPWR VPWR sky130_fd_sc_hd__decap_3
XFILLER_103_349 VPWR VGND VPWR VGND sky130_ef_sc_hd__decap_12
XFILLER_112_861 VGND VGND VPWR VPWR sky130_fd_sc_hd__decap_6
XFILLER_97_561 VPWR VGND VPWR VGND sky130_ef_sc_hd__decap_12
X_2407_ _0158_ _0160_ VGND VGND VPWR VPWR _0161_ sky130_fd_sc_hd__nor2_1
XPHY_EDGE_ROW_71_Left_225 VGND VGND VPWR VPWR sky130_fd_sc_hd__decap_3
XFILLER_85_723 VGND VGND VPWR VPWR sky130_fd_sc_hd__decap_4
X_2338_ _0902_ _1587_ _1589_ VGND VGND VPWR VPWR _1591_ sky130_fd_sc_hd__and3_1
XFILLER_29_105 VGND VGND VPWR VPWR sky130_fd_sc_hd__decap_6
XTAP_TAPCELL_ROW_127_2363 VGND VPWR sky130_fd_sc_hd__tapvpwrvgnd_1
XFILLER_111_393 VPWR VGND VPWR VGND sky130_ef_sc_hd__decap_12
XFILLER_84_233 VPWR VGND VPWR VGND sky130_ef_sc_hd__decap_12
X_2269_ _1524_ _1525_ VGND VGND VPWR VPWR _1526_ sky130_fd_sc_hd__or2_1
XFILLER_29_149 VPWR VGND VPWR VGND sky130_ef_sc_hd__decap_12
XFILLER_37_193 VPWR VGND VPWR VGND sky130_ef_sc_hd__decap_12
XTAP_TAPCELL_ROW_140_2574 VGND VPWR sky130_fd_sc_hd__tapvpwrvgnd_1
XFILLER_53_664 VGND VGND VPWR VPWR sky130_fd_sc_hd__decap_8
XFILLER_52_141 VGND VGND VPWR VPWR sky130_fd_sc_hd__decap_3
XFILLER_52_130 VGND VGND VPWR VPWR sky130_fd_sc_hd__fill_2
XFILLER_13_517 VPWR VGND VPWR VGND sky130_ef_sc_hd__decap_12
XFILLER_26_867 VGND VGND VPWR VPWR sky130_fd_sc_hd__fill_1
XFILLER_71_27 VGND VGND VPWR VPWR sky130_fd_sc_hd__decap_4
XFILLER_53_697 VGND VGND VPWR VPWR sky130_fd_sc_hd__decap_4
XPHY_EDGE_ROW_80_Left_234 VGND VGND VPWR VPWR sky130_fd_sc_hd__decap_3
XFILLER_21_561 VPWR VGND VPWR VGND sky130_ef_sc_hd__decap_12
XFILLER_127_909 VGND VGND VPWR VPWR sky130_fd_sc_hd__fill_1
XFILLER_126_419 VGND VGND VPWR VPWR sky130_fd_sc_hd__fill_1
XFILLER_5_727 VGND VGND VPWR VPWR sky130_fd_sc_hd__fill_1
XFILLER_153_249 VGND VGND VPWR VPWR sky130_fd_sc_hd__decap_3
XFILLER_106_121 VPWR VGND VPWR VGND sky130_ef_sc_hd__decap_12
XFILLER_136_53 VPWR VGND VPWR VGND sky130_ef_sc_hd__decap_12
XFILLER_106_165 VPWR VGND VPWR VGND sky130_ef_sc_hd__decap_12
XANTENNA__2751__A1 _0185_ VGND VGND VPWR VPWR sky130_fd_sc_hd__diode_2
XANTENNA__2751__B2 OpSel_reg\[0\] VGND VGND VPWR VPWR sky130_fd_sc_hd__diode_2
XFILLER_20_53 VPWR VGND VPWR VGND sky130_ef_sc_hd__decap_12
XFILLER_122_625 VPWR VGND VPWR VGND sky130_ef_sc_hd__decap_12
XFILLER_121_113 VPWR VGND VPWR VGND sky130_ef_sc_hd__decap_12
XFILLER_0_421 VPWR VGND VPWR VGND sky130_ef_sc_hd__decap_12
XFILLER_20_97 VPWR VGND VPWR VGND sky130_ef_sc_hd__decap_12
XFILLER_136_97 VPWR VGND VPWR VGND sky130_ef_sc_hd__decap_12
XFILLER_122_669 VPWR VGND VPWR VGND sky130_ef_sc_hd__decap_12
XFILLER_29_51 VGND VGND VPWR VPWR sky130_fd_sc_hd__decap_4
XFILLER_152_41 VPWR VGND VPWR VGND sky130_ef_sc_hd__decap_12
XANTENNA_input25_A B_in[2] VGND VGND VPWR VPWR sky130_fd_sc_hd__diode_2
XFILLER_152_85 VPWR VGND VPWR VGND sky130_ef_sc_hd__decap_12
XTAP_TAPCELL_ROW_67_1410 VGND VPWR sky130_fd_sc_hd__tapvpwrvgnd_1
XFILLER_63_428 VGND VGND VPWR VPWR sky130_fd_sc_hd__decap_4
XFILLER_90_225 VPWR VGND VPWR VGND sky130_ef_sc_hd__decap_12
XPHY_EDGE_ROW_119_Left_273 VGND VGND VPWR VPWR sky130_fd_sc_hd__decap_3
XFILLER_17_889 VGND VGND VPWR VPWR sky130_fd_sc_hd__decap_6
XFILLER_44_675 VPWR VGND VPWR VGND sky130_ef_sc_hd__decap_12
XTAP_TAPCELL_ROW_80_1610 VGND VPWR sky130_fd_sc_hd__tapvpwrvgnd_1
XFILLER_31_314 VPWR VGND VPWR VGND sky130_ef_sc_hd__decap_12
XTAP_TAPCELL_ROW_14_556 VGND VPWR sky130_fd_sc_hd__tapvpwrvgnd_1
XFILLER_84_8 VGND VGND VPWR VPWR sky130_fd_sc_hd__decap_8
XFILLER_118_909 VGND VGND VPWR VPWR sky130_fd_sc_hd__fill_1
XFILLER_129_279 VGND VGND VPWR VPWR sky130_fd_sc_hd__fill_1
XFILLER_8_587 VGND VGND VPWR VPWR sky130_fd_sc_hd__fill_1
X_1640_ A_reg\[14\] A_reg\[13\] A_reg\[15\] VGND VGND VPWR VPWR _0916_ sky130_fd_sc_hd__a21boi_1
XFILLER_125_441 VGND VGND VPWR VPWR sky130_fd_sc_hd__decap_6
XTAP_TAPCELL_ROW_78_1572 VGND VPWR sky130_fd_sc_hd__tapvpwrvgnd_1
XPHY_EDGE_ROW_128_Left_282 VGND VGND VPWR VPWR sky130_fd_sc_hd__decap_3
XTAP_TAPCELL_ROW_78_1583 VGND VPWR sky130_fd_sc_hd__tapvpwrvgnd_1
X_3310_ clknet_3_7__leaf_clk _0093_ net36 VGND VGND VPWR VPWR X_crt\[4\] sky130_fd_sc_hd__dfrtp_1
XFILLER_6_77 VGND VGND VPWR VPWR sky130_fd_sc_hd__decap_6
XFILLER_140_433 VPWR VGND VPWR VGND sky130_ef_sc_hd__decap_12
XFILLER_125_485 VPWR VGND VPWR VGND sky130_ef_sc_hd__decap_12
XFILLER_4_793 VPWR VGND VPWR VGND sky130_ef_sc_hd__decap_12
XFILLER_3_281 VPWR VGND VPWR VGND sky130_ef_sc_hd__decap_12
XFILLER_140_477 VPWR VGND VPWR VGND sky130_ef_sc_hd__decap_12
XFILLER_101_809 VPWR VGND VPWR VGND sky130_ef_sc_hd__decap_12
XTAP_TAPCELL_ROW_91_1783 VGND VPWR sky130_fd_sc_hd__tapvpwrvgnd_1
X_3241_ clknet_3_4__leaf_clk ALU_EN net36 VGND VGND VPWR VPWR u_slice0.start_d sky130_fd_sc_hd__dfrtp_1
XTAP_TAPCELL_ROW_91_1794 VGND VPWR sky130_fd_sc_hd__tapvpwrvgnd_1
XFILLER_67_712 VGND VGND VPWR VPWR sky130_fd_sc_hd__decap_8
X_3172_ _0561_ _0858_ VGND VGND VPWR VPWR _0860_ sky130_fd_sc_hd__nor2_1
XFILLER_20_3 VPWR VGND VPWR VGND sky130_ef_sc_hd__decap_12
XFILLER_94_531 VGND VGND VPWR VPWR sky130_fd_sc_hd__fill_1
X_2123_ _1380_ _1381_ B_reg\[6\] VGND VGND VPWR VPWR _1382_ sky130_fd_sc_hd__o21ai_1
XFILLER_27_609 VGND VGND VPWR VPWR sky130_fd_sc_hd__decap_6
XFILLER_39_447 VGND VGND VPWR VPWR sky130_fd_sc_hd__fill_1
XTAP_TAPCELL_ROW_109_2082 VGND VPWR sky130_fd_sc_hd__tapvpwrvgnd_1
XTAP_TAPCELL_ROW_109_2071 VGND VPWR sky130_fd_sc_hd__tapvpwrvgnd_1
XFILLER_66_277 VPWR VGND VPWR VGND sky130_ef_sc_hd__decap_12
XPHY_EDGE_ROW_137_Left_291 VGND VGND VPWR VPWR sky130_fd_sc_hd__decap_3
X_2054_ B_reg\[4\] _1315_ VGND VGND VPWR VPWR _1316_ sky130_fd_sc_hd__nor2_1
XFILLER_82_748 VGND VGND VPWR VPWR sky130_fd_sc_hd__decap_8
XFILLER_81_225 VPWR VGND VPWR VGND sky130_ef_sc_hd__decap_12
XFILLER_50_601 VPWR VGND VPWR VGND sky130_ef_sc_hd__decap_12
XFILLER_19_193 VPWR VGND VPWR VGND sky130_ef_sc_hd__decap_12
XFILLER_34_141 VPWR VGND VPWR VGND sky130_ef_sc_hd__decap_12
XFILLER_35_653 VPWR VGND VPWR VGND sky130_ef_sc_hd__decap_12
XTAP_TAPCELL_ROW_122_2282 VGND VPWR sky130_fd_sc_hd__tapvpwrvgnd_1
XFILLER_90_781 VPWR VGND VPWR VGND sky130_ef_sc_hd__decap_12
XFILLER_35_697 VPWR VGND VPWR VGND sky130_ef_sc_hd__decap_12
XFILLER_50_645 VPWR VGND VPWR VGND sky130_ef_sc_hd__decap_12
XTAP_TAPCELL_ROW_33_854 VGND VPWR sky130_fd_sc_hd__tapvpwrvgnd_1
XFILLER_148_533 VPWR VGND VPWR VGND sky130_ef_sc_hd__decap_12
XTAP_TAPCELL_ROW_98_1904 VGND VPWR sky130_fd_sc_hd__tapvpwrvgnd_1
X_2956_ _0628_ _0643_ VGND VGND VPWR VPWR _0644_ sky130_fd_sc_hd__and2_1
XANTENNA__1769__C1 A_reg\[8\] VGND VGND VPWR VPWR sky130_fd_sc_hd__diode_2
XTAP_TAPCELL_ROW_33_865 VGND VPWR sky130_fd_sc_hd__tapvpwrvgnd_1
XFILLER_109_909 VGND VGND VPWR VPWR sky130_fd_sc_hd__fill_1
X_2887_ u_crt.r3\[0\] _0566_ _0574_ VGND VGND VPWR VPWR _0575_ sky130_fd_sc_hd__a21boi_1
X_1907_ B_reg\[12\] _1169_ _1171_ VGND VGND VPWR VPWR _1172_ sky130_fd_sc_hd__o21a_1
XFILLER_135_205 VPWR VGND VPWR VGND sky130_ef_sc_hd__decap_12
X_1838_ a_r1\[1\] _1109_ Encode_EN VGND VGND VPWR VPWR _0004_ sky130_fd_sc_hd__mux2_1
XFILLER_151_709 VPWR VGND VPWR VGND sky130_ef_sc_hd__decap_12
XFILLER_135_249 VPWR VGND VPWR VGND sky130_ef_sc_hd__decap_12
X_1769_ A_reg\[9\] _1033_ _1036_ _1038_ A_reg\[8\] VGND VGND VPWR VPWR _1042_ sky130_fd_sc_hd__a311o_1
XFILLER_143_293 VPWR VGND VPWR VGND sky130_ef_sc_hd__decap_12
XFILLER_104_625 VPWR VGND VPWR VGND sky130_ef_sc_hd__decap_12
XFILLER_103_113 VPWR VGND VPWR VGND sky130_ef_sc_hd__decap_12
XFILLER_89_325 VGND VGND VPWR VPWR sky130_fd_sc_hd__decap_8
XTAP_TAPCELL_ROW_129_2403 VGND VPWR sky130_fd_sc_hd__tapvpwrvgnd_1
XFILLER_104_669 VPWR VGND VPWR VGND sky130_ef_sc_hd__decap_12
XFILLER_58_701 VGND VGND VPWR VPWR sky130_fd_sc_hd__fill_2
XFILLER_98_881 VPWR VGND VPWR VGND sky130_ef_sc_hd__decap_12
XTAP_TAPCELL_ROW_142_2603 VGND VPWR sky130_fd_sc_hd__tapvpwrvgnd_1
XFILLER_97_391 VGND VGND VPWR VPWR sky130_fd_sc_hd__fill_1
XFILLER_57_222 VGND VGND VPWR VPWR sky130_fd_sc_hd__fill_2
XFILLER_73_726 VGND VGND VPWR VPWR sky130_fd_sc_hd__fill_2
XFILLER_45_417 VPWR VGND VPWR VGND sky130_ef_sc_hd__decap_12
XFILLER_85_597 VGND VGND VPWR VPWR sky130_fd_sc_hd__decap_6
XFILLER_122_77 VGND VGND VPWR VPWR sky130_fd_sc_hd__decap_6
XFILLER_82_15 VGND VGND VPWR VPWR sky130_fd_sc_hd__fill_1
XFILLER_72_258 VPWR VGND VPWR VGND sky130_ef_sc_hd__decap_12
XFILLER_82_59 VPWR VGND VPWR VGND sky130_ef_sc_hd__decap_12
XFILLER_14_837 VPWR VGND VPWR VGND sky130_ef_sc_hd__decap_12
XFILLER_40_133 VGND VGND VPWR VPWR sky130_fd_sc_hd__decap_6
XTAP_TAPCELL_ROW_45_1048 VGND VPWR sky130_fd_sc_hd__tapvpwrvgnd_1
XTAP_TAPCELL_ROW_45_1059 VGND VPWR sky130_fd_sc_hd__tapvpwrvgnd_1
XTAP_TAPCELL_ROW_11_504 VGND VPWR sky130_fd_sc_hd__tapvpwrvgnd_1
XFILLER_9_329 VGND VGND VPWR VPWR sky130_fd_sc_hd__decap_6
XFILLER_22_881 VPWR VGND VPWR VGND sky130_ef_sc_hd__decap_12
XANTENNA__3239__Q b_r3\[3\] VGND VGND VPWR VPWR sky130_fd_sc_hd__diode_2
XTAP_TAPCELL_ROW_11_515 VGND VPWR sky130_fd_sc_hd__tapvpwrvgnd_1
XFILLER_21_391 VGND VGND VPWR VPWR sky130_fd_sc_hd__fill_1
XTAP_TAPCELL_ROW_153_2798 VGND VPWR sky130_fd_sc_hd__tapvpwrvgnd_1
XTAP_TAPCELL_ROW_153_2787 VGND VPWR sky130_fd_sc_hd__tapvpwrvgnd_1
XTAP_TAPCELL_ROW_153_2776 VGND VPWR sky130_fd_sc_hd__tapvpwrvgnd_1
XFILLER_135_783 VGND VGND VPWR VPWR sky130_fd_sc_hd__fill_1
XFILLER_122_433 VPWR VGND VPWR VGND sky130_ef_sc_hd__decap_12
Xoutput52 net52 VGND VGND VPWR VPWR X_out[8] sky130_fd_sc_hd__buf_1
Xoutput41 net41 VGND VGND VPWR VPWR X_out[12] sky130_fd_sc_hd__buf_1
XFILLER_1_741 VPWR VGND VPWR VGND sky130_ef_sc_hd__decap_12
XFILLER_122_477 VPWR VGND VPWR VGND sky130_ef_sc_hd__decap_12
XFILLER_49_723 VGND VGND VPWR VPWR sky130_fd_sc_hd__decap_4
XFILLER_0_251 VGND VGND VPWR VPWR sky130_fd_sc_hd__fill_1
XFILLER_1_785 VPWR VGND VPWR VGND sky130_ef_sc_hd__decap_12
XFILLER_76_531 VGND VGND VPWR VPWR sky130_fd_sc_hd__fill_1
XFILLER_48_233 VPWR VGND VPWR VGND sky130_ef_sc_hd__decap_12
XFILLER_48_277 VGND VGND VPWR VPWR sky130_fd_sc_hd__decap_6
XFILLER_64_737 VPWR VGND VPWR VGND sky130_ef_sc_hd__decap_12
XFILLER_63_225 VGND VGND VPWR VPWR sky130_fd_sc_hd__decap_4
XFILLER_56_60 VPWR VGND VPWR VGND sky130_ef_sc_hd__decap_12
XTAP_TAPCELL_ROW_19_637 VGND VPWR sky130_fd_sc_hd__tapvpwrvgnd_1
XANTENNA__3279__RESET_B net36 VGND VGND VPWR VPWR sky130_fd_sc_hd__diode_2
XFILLER_16_141 VPWR VGND VPWR VGND sky130_ef_sc_hd__decap_12
XFILLER_17_653 VPWR VGND VPWR VGND sky130_ef_sc_hd__decap_12
XFILLER_17_697 VPWR VGND VPWR VGND sky130_ef_sc_hd__decap_12
XFILLER_32_601 VPWR VGND VPWR VGND sky130_ef_sc_hd__decap_12
XFILLER_31_111 VGND VGND VPWR VPWR sky130_fd_sc_hd__fill_1
XFILLER_32_645 VPWR VGND VPWR VGND sky130_ef_sc_hd__decap_12
X_2810_ _0525_ _0535_ VGND VGND VPWR VPWR _0548_ sky130_fd_sc_hd__nand2_1
XTAP_TAPCELL_ROW_30_813 VGND VPWR sky130_fd_sc_hd__tapvpwrvgnd_1
X_2741_ _0477_ _0478_ _0479_ _0480_ VGND VGND VPWR VPWR _0481_ sky130_fd_sc_hd__or4_1
XFILLER_9_841 VPWR VGND VPWR VGND sky130_ef_sc_hd__decap_12
XFILLER_145_503 VGND VGND VPWR VPWR sky130_fd_sc_hd__fill_1
XFILLER_117_205 VPWR VGND VPWR VGND sky130_ef_sc_hd__decap_12
XFILLER_8_340 VGND VGND VPWR VPWR sky130_fd_sc_hd__decap_6
XFILLER_133_709 VPWR VGND VPWR VGND sky130_ef_sc_hd__decap_12
XFILLER_117_249 VPWR VGND VPWR VGND sky130_ef_sc_hd__decap_12
X_2672_ a_r3\[1\] b_r3\[1\] VGND VGND VPWR VPWR _0412_ sky130_fd_sc_hd__nand2_1
XFILLER_68_3 VPWR VGND VPWR VGND sky130_ef_sc_hd__decap_12
XTAP_TAPCELL_ROW_93_1823 VGND VPWR sky130_fd_sc_hd__tapvpwrvgnd_1
XTAP_TAPCELL_ROW_93_1812 VGND VPWR sky130_fd_sc_hd__tapvpwrvgnd_1
X_1623_ B_reg\[7\] VGND VGND VPWR VPWR _0903_ sky130_fd_sc_hd__inv_2
XFILLER_141_753 VPWR VGND VPWR VGND sky130_ef_sc_hd__decap_12
XFILLER_125_293 VPWR VGND VPWR VGND sky130_ef_sc_hd__decap_12
XFILLER_98_133 VGND VGND VPWR VPWR sky130_fd_sc_hd__decap_6
XFILLER_141_797 VPWR VGND VPWR VGND sky130_ef_sc_hd__decap_12
XFILLER_101_617 VPWR VGND VPWR VGND sky130_ef_sc_hd__decap_12
XFILLER_98_177 VGND VGND VPWR VPWR sky130_fd_sc_hd__decap_8
XANTENNA__1624__A B_reg\[6\] VGND VGND VPWR VPWR sky130_fd_sc_hd__diode_2
X_3224_ clknet_3_3__leaf_clk _0011_ net36 VGND VGND VPWR VPWR b_r2\[0\] sky130_fd_sc_hd__dfrtp_2
.ends
